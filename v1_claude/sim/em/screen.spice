** sch_path: /home/noritsuna/GPS/xschem/tb_full.sch
**.subckt tb_full
VDD vdd 0 3.3
VREF refin 0 sin(1.65 0.4 16.368e6)
VRFP sp0 0 sin(0 11.2u 1575.42e6)
VRNP sp sp0 dc 0
RSP sp sps 50
CCP sps rfin 10p
VSCLK sclk 0 pwl(0 0 2.6e-06 0 2.602e-06 3.3 2.65e-06 3.3 2.652e-06 0 2.7e-06 0 2.702e-06 3.3 2.75e-06 3.3 2.752e-06 0 2.8e-06 0  2.802e-06 3.3 2.85e-06 3.3 2.852e-06 0 2.9e-06 0 2.902e-06 3.3 2.95e-06 3.3 2.952e-06 0 3e-06 0 3.002e-06 3.3 3.05e-06 3.3 3.052e-06 0  3.1e-06 0 3.102e-06 3.3 3.15e-06 3.3 3.152e-06 0 3.2e-06 0 3.202e-06 3.3 3.25e-06 3.3 3.252e-06 0 3.3e-06 0 3.302e-06 3.3 3.35e-06 3.3  3.352e-06 0 3.4e-06 0 3.402e-06 3.3 3.45e-06 3.3 3.452e-06 0 3.5e-06 0 3.502e-06 3.3 3.55e-06 3.3 3.552e-06 0 3.6e-06 0 3.602e-06 3.3  3.65e-06 3.3 3.652e-06 0 3.7e-06 0 3.702e-06 3.3 3.75e-06 3.3 3.752e-06 0 3.8e-06 0 3.802e-06 3.3 3.85e-06 3.3 3.852e-06 0 3.9e-06 0  3.902e-06 3.3 3.95e-06 3.3 3.952e-06 0 4e-06 0 4.002e-06 3.3 4.05e-06 3.3 4.052e-06 0 4.1e-06 0 4.102e-06 3.3 4.15e-06 3.3 4.152e-06 0  4.2e-06 0 4.202e-06 3.3 4.25e-06 3.3 4.252e-06 0 4.3e-06 0 4.302e-06 3.3 4.35e-06 3.3 4.352e-06 0 4.4e-06 0 4.402e-06 3.3 4.45e-06 3.3  4.452e-06 0 4.5e-06 0 4.502e-06 3.3 4.55e-06 3.3 4.552e-06 0 4.6e-06 0 4.602e-06 3.3 4.65e-06 3.3 4.652e-06 0 4.7e-06 0 4.702e-06 3.3  4.75e-06 3.3 4.752e-06 0 4.8e-06 0 4.802e-06 3.3 4.85e-06 3.3 4.852e-06 0 4.9e-06 0 4.902e-06 3.3 4.95e-06 3.3 4.952e-06 0)
VSDI sdi 0 pwl(0 0 2.55e-06 0 2.552e-06 0 2.65e-06 0 2.652e-06 0 2.75e-06 0 2.752e-06 0 2.85e-06 0 2.852e-06 0 2.95e-06 0  2.952e-06 0 3.05e-06 0 3.052e-06 0 3.15e-06 0 3.152e-06 0 3.25e-06 0 3.252e-06 0 3.35e-06 0 3.352e-06 0 3.45e-06 0 3.452e-06 0 3.55e-06 0  3.552e-06 0 3.65e-06 0 3.652e-06 0 3.75e-06 0 3.752e-06 0 3.85e-06 0 3.852e-06 0 3.95e-06 0 3.952e-06 0 4.05e-06 0 4.052e-06 0 4.15e-06 0  4.152e-06 0 4.25e-06 0 4.252e-06 0 4.35e-06 0 4.352e-06 0 4.45e-06 0 4.452e-06 3.3 4.55e-06 3.3 4.552e-06 0 4.65e-06 0 4.652e-06 3.3  4.75e-06 3.3 4.752e-06 0 4.85e-06 0 4.852e-06 3.3)
VCSN csn 0 pwl(0 3.3 2.5e-06 3.3 2.502e-06 0 5e-06 0 5.002e-06 3.3)
XDUT rfin refin sclk sdi csn isign imag qsign qmag clkout afcout vctrl vddv vdd 0 gnss_afe_top
VDDV vdd vddv 0
CPisign isign 0 2p
CPimag imag 0 2p
CPqsign qsign 0 2p
CPqmag qmag 0 2p
CPclkout clkout 0 2p
RAFC afcout 0 100k
**** begin user architecture code
 .include /home/noritsuna/pdk/gf180mcuD/libs.tech/ngspice/design.ngspice
.lib /home/noritsuna/pdk/gf180mcuD/libs.tech/ngspice/sm141064.ngspice typical
.lib /home/noritsuna/pdk/gf180mcuD/libs.tech/ngspice/sm141064.ngspice res_typical
.lib /home/noritsuna/pdk/gf180mcuD/libs.tech/ngspice/sm141064.ngspice mimcap_typical

.option method=gear reltol=2e-4 minbreak=1e-12
.ic v(vctrl)=1.7 v(xdut.xpll.xlf.z)=1.7 v(xdut.xpll.vcp)=1.7 v(xdut.xvco.xcore.p4)=0 v(xdut.xvco.xcore.n4)=1
.control
set num_threads=4
save @m.xdut.xspi.xscb.xmn.m0[id] @m.xdut.xspi.xscb.xmp.m0[id] @m.xdut.xspi.xscg.xmn1.m0[id] @m.xdut.xspi.xscg.xmn2.m0[id] @m.xdut.xspi.xscg.xmp1.m0[id] @m.xdut.xspi.xscg.xmp2.m0[id] @m.xdut.xspi.xp1.xmn.m0[id] @m.xdut.xspi.xp1.xmp.m0[id] @m.xdut.xspi.xp2.xmn.m0[id] @m.xdut.xspi.xp2.xmp.m0[id] @m.xdut.xspi.xp3.xmn.m0[id] @m.xdut.xspi.xp3.xmp.m0[id] @m.xdut.xspi.xr0.xci.xmn.m0[id] @m.xdut.xspi.xr0.xci.xmp.m0[id] @m.xdut.xspi.xr0.xt1n.m0[id] @m.xdut.xspi.xr0.xt1p.m0[id] @m.xdut.xspi.xr0.xm.xmn1.m0[id] @m.xdut.xspi.xr0.xm.xmn2.m0[id] @m.xdut.xspi.xr0.xm.xmp1.m0[id] @m.xdut.xspi.xr0.xm.xmp2.m0[id]
save @m.xdut.xspi.xr0.xmf.xmn.m0[id] @m.xdut.xspi.xr0.xmf.xmp.m0[id] @m.xdut.xspi.xr0.xt2n.m0[id] @m.xdut.xspi.xr0.xt2p.m0[id] @m.xdut.xspi.xr0.xt3n.m0[id] @m.xdut.xspi.xr0.xt3p.m0[id] @m.xdut.xspi.xr0.xs.xmn1.m0[id] @m.xdut.xspi.xr0.xs.xmn2.m0[id] @m.xdut.xspi.xr0.xs.xmp1.m0[id] @m.xdut.xspi.xr0.xs.xmp2.m0[id] @m.xdut.xspi.xr0.xsf.xmn.m0[id] @m.xdut.xspi.xr0.xsf.xmp.m0[id] @m.xdut.xspi.xr0.xt4n.m0[id] @m.xdut.xspi.xr0.xt4p.m0[id] @m.xdut.xspi.xr1.xci.xmn.m0[id] @m.xdut.xspi.xr1.xci.xmp.m0[id] @m.xdut.xspi.xr1.xt1n.m0[id] @m.xdut.xspi.xr1.xt1p.m0[id] @m.xdut.xspi.xr1.xm.xmn1.m0[id] @m.xdut.xspi.xr1.xm.xmn2.m0[id]
save @m.xdut.xspi.xr1.xm.xmp1.m0[id] @m.xdut.xspi.xr1.xm.xmp2.m0[id] @m.xdut.xspi.xr1.xmf.xmn.m0[id] @m.xdut.xspi.xr1.xmf.xmp.m0[id] @m.xdut.xspi.xr1.xt2n.m0[id] @m.xdut.xspi.xr1.xt2p.m0[id] @m.xdut.xspi.xr1.xt3n.m0[id] @m.xdut.xspi.xr1.xt3p.m0[id] @m.xdut.xspi.xr1.xs.xmn1.m0[id] @m.xdut.xspi.xr1.xs.xmn2.m0[id] @m.xdut.xspi.xr1.xs.xmp1.m0[id] @m.xdut.xspi.xr1.xs.xmp2.m0[id] @m.xdut.xspi.xr1.xsf.xmn.m0[id] @m.xdut.xspi.xr1.xsf.xmp.m0[id] @m.xdut.xspi.xr1.xt4n.m0[id] @m.xdut.xspi.xr1.xt4p.m0[id] @m.xdut.xspi.xr2.xci.xmn.m0[id] @m.xdut.xspi.xr2.xci.xmp.m0[id] @m.xdut.xspi.xr2.xt1n.m0[id] @m.xdut.xspi.xr2.xt1p.m0[id]
save @m.xdut.xspi.xr2.xm.xmn1.m0[id] @m.xdut.xspi.xr2.xm.xmn2.m0[id] @m.xdut.xspi.xr2.xm.xmp1.m0[id] @m.xdut.xspi.xr2.xm.xmp2.m0[id] @m.xdut.xspi.xr2.xmf.xmn.m0[id] @m.xdut.xspi.xr2.xmf.xmp.m0[id] @m.xdut.xspi.xr2.xt2n.m0[id] @m.xdut.xspi.xr2.xt2p.m0[id] @m.xdut.xspi.xr2.xt3n.m0[id] @m.xdut.xspi.xr2.xt3p.m0[id] @m.xdut.xspi.xr2.xs.xmn1.m0[id] @m.xdut.xspi.xr2.xs.xmn2.m0[id] @m.xdut.xspi.xr2.xs.xmp1.m0[id] @m.xdut.xspi.xr2.xs.xmp2.m0[id] @m.xdut.xspi.xr2.xsf.xmn.m0[id] @m.xdut.xspi.xr2.xsf.xmp.m0[id] @m.xdut.xspi.xr2.xt4n.m0[id] @m.xdut.xspi.xr2.xt4p.m0[id] @m.xdut.xspi.xr3.xci.xmn.m0[id] @m.xdut.xspi.xr3.xci.xmp.m0[id]
save @m.xdut.xspi.xr3.xt1n.m0[id] @m.xdut.xspi.xr3.xt1p.m0[id] @m.xdut.xspi.xr3.xm.xmn1.m0[id] @m.xdut.xspi.xr3.xm.xmn2.m0[id] @m.xdut.xspi.xr3.xm.xmp1.m0[id] @m.xdut.xspi.xr3.xm.xmp2.m0[id] @m.xdut.xspi.xr3.xmf.xmn.m0[id] @m.xdut.xspi.xr3.xmf.xmp.m0[id] @m.xdut.xspi.xr3.xt2n.m0[id] @m.xdut.xspi.xr3.xt2p.m0[id] @m.xdut.xspi.xr3.xt3n.m0[id] @m.xdut.xspi.xr3.xt3p.m0[id] @m.xdut.xspi.xr3.xs.xmn1.m0[id] @m.xdut.xspi.xr3.xs.xmn2.m0[id] @m.xdut.xspi.xr3.xs.xmp1.m0[id] @m.xdut.xspi.xr3.xs.xmp2.m0[id] @m.xdut.xspi.xr3.xsf.xmn.m0[id] @m.xdut.xspi.xr3.xsf.xmp.m0[id] @m.xdut.xspi.xr3.xt4n.m0[id] @m.xdut.xspi.xr3.xt4p.m0[id]
save @m.xdut.xspi.xr4.xci.xmn.m0[id] @m.xdut.xspi.xr4.xci.xmp.m0[id] @m.xdut.xspi.xr4.xt1n.m0[id] @m.xdut.xspi.xr4.xt1p.m0[id] @m.xdut.xspi.xr4.xm.xmn1.m0[id] @m.xdut.xspi.xr4.xm.xmn2.m0[id] @m.xdut.xspi.xr4.xm.xmp1.m0[id] @m.xdut.xspi.xr4.xm.xmp2.m0[id] @m.xdut.xspi.xr4.xmf.xmn.m0[id] @m.xdut.xspi.xr4.xmf.xmp.m0[id] @m.xdut.xspi.xr4.xt2n.m0[id] @m.xdut.xspi.xr4.xt2p.m0[id] @m.xdut.xspi.xr4.xt3n.m0[id] @m.xdut.xspi.xr4.xt3p.m0[id] @m.xdut.xspi.xr4.xs.xmn1.m0[id] @m.xdut.xspi.xr4.xs.xmn2.m0[id] @m.xdut.xspi.xr4.xs.xmp1.m0[id] @m.xdut.xspi.xr4.xs.xmp2.m0[id] @m.xdut.xspi.xr4.xsf.xmn.m0[id] @m.xdut.xspi.xr4.xsf.xmp.m0[id]
save @m.xdut.xspi.xr4.xt4n.m0[id] @m.xdut.xspi.xr4.xt4p.m0[id] @m.xdut.xspi.xr5.xci.xmn.m0[id] @m.xdut.xspi.xr5.xci.xmp.m0[id] @m.xdut.xspi.xr5.xt1n.m0[id] @m.xdut.xspi.xr5.xt1p.m0[id] @m.xdut.xspi.xr5.xm.xmn1.m0[id] @m.xdut.xspi.xr5.xm.xmn2.m0[id] @m.xdut.xspi.xr5.xm.xmp1.m0[id] @m.xdut.xspi.xr5.xm.xmp2.m0[id] @m.xdut.xspi.xr5.xmf.xmn.m0[id] @m.xdut.xspi.xr5.xmf.xmp.m0[id] @m.xdut.xspi.xr5.xt2n.m0[id] @m.xdut.xspi.xr5.xt2p.m0[id] @m.xdut.xspi.xr5.xt3n.m0[id] @m.xdut.xspi.xr5.xt3p.m0[id] @m.xdut.xspi.xr5.xs.xmn1.m0[id] @m.xdut.xspi.xr5.xs.xmn2.m0[id] @m.xdut.xspi.xr5.xs.xmp1.m0[id] @m.xdut.xspi.xr5.xs.xmp2.m0[id]
save @m.xdut.xspi.xr5.xsf.xmn.m0[id] @m.xdut.xspi.xr5.xsf.xmp.m0[id] @m.xdut.xspi.xr5.xt4n.m0[id] @m.xdut.xspi.xr5.xt4p.m0[id] @m.xdut.xspi.xr6.xci.xmn.m0[id] @m.xdut.xspi.xr6.xci.xmp.m0[id] @m.xdut.xspi.xr6.xt1n.m0[id] @m.xdut.xspi.xr6.xt1p.m0[id] @m.xdut.xspi.xr6.xm.xmn1.m0[id] @m.xdut.xspi.xr6.xm.xmn2.m0[id] @m.xdut.xspi.xr6.xm.xmp1.m0[id] @m.xdut.xspi.xr6.xm.xmp2.m0[id] @m.xdut.xspi.xr6.xmf.xmn.m0[id] @m.xdut.xspi.xr6.xmf.xmp.m0[id] @m.xdut.xspi.xr6.xt2n.m0[id] @m.xdut.xspi.xr6.xt2p.m0[id] @m.xdut.xspi.xr6.xt3n.m0[id] @m.xdut.xspi.xr6.xt3p.m0[id] @m.xdut.xspi.xr6.xs.xmn1.m0[id] @m.xdut.xspi.xr6.xs.xmn2.m0[id]
save @m.xdut.xspi.xr6.xs.xmp1.m0[id] @m.xdut.xspi.xr6.xs.xmp2.m0[id] @m.xdut.xspi.xr6.xsf.xmn.m0[id] @m.xdut.xspi.xr6.xsf.xmp.m0[id] @m.xdut.xspi.xr6.xt4n.m0[id] @m.xdut.xspi.xr6.xt4p.m0[id] @m.xdut.xspi.xr7.xci.xmn.m0[id] @m.xdut.xspi.xr7.xci.xmp.m0[id] @m.xdut.xspi.xr7.xt1n.m0[id] @m.xdut.xspi.xr7.xt1p.m0[id] @m.xdut.xspi.xr7.xm.xmn1.m0[id] @m.xdut.xspi.xr7.xm.xmn2.m0[id] @m.xdut.xspi.xr7.xm.xmp1.m0[id] @m.xdut.xspi.xr7.xm.xmp2.m0[id] @m.xdut.xspi.xr7.xmf.xmn.m0[id] @m.xdut.xspi.xr7.xmf.xmp.m0[id] @m.xdut.xspi.xr7.xt2n.m0[id] @m.xdut.xspi.xr7.xt2p.m0[id] @m.xdut.xspi.xr7.xt3n.m0[id] @m.xdut.xspi.xr7.xt3p.m0[id]
save @m.xdut.xspi.xr7.xs.xmn1.m0[id] @m.xdut.xspi.xr7.xs.xmn2.m0[id] @m.xdut.xspi.xr7.xs.xmp1.m0[id] @m.xdut.xspi.xr7.xs.xmp2.m0[id] @m.xdut.xspi.xr7.xsf.xmn.m0[id] @m.xdut.xspi.xr7.xsf.xmp.m0[id] @m.xdut.xspi.xr7.xt4n.m0[id] @m.xdut.xspi.xr7.xt4p.m0[id] @m.xdut.xspi.xr8.xci.xmn.m0[id] @m.xdut.xspi.xr8.xci.xmp.m0[id] @m.xdut.xspi.xr8.xt1n.m0[id] @m.xdut.xspi.xr8.xt1p.m0[id] @m.xdut.xspi.xr8.xm.xmn1.m0[id] @m.xdut.xspi.xr8.xm.xmn2.m0[id] @m.xdut.xspi.xr8.xm.xmp1.m0[id] @m.xdut.xspi.xr8.xm.xmp2.m0[id] @m.xdut.xspi.xr8.xmf.xmn.m0[id] @m.xdut.xspi.xr8.xmf.xmp.m0[id] @m.xdut.xspi.xr8.xt2n.m0[id] @m.xdut.xspi.xr8.xt2p.m0[id]
save @m.xdut.xspi.xr8.xt3n.m0[id] @m.xdut.xspi.xr8.xt3p.m0[id] @m.xdut.xspi.xr8.xs.xmn1.m0[id] @m.xdut.xspi.xr8.xs.xmn2.m0[id] @m.xdut.xspi.xr8.xs.xmp1.m0[id] @m.xdut.xspi.xr8.xs.xmp2.m0[id] @m.xdut.xspi.xr8.xsf.xmn.m0[id] @m.xdut.xspi.xr8.xsf.xmp.m0[id] @m.xdut.xspi.xr8.xt4n.m0[id] @m.xdut.xspi.xr8.xt4p.m0[id] @m.xdut.xspi.xr9.xci.xmn.m0[id] @m.xdut.xspi.xr9.xci.xmp.m0[id] @m.xdut.xspi.xr9.xt1n.m0[id] @m.xdut.xspi.xr9.xt1p.m0[id] @m.xdut.xspi.xr9.xm.xmn1.m0[id] @m.xdut.xspi.xr9.xm.xmn2.m0[id] @m.xdut.xspi.xr9.xm.xmp1.m0[id] @m.xdut.xspi.xr9.xm.xmp2.m0[id] @m.xdut.xspi.xr9.xmf.xmn.m0[id] @m.xdut.xspi.xr9.xmf.xmp.m0[id]
save @m.xdut.xspi.xr9.xt2n.m0[id] @m.xdut.xspi.xr9.xt2p.m0[id] @m.xdut.xspi.xr9.xt3n.m0[id] @m.xdut.xspi.xr9.xt3p.m0[id] @m.xdut.xspi.xr9.xs.xmn1.m0[id] @m.xdut.xspi.xr9.xs.xmn2.m0[id] @m.xdut.xspi.xr9.xs.xmp1.m0[id] @m.xdut.xspi.xr9.xs.xmp2.m0[id] @m.xdut.xspi.xr9.xsf.xmn.m0[id] @m.xdut.xspi.xr9.xsf.xmp.m0[id] @m.xdut.xspi.xr9.xt4n.m0[id] @m.xdut.xspi.xr9.xt4p.m0[id] @m.xdut.xspi.xr10.xci.xmn.m0[id] @m.xdut.xspi.xr10.xci.xmp.m0[id] @m.xdut.xspi.xr10.xt1n.m0[id] @m.xdut.xspi.xr10.xt1p.m0[id] @m.xdut.xspi.xr10.xm.xmn1.m0[id] @m.xdut.xspi.xr10.xm.xmn2.m0[id] @m.xdut.xspi.xr10.xm.xmp1.m0[id] @m.xdut.xspi.xr10.xm.xmp2.m0[id]
save @m.xdut.xspi.xr10.xmf.xmn.m0[id] @m.xdut.xspi.xr10.xmf.xmp.m0[id] @m.xdut.xspi.xr10.xt2n.m0[id] @m.xdut.xspi.xr10.xt2p.m0[id] @m.xdut.xspi.xr10.xt3n.m0[id] @m.xdut.xspi.xr10.xt3p.m0[id] @m.xdut.xspi.xr10.xs.xmn1.m0[id] @m.xdut.xspi.xr10.xs.xmn2.m0[id] @m.xdut.xspi.xr10.xs.xmp1.m0[id] @m.xdut.xspi.xr10.xs.xmp2.m0[id] @m.xdut.xspi.xr10.xsf.xmn.m0[id] @m.xdut.xspi.xr10.xsf.xmp.m0[id] @m.xdut.xspi.xr10.xt4n.m0[id] @m.xdut.xspi.xr10.xt4p.m0[id] @m.xdut.xspi.xr11.xci.xmn.m0[id] @m.xdut.xspi.xr11.xci.xmp.m0[id] @m.xdut.xspi.xr11.xt1n.m0[id] @m.xdut.xspi.xr11.xt1p.m0[id] @m.xdut.xspi.xr11.xm.xmn1.m0[id] @m.xdut.xspi.xr11.xm.xmn2.m0[id]
save @m.xdut.xspi.xr11.xm.xmp1.m0[id] @m.xdut.xspi.xr11.xm.xmp2.m0[id] @m.xdut.xspi.xr11.xmf.xmn.m0[id] @m.xdut.xspi.xr11.xmf.xmp.m0[id] @m.xdut.xspi.xr11.xt2n.m0[id] @m.xdut.xspi.xr11.xt2p.m0[id] @m.xdut.xspi.xr11.xt3n.m0[id] @m.xdut.xspi.xr11.xt3p.m0[id] @m.xdut.xspi.xr11.xs.xmn1.m0[id] @m.xdut.xspi.xr11.xs.xmn2.m0[id] @m.xdut.xspi.xr11.xs.xmp1.m0[id] @m.xdut.xspi.xr11.xs.xmp2.m0[id] @m.xdut.xspi.xr11.xsf.xmn.m0[id] @m.xdut.xspi.xr11.xsf.xmp.m0[id] @m.xdut.xspi.xr11.xt4n.m0[id] @m.xdut.xspi.xr11.xt4p.m0[id] @m.xdut.xspi.xr12.xci.xmn.m0[id] @m.xdut.xspi.xr12.xci.xmp.m0[id] @m.xdut.xspi.xr12.xt1n.m0[id] @m.xdut.xspi.xr12.xt1p.m0[id]
save @m.xdut.xspi.xr12.xm.xmn1.m0[id] @m.xdut.xspi.xr12.xm.xmn2.m0[id] @m.xdut.xspi.xr12.xm.xmp1.m0[id] @m.xdut.xspi.xr12.xm.xmp2.m0[id] @m.xdut.xspi.xr12.xmf.xmn.m0[id] @m.xdut.xspi.xr12.xmf.xmp.m0[id] @m.xdut.xspi.xr12.xt2n.m0[id] @m.xdut.xspi.xr12.xt2p.m0[id] @m.xdut.xspi.xr12.xt3n.m0[id] @m.xdut.xspi.xr12.xt3p.m0[id] @m.xdut.xspi.xr12.xs.xmn1.m0[id] @m.xdut.xspi.xr12.xs.xmn2.m0[id] @m.xdut.xspi.xr12.xs.xmp1.m0[id] @m.xdut.xspi.xr12.xs.xmp2.m0[id] @m.xdut.xspi.xr12.xsf.xmn.m0[id] @m.xdut.xspi.xr12.xsf.xmp.m0[id] @m.xdut.xspi.xr12.xt4n.m0[id] @m.xdut.xspi.xr12.xt4p.m0[id] @m.xdut.xspi.xr13.xci.xmn.m0[id] @m.xdut.xspi.xr13.xci.xmp.m0[id]
save @m.xdut.xspi.xr13.xt1n.m0[id] @m.xdut.xspi.xr13.xt1p.m0[id] @m.xdut.xspi.xr13.xm.xmn1.m0[id] @m.xdut.xspi.xr13.xm.xmn2.m0[id] @m.xdut.xspi.xr13.xm.xmp1.m0[id] @m.xdut.xspi.xr13.xm.xmp2.m0[id] @m.xdut.xspi.xr13.xmf.xmn.m0[id] @m.xdut.xspi.xr13.xmf.xmp.m0[id] @m.xdut.xspi.xr13.xt2n.m0[id] @m.xdut.xspi.xr13.xt2p.m0[id] @m.xdut.xspi.xr13.xt3n.m0[id] @m.xdut.xspi.xr13.xt3p.m0[id] @m.xdut.xspi.xr13.xs.xmn1.m0[id] @m.xdut.xspi.xr13.xs.xmn2.m0[id] @m.xdut.xspi.xr13.xs.xmp1.m0[id] @m.xdut.xspi.xr13.xs.xmp2.m0[id] @m.xdut.xspi.xr13.xsf.xmn.m0[id] @m.xdut.xspi.xr13.xsf.xmp.m0[id] @m.xdut.xspi.xr13.xt4n.m0[id] @m.xdut.xspi.xr13.xt4p.m0[id]
save @m.xdut.xspi.xr14.xci.xmn.m0[id] @m.xdut.xspi.xr14.xci.xmp.m0[id] @m.xdut.xspi.xr14.xt1n.m0[id] @m.xdut.xspi.xr14.xt1p.m0[id] @m.xdut.xspi.xr14.xm.xmn1.m0[id] @m.xdut.xspi.xr14.xm.xmn2.m0[id] @m.xdut.xspi.xr14.xm.xmp1.m0[id] @m.xdut.xspi.xr14.xm.xmp2.m0[id] @m.xdut.xspi.xr14.xmf.xmn.m0[id] @m.xdut.xspi.xr14.xmf.xmp.m0[id] @m.xdut.xspi.xr14.xt2n.m0[id] @m.xdut.xspi.xr14.xt2p.m0[id] @m.xdut.xspi.xr14.xt3n.m0[id] @m.xdut.xspi.xr14.xt3p.m0[id] @m.xdut.xspi.xr14.xs.xmn1.m0[id] @m.xdut.xspi.xr14.xs.xmn2.m0[id] @m.xdut.xspi.xr14.xs.xmp1.m0[id] @m.xdut.xspi.xr14.xs.xmp2.m0[id] @m.xdut.xspi.xr14.xsf.xmn.m0[id] @m.xdut.xspi.xr14.xsf.xmp.m0[id]
save @m.xdut.xspi.xr14.xt4n.m0[id] @m.xdut.xspi.xr14.xt4p.m0[id] @m.xdut.xspi.xr15.xci.xmn.m0[id] @m.xdut.xspi.xr15.xci.xmp.m0[id] @m.xdut.xspi.xr15.xt1n.m0[id] @m.xdut.xspi.xr15.xt1p.m0[id] @m.xdut.xspi.xr15.xm.xmn1.m0[id] @m.xdut.xspi.xr15.xm.xmn2.m0[id] @m.xdut.xspi.xr15.xm.xmp1.m0[id] @m.xdut.xspi.xr15.xm.xmp2.m0[id] @m.xdut.xspi.xr15.xmf.xmn.m0[id] @m.xdut.xspi.xr15.xmf.xmp.m0[id] @m.xdut.xspi.xr15.xt2n.m0[id] @m.xdut.xspi.xr15.xt2p.m0[id] @m.xdut.xspi.xr15.xt3n.m0[id] @m.xdut.xspi.xr15.xt3p.m0[id] @m.xdut.xspi.xr15.xs.xmn1.m0[id] @m.xdut.xspi.xr15.xs.xmn2.m0[id] @m.xdut.xspi.xr15.xs.xmp1.m0[id] @m.xdut.xspi.xr15.xs.xmp2.m0[id]
save @m.xdut.xspi.xr15.xsf.xmn.m0[id] @m.xdut.xspi.xr15.xsf.xmp.m0[id] @m.xdut.xspi.xr15.xt4n.m0[id] @m.xdut.xspi.xr15.xt4p.m0[id] @m.xdut.xspi.xr16.xci.xmn.m0[id] @m.xdut.xspi.xr16.xci.xmp.m0[id] @m.xdut.xspi.xr16.xt1n.m0[id] @m.xdut.xspi.xr16.xt1p.m0[id] @m.xdut.xspi.xr16.xm.xmn1.m0[id] @m.xdut.xspi.xr16.xm.xmn2.m0[id] @m.xdut.xspi.xr16.xm.xmp1.m0[id] @m.xdut.xspi.xr16.xm.xmp2.m0[id] @m.xdut.xspi.xr16.xmf.xmn.m0[id] @m.xdut.xspi.xr16.xmf.xmp.m0[id] @m.xdut.xspi.xr16.xt2n.m0[id] @m.xdut.xspi.xr16.xt2p.m0[id] @m.xdut.xspi.xr16.xt3n.m0[id] @m.xdut.xspi.xr16.xt3p.m0[id] @m.xdut.xspi.xr16.xs.xmn1.m0[id] @m.xdut.xspi.xr16.xs.xmn2.m0[id]
save @m.xdut.xspi.xr16.xs.xmp1.m0[id] @m.xdut.xspi.xr16.xs.xmp2.m0[id] @m.xdut.xspi.xr16.xsf.xmn.m0[id] @m.xdut.xspi.xr16.xsf.xmp.m0[id] @m.xdut.xspi.xr16.xt4n.m0[id] @m.xdut.xspi.xr16.xt4p.m0[id] @m.xdut.xspi.xr17.xci.xmn.m0[id] @m.xdut.xspi.xr17.xci.xmp.m0[id] @m.xdut.xspi.xr17.xt1n.m0[id] @m.xdut.xspi.xr17.xt1p.m0[id] @m.xdut.xspi.xr17.xm.xmn1.m0[id] @m.xdut.xspi.xr17.xm.xmn2.m0[id] @m.xdut.xspi.xr17.xm.xmp1.m0[id] @m.xdut.xspi.xr17.xm.xmp2.m0[id] @m.xdut.xspi.xr17.xmf.xmn.m0[id] @m.xdut.xspi.xr17.xmf.xmp.m0[id] @m.xdut.xspi.xr17.xt2n.m0[id] @m.xdut.xspi.xr17.xt2p.m0[id] @m.xdut.xspi.xr17.xt3n.m0[id] @m.xdut.xspi.xr17.xt3p.m0[id]
save @m.xdut.xspi.xr17.xs.xmn1.m0[id] @m.xdut.xspi.xr17.xs.xmn2.m0[id] @m.xdut.xspi.xr17.xs.xmp1.m0[id] @m.xdut.xspi.xr17.xs.xmp2.m0[id] @m.xdut.xspi.xr17.xsf.xmn.m0[id] @m.xdut.xspi.xr17.xsf.xmp.m0[id] @m.xdut.xspi.xr17.xt4n.m0[id] @m.xdut.xspi.xr17.xt4p.m0[id] @m.xdut.xspi.xr18.xci.xmn.m0[id] @m.xdut.xspi.xr18.xci.xmp.m0[id] @m.xdut.xspi.xr18.xt1n.m0[id] @m.xdut.xspi.xr18.xt1p.m0[id] @m.xdut.xspi.xr18.xm.xmn1.m0[id] @m.xdut.xspi.xr18.xm.xmn2.m0[id] @m.xdut.xspi.xr18.xm.xmp1.m0[id] @m.xdut.xspi.xr18.xm.xmp2.m0[id] @m.xdut.xspi.xr18.xmf.xmn.m0[id] @m.xdut.xspi.xr18.xmf.xmp.m0[id] @m.xdut.xspi.xr18.xt2n.m0[id] @m.xdut.xspi.xr18.xt2p.m0[id]
save @m.xdut.xspi.xr18.xt3n.m0[id] @m.xdut.xspi.xr18.xt3p.m0[id] @m.xdut.xspi.xr18.xs.xmn1.m0[id] @m.xdut.xspi.xr18.xs.xmn2.m0[id] @m.xdut.xspi.xr18.xs.xmp1.m0[id] @m.xdut.xspi.xr18.xs.xmp2.m0[id] @m.xdut.xspi.xr18.xsf.xmn.m0[id] @m.xdut.xspi.xr18.xsf.xmp.m0[id] @m.xdut.xspi.xr18.xt4n.m0[id] @m.xdut.xspi.xr18.xt4p.m0[id] @m.xdut.xspi.xr19.xci.xmn.m0[id] @m.xdut.xspi.xr19.xci.xmp.m0[id] @m.xdut.xspi.xr19.xt1n.m0[id] @m.xdut.xspi.xr19.xt1p.m0[id] @m.xdut.xspi.xr19.xm.xmn1.m0[id] @m.xdut.xspi.xr19.xm.xmn2.m0[id] @m.xdut.xspi.xr19.xm.xmp1.m0[id] @m.xdut.xspi.xr19.xm.xmp2.m0[id] @m.xdut.xspi.xr19.xmf.xmn.m0[id] @m.xdut.xspi.xr19.xmf.xmp.m0[id]
save @m.xdut.xspi.xr19.xt2n.m0[id] @m.xdut.xspi.xr19.xt2p.m0[id] @m.xdut.xspi.xr19.xt3n.m0[id] @m.xdut.xspi.xr19.xt3p.m0[id] @m.xdut.xspi.xr19.xs.xmn1.m0[id] @m.xdut.xspi.xr19.xs.xmn2.m0[id] @m.xdut.xspi.xr19.xs.xmp1.m0[id] @m.xdut.xspi.xr19.xs.xmp2.m0[id] @m.xdut.xspi.xr19.xsf.xmn.m0[id] @m.xdut.xspi.xr19.xsf.xmp.m0[id] @m.xdut.xspi.xr19.xt4n.m0[id] @m.xdut.xspi.xr19.xt4p.m0[id] @m.xdut.xspi.xr20.xci.xmn.m0[id] @m.xdut.xspi.xr20.xci.xmp.m0[id] @m.xdut.xspi.xr20.xt1n.m0[id] @m.xdut.xspi.xr20.xt1p.m0[id] @m.xdut.xspi.xr20.xm.xmn1.m0[id] @m.xdut.xspi.xr20.xm.xmn2.m0[id] @m.xdut.xspi.xr20.xm.xmp1.m0[id] @m.xdut.xspi.xr20.xm.xmp2.m0[id]
save @m.xdut.xspi.xr20.xmf.xmn.m0[id] @m.xdut.xspi.xr20.xmf.xmp.m0[id] @m.xdut.xspi.xr20.xt2n.m0[id] @m.xdut.xspi.xr20.xt2p.m0[id] @m.xdut.xspi.xr20.xt3n.m0[id] @m.xdut.xspi.xr20.xt3p.m0[id] @m.xdut.xspi.xr20.xs.xmn1.m0[id] @m.xdut.xspi.xr20.xs.xmn2.m0[id] @m.xdut.xspi.xr20.xs.xmp1.m0[id] @m.xdut.xspi.xr20.xs.xmp2.m0[id] @m.xdut.xspi.xr20.xsf.xmn.m0[id] @m.xdut.xspi.xr20.xsf.xmp.m0[id] @m.xdut.xspi.xr20.xt4n.m0[id] @m.xdut.xspi.xr20.xt4p.m0[id] @m.xdut.xspi.xr21.xci.xmn.m0[id] @m.xdut.xspi.xr21.xci.xmp.m0[id] @m.xdut.xspi.xr21.xt1n.m0[id] @m.xdut.xspi.xr21.xt1p.m0[id] @m.xdut.xspi.xr21.xm.xmn1.m0[id] @m.xdut.xspi.xr21.xm.xmn2.m0[id]
save @m.xdut.xspi.xr21.xm.xmp1.m0[id] @m.xdut.xspi.xr21.xm.xmp2.m0[id] @m.xdut.xspi.xr21.xmf.xmn.m0[id] @m.xdut.xspi.xr21.xmf.xmp.m0[id] @m.xdut.xspi.xr21.xt2n.m0[id] @m.xdut.xspi.xr21.xt2p.m0[id] @m.xdut.xspi.xr21.xt3n.m0[id] @m.xdut.xspi.xr21.xt3p.m0[id] @m.xdut.xspi.xr21.xs.xmn1.m0[id] @m.xdut.xspi.xr21.xs.xmn2.m0[id] @m.xdut.xspi.xr21.xs.xmp1.m0[id] @m.xdut.xspi.xr21.xs.xmp2.m0[id] @m.xdut.xspi.xr21.xsf.xmn.m0[id] @m.xdut.xspi.xr21.xsf.xmp.m0[id] @m.xdut.xspi.xr21.xt4n.m0[id] @m.xdut.xspi.xr21.xt4p.m0[id] @m.xdut.xspi.xr22.xci.xmn.m0[id] @m.xdut.xspi.xr22.xci.xmp.m0[id] @m.xdut.xspi.xr22.xt1n.m0[id] @m.xdut.xspi.xr22.xt1p.m0[id]
save @m.xdut.xspi.xr22.xm.xmn1.m0[id] @m.xdut.xspi.xr22.xm.xmn2.m0[id] @m.xdut.xspi.xr22.xm.xmp1.m0[id] @m.xdut.xspi.xr22.xm.xmp2.m0[id] @m.xdut.xspi.xr22.xmf.xmn.m0[id] @m.xdut.xspi.xr22.xmf.xmp.m0[id] @m.xdut.xspi.xr22.xt2n.m0[id] @m.xdut.xspi.xr22.xt2p.m0[id] @m.xdut.xspi.xr22.xt3n.m0[id] @m.xdut.xspi.xr22.xt3p.m0[id] @m.xdut.xspi.xr22.xs.xmn1.m0[id] @m.xdut.xspi.xr22.xs.xmn2.m0[id] @m.xdut.xspi.xr22.xs.xmp1.m0[id] @m.xdut.xspi.xr22.xs.xmp2.m0[id] @m.xdut.xspi.xr22.xsf.xmn.m0[id] @m.xdut.xspi.xr22.xsf.xmp.m0[id] @m.xdut.xspi.xr22.xt4n.m0[id] @m.xdut.xspi.xr22.xt4p.m0[id] @m.xdut.xspi.xr23.xci.xmn.m0[id] @m.xdut.xspi.xr23.xci.xmp.m0[id]
save @m.xdut.xspi.xr23.xt1n.m0[id] @m.xdut.xspi.xr23.xt1p.m0[id] @m.xdut.xspi.xr23.xm.xmn1.m0[id] @m.xdut.xspi.xr23.xm.xmn2.m0[id] @m.xdut.xspi.xr23.xm.xmp1.m0[id] @m.xdut.xspi.xr23.xm.xmp2.m0[id] @m.xdut.xspi.xr23.xmf.xmn.m0[id] @m.xdut.xspi.xr23.xmf.xmp.m0[id] @m.xdut.xspi.xr23.xt2n.m0[id] @m.xdut.xspi.xr23.xt2p.m0[id] @m.xdut.xspi.xr23.xt3n.m0[id] @m.xdut.xspi.xr23.xt3p.m0[id] @m.xdut.xspi.xr23.xs.xmn1.m0[id] @m.xdut.xspi.xr23.xs.xmn2.m0[id] @m.xdut.xspi.xr23.xs.xmp1.m0[id] @m.xdut.xspi.xr23.xs.xmp2.m0[id] @m.xdut.xspi.xr23.xsf.xmn.m0[id] @m.xdut.xspi.xr23.xsf.xmp.m0[id] @m.xdut.xspi.xr23.xt4n.m0[id] @m.xdut.xspi.xr23.xt4p.m0[id]
save @m.xdut.xspi.xl0.xei.xmn.m0[id] @m.xdut.xspi.xl0.xei.xmp.m0[id] @m.xdut.xspi.xl0.xtin.m0[id] @m.xdut.xspi.xl0.xtip.m0[id] @m.xdut.xspi.xl0.x1.xmn.m0[id] @m.xdut.xspi.xl0.x1.xmp.m0[id] @m.xdut.xspi.xl0.x2.xmn.m0[id] @m.xdut.xspi.xl0.x2.xmp.m0[id] @m.xdut.xspi.xl0.xtfn.m0[id] @m.xdut.xspi.xl0.xtfp.m0[id] @m.xdut.xspi.xl1.xei.xmn.m0[id] @m.xdut.xspi.xl1.xei.xmp.m0[id] @m.xdut.xspi.xl1.xtin.m0[id] @m.xdut.xspi.xl1.xtip.m0[id] @m.xdut.xspi.xl1.x1.xmn.m0[id] @m.xdut.xspi.xl1.x1.xmp.m0[id] @m.xdut.xspi.xl1.x2.xmn.m0[id] @m.xdut.xspi.xl1.x2.xmp.m0[id] @m.xdut.xspi.xl1.xtfn.m0[id] @m.xdut.xspi.xl1.xtfp.m0[id]
save @m.xdut.xspi.xl2.xei.xmn.m0[id] @m.xdut.xspi.xl2.xei.xmp.m0[id] @m.xdut.xspi.xl2.xtin.m0[id] @m.xdut.xspi.xl2.xtip.m0[id] @m.xdut.xspi.xl2.x1.xmn.m0[id] @m.xdut.xspi.xl2.x1.xmp.m0[id] @m.xdut.xspi.xl2.x2.xmn.m0[id] @m.xdut.xspi.xl2.x2.xmp.m0[id] @m.xdut.xspi.xl2.xtfn.m0[id] @m.xdut.xspi.xl2.xtfp.m0[id] @m.xdut.xspi.xl3.xei.xmn.m0[id] @m.xdut.xspi.xl3.xei.xmp.m0[id] @m.xdut.xspi.xl3.xtin.m0[id] @m.xdut.xspi.xl3.xtip.m0[id] @m.xdut.xspi.xl3.x1.xmn.m0[id] @m.xdut.xspi.xl3.x1.xmp.m0[id] @m.xdut.xspi.xl3.x2.xmn.m0[id] @m.xdut.xspi.xl3.x2.xmp.m0[id] @m.xdut.xspi.xl3.xtfn.m0[id] @m.xdut.xspi.xl3.xtfp.m0[id]
save @m.xdut.xspi.xl4.xei.xmn.m0[id] @m.xdut.xspi.xl4.xei.xmp.m0[id] @m.xdut.xspi.xl4.xtin.m0[id] @m.xdut.xspi.xl4.xtip.m0[id] @m.xdut.xspi.xl4.x1.xmn.m0[id] @m.xdut.xspi.xl4.x1.xmp.m0[id] @m.xdut.xspi.xl4.x2.xmn.m0[id] @m.xdut.xspi.xl4.x2.xmp.m0[id] @m.xdut.xspi.xl4.xtfn.m0[id] @m.xdut.xspi.xl4.xtfp.m0[id] @m.xdut.xspi.xl5.xei.xmn.m0[id] @m.xdut.xspi.xl5.xei.xmp.m0[id] @m.xdut.xspi.xl5.xtin.m0[id] @m.xdut.xspi.xl5.xtip.m0[id] @m.xdut.xspi.xl5.x1.xmn.m0[id] @m.xdut.xspi.xl5.x1.xmp.m0[id] @m.xdut.xspi.xl5.x2.xmn.m0[id] @m.xdut.xspi.xl5.x2.xmp.m0[id] @m.xdut.xspi.xl5.xtfn.m0[id] @m.xdut.xspi.xl5.xtfp.m0[id]
save @m.xdut.xspi.xl6.xei.xmn.m0[id] @m.xdut.xspi.xl6.xei.xmp.m0[id] @m.xdut.xspi.xl6.xtin.m0[id] @m.xdut.xspi.xl6.xtip.m0[id] @m.xdut.xspi.xl6.x1.xmn.m0[id] @m.xdut.xspi.xl6.x1.xmp.m0[id] @m.xdut.xspi.xl6.x2.xmn.m0[id] @m.xdut.xspi.xl6.x2.xmp.m0[id] @m.xdut.xspi.xl6.xtfn.m0[id] @m.xdut.xspi.xl6.xtfp.m0[id] @m.xdut.xspi.xl7.xei.xmn.m0[id] @m.xdut.xspi.xl7.xei.xmp.m0[id] @m.xdut.xspi.xl7.xtin.m0[id] @m.xdut.xspi.xl7.xtip.m0[id] @m.xdut.xspi.xl7.x1.xmn.m0[id] @m.xdut.xspi.xl7.x1.xmp.m0[id] @m.xdut.xspi.xl7.x2.xmn.m0[id] @m.xdut.xspi.xl7.x2.xmp.m0[id] @m.xdut.xspi.xl7.xtfn.m0[id] @m.xdut.xspi.xl7.xtfp.m0[id]
save @m.xdut.xspi.xl8.xei.xmn.m0[id] @m.xdut.xspi.xl8.xei.xmp.m0[id] @m.xdut.xspi.xl8.xtin.m0[id] @m.xdut.xspi.xl8.xtip.m0[id] @m.xdut.xspi.xl8.x1.xmn.m0[id] @m.xdut.xspi.xl8.x1.xmp.m0[id] @m.xdut.xspi.xl8.x2.xmn.m0[id] @m.xdut.xspi.xl8.x2.xmp.m0[id] @m.xdut.xspi.xl8.xtfn.m0[id] @m.xdut.xspi.xl8.xtfp.m0[id] @m.xdut.xspi.xl9.xei.xmn.m0[id] @m.xdut.xspi.xl9.xei.xmp.m0[id] @m.xdut.xspi.xl9.xtin.m0[id] @m.xdut.xspi.xl9.xtip.m0[id] @m.xdut.xspi.xl9.x1.xmn.m0[id] @m.xdut.xspi.xl9.x1.xmp.m0[id] @m.xdut.xspi.xl9.x2.xmn.m0[id] @m.xdut.xspi.xl9.x2.xmp.m0[id] @m.xdut.xspi.xl9.xtfn.m0[id] @m.xdut.xspi.xl9.xtfp.m0[id]
save @m.xdut.xspi.xl10.xei.xmn.m0[id] @m.xdut.xspi.xl10.xei.xmp.m0[id] @m.xdut.xspi.xl10.xtin.m0[id] @m.xdut.xspi.xl10.xtip.m0[id] @m.xdut.xspi.xl10.x1.xmn.m0[id] @m.xdut.xspi.xl10.x1.xmp.m0[id] @m.xdut.xspi.xl10.x2.xmn.m0[id] @m.xdut.xspi.xl10.x2.xmp.m0[id] @m.xdut.xspi.xl10.xtfn.m0[id] @m.xdut.xspi.xl10.xtfp.m0[id] @m.xdut.xspi.xl11.xei.xmn.m0[id] @m.xdut.xspi.xl11.xei.xmp.m0[id] @m.xdut.xspi.xl11.xtin.m0[id] @m.xdut.xspi.xl11.xtip.m0[id] @m.xdut.xspi.xl11.x1.xmn.m0[id] @m.xdut.xspi.xl11.x1.xmp.m0[id] @m.xdut.xspi.xl11.x2.xmn.m0[id] @m.xdut.xspi.xl11.x2.xmp.m0[id] @m.xdut.xspi.xl11.xtfn.m0[id] @m.xdut.xspi.xl11.xtfp.m0[id]
save @m.xdut.xspi.xl12.xei.xmn.m0[id] @m.xdut.xspi.xl12.xei.xmp.m0[id] @m.xdut.xspi.xl12.xtin.m0[id] @m.xdut.xspi.xl12.xtip.m0[id] @m.xdut.xspi.xl12.x1.xmn.m0[id] @m.xdut.xspi.xl12.x1.xmp.m0[id] @m.xdut.xspi.xl12.x2.xmn.m0[id] @m.xdut.xspi.xl12.x2.xmp.m0[id] @m.xdut.xspi.xl12.xtfn.m0[id] @m.xdut.xspi.xl12.xtfp.m0[id] @m.xdut.xspi.xl13.xei.xmn.m0[id] @m.xdut.xspi.xl13.xei.xmp.m0[id] @m.xdut.xspi.xl13.xtin.m0[id] @m.xdut.xspi.xl13.xtip.m0[id] @m.xdut.xspi.xl13.x1.xmn.m0[id] @m.xdut.xspi.xl13.x1.xmp.m0[id] @m.xdut.xspi.xl13.x2.xmn.m0[id] @m.xdut.xspi.xl13.x2.xmp.m0[id] @m.xdut.xspi.xl13.xtfn.m0[id] @m.xdut.xspi.xl13.xtfp.m0[id]
save @m.xdut.xspi.xl14.xei.xmn.m0[id] @m.xdut.xspi.xl14.xei.xmp.m0[id] @m.xdut.xspi.xl14.xtin.m0[id] @m.xdut.xspi.xl14.xtip.m0[id] @m.xdut.xspi.xl14.x1.xmn.m0[id] @m.xdut.xspi.xl14.x1.xmp.m0[id] @m.xdut.xspi.xl14.x2.xmn.m0[id] @m.xdut.xspi.xl14.x2.xmp.m0[id] @m.xdut.xspi.xl14.xtfn.m0[id] @m.xdut.xspi.xl14.xtfp.m0[id] @m.xdut.xspi.xl15.xei.xmn.m0[id] @m.xdut.xspi.xl15.xei.xmp.m0[id] @m.xdut.xspi.xl15.xtin.m0[id] @m.xdut.xspi.xl15.xtip.m0[id] @m.xdut.xspi.xl15.x1.xmn.m0[id] @m.xdut.xspi.xl15.x1.xmp.m0[id] @m.xdut.xspi.xl15.x2.xmn.m0[id] @m.xdut.xspi.xl15.x2.xmp.m0[id] @m.xdut.xspi.xl15.xtfn.m0[id] @m.xdut.xspi.xl15.xtfp.m0[id]
save @m.xdut.xspi.xafc7.xmn.m0[id] @m.xdut.xspi.xafc7.xmp.m0[id] @m.xdut.xspi.xl16.xei.xmn.m0[id] @m.xdut.xspi.xl16.xei.xmp.m0[id] @m.xdut.xspi.xl16.xtin.m0[id] @m.xdut.xspi.xl16.xtip.m0[id] @m.xdut.xspi.xl16.x1.xmn.m0[id] @m.xdut.xspi.xl16.x1.xmp.m0[id] @m.xdut.xspi.xl16.x2.xmn.m0[id] @m.xdut.xspi.xl16.x2.xmp.m0[id] @m.xdut.xspi.xl16.xtfn.m0[id] @m.xdut.xspi.xl16.xtfp.m0[id] @m.xdut.xbias.xmn1.m0[id] @m.xdut.xbias.xmn2.m0[id] @m.xdut.xbias.xmp1.m0[id] @m.xdut.xbias.xmp2.m0[id] @m.xdut.xbias.xmsp.m0[id] @m.xdut.xbias.xmsn.m0[id] @m.xdut.xbias.xmsu.m0[id] @m.xdut.xbias.xmp3.m0[id]
save @m.xdut.xbias.xmn3.m0[id] @m.xdut.xbias.xmn4.m0[id] @m.xdut.xbias.xmp4.m0[id] @m.xdut.xvco.xmvi.m0[id] @m.xdut.xvco.xmpd.m0[id] @m.xdut.xvco.xmpo.m0[id] @m.xdut.xvco.xmmin.m0[id] @m.xdut.xvco.xb0.xmn.m0[id] @m.xdut.xvco.xb0.xmp.m0[id] @m.xdut.xvco.xb1.xmn.m0[id] @m.xdut.xvco.xb1.xmp.m0[id] @m.xdut.xvco.xmpb0.m0[id] @m.xdut.xvco.xmsb0.m0[id] @m.xdut.xvco.xmpb1.m0[id] @m.xdut.xvco.xmsb1.m0[id] @m.xdut.xvco.xcore.xmna1.m0[id] @m.xdut.xvco.xcore.xmnb1.m0[id] @m.xdut.xvco.xcore.xmpa1.m0[id] @m.xdut.xvco.xcore.xmpb1.m0[id] @m.xdut.xvco.xcore.xmnc1.m0[id]
save @m.xdut.xvco.xcore.xmnd1.m0[id] @m.xdut.xvco.xcore.xmpc1.m0[id] @m.xdut.xvco.xcore.xmpd1.m0[id] @m.xdut.xvco.xcore.xmna2.m0[id] @m.xdut.xvco.xcore.xmnb2.m0[id] @m.xdut.xvco.xcore.xmpa2.m0[id] @m.xdut.xvco.xcore.xmpb2.m0[id] @m.xdut.xvco.xcore.xmnc2.m0[id] @m.xdut.xvco.xcore.xmnd2.m0[id] @m.xdut.xvco.xcore.xmpc2.m0[id] @m.xdut.xvco.xcore.xmpd2.m0[id] @m.xdut.xvco.xcore.xmna3.m0[id] @m.xdut.xvco.xcore.xmnb3.m0[id] @m.xdut.xvco.xcore.xmpa3.m0[id] @m.xdut.xvco.xcore.xmpb3.m0[id] @m.xdut.xvco.xcore.xmnc3.m0[id] @m.xdut.xvco.xcore.xmnd3.m0[id] @m.xdut.xvco.xcore.xmpc3.m0[id] @m.xdut.xvco.xcore.xmpd3.m0[id] @m.xdut.xvco.xcore.xmna4.m0[id]
save @m.xdut.xvco.xcore.xmnb4.m0[id] @m.xdut.xvco.xcore.xmpa4.m0[id] @m.xdut.xvco.xcore.xmpb4.m0[id] @m.xdut.xvco.xcore.xmnc4.m0[id] @m.xdut.xvco.xcore.xmnd4.m0[id] @m.xdut.xvco.xcore.xmpc4.m0[id] @m.xdut.xvco.xcore.xmpd4.m0[id] @m.xdut.xvco.xcore.xmbnp1.m0[id] @m.xdut.xvco.xcore.xmbpp1.m0[id] @m.xdut.xvco.xcore.xmdnp1.m0[id] @m.xdut.xvco.xcore.xmdpp1.m0[id] @m.xdut.xvco.xcore.xmcnp1.m0[id] @m.xdut.xvco.xcore.xmcpp1.m0[id] @m.xdut.xvco.xcore.xmbnn1.m0[id] @m.xdut.xvco.xcore.xmbpn1.m0[id] @m.xdut.xvco.xcore.xmdnn1.m0[id] @m.xdut.xvco.xcore.xmdpn1.m0[id] @m.xdut.xvco.xcore.xmcnn1.m0[id] @m.xdut.xvco.xcore.xmcpn1.m0[id] @m.xdut.xvco.xcore.xmbnp2.m0[id]
save @m.xdut.xvco.xcore.xmbpp2.m0[id] @m.xdut.xvco.xcore.xmdnp2.m0[id] @m.xdut.xvco.xcore.xmdpp2.m0[id] @m.xdut.xvco.xcore.xmcnp2.m0[id] @m.xdut.xvco.xcore.xmcpp2.m0[id] @m.xdut.xvco.xcore.xmbnn2.m0[id] @m.xdut.xvco.xcore.xmbpn2.m0[id] @m.xdut.xvco.xcore.xmdnn2.m0[id] @m.xdut.xvco.xcore.xmdpn2.m0[id] @m.xdut.xvco.xcore.xmcnn2.m0[id] @m.xdut.xvco.xcore.xmcpn2.m0[id] @m.xdut.xvco.xcore.xmbnp3.m0[id] @m.xdut.xvco.xcore.xmbpp3.m0[id] @m.xdut.xvco.xcore.xmdnp3.m0[id] @m.xdut.xvco.xcore.xmdpp3.m0[id] @m.xdut.xvco.xcore.xmcnp3.m0[id] @m.xdut.xvco.xcore.xmcpp3.m0[id] @m.xdut.xvco.xcore.xmbnn3.m0[id] @m.xdut.xvco.xcore.xmbpn3.m0[id] @m.xdut.xvco.xcore.xmdnn3.m0[id]
save @m.xdut.xvco.xcore.xmdpn3.m0[id] @m.xdut.xvco.xcore.xmcnn3.m0[id] @m.xdut.xvco.xcore.xmcpn3.m0[id] @m.xdut.xvco.xcore.xmbnp4.m0[id] @m.xdut.xvco.xcore.xmbpp4.m0[id] @m.xdut.xvco.xcore.xmdnp4.m0[id] @m.xdut.xvco.xcore.xmdpp4.m0[id] @m.xdut.xvco.xcore.xmcnp4.m0[id] @m.xdut.xvco.xcore.xmcpp4.m0[id] @m.xdut.xvco.xcore.xmbnn4.m0[id] @m.xdut.xvco.xcore.xmbpn4.m0[id] @m.xdut.xvco.xcore.xmdnn4.m0[id] @m.xdut.xvco.xcore.xmdpn4.m0[id] @m.xdut.xvco.xcore.xmcnn4.m0[id] @m.xdut.xvco.xcore.xmcpn4.m0[id] @m.xdut.xvco.xcore.xmk1.m0[id] @m.xdut.xvco.xcore.xmkd1.m0[id] @m.xdut.xvco.xcore.xmk2.m0[id] @m.xdut.xvco.xcore.xmkd2.m0[id] @m.xdut.xvco.xcore.xmk3.m0[id]
save @m.xdut.xvco.xcore.xmkd3.m0[id] @m.xdut.xvco.xcore.xmk4.m0[id] @m.xdut.xvco.xcore.xmkd4.m0[id] @m.xdut.xvco.xsua.xmn1.m0[id] @m.xdut.xvco.xsua.xmn2.m0[id] @m.xdut.xvco.xsua.xmp1.m0[id] @m.xdut.xvco.xsua.xmp2.m0[id] @m.xdut.xvco.xsub.xmn1.m0[id] @m.xdut.xvco.xsub.xmn2.m0[id] @m.xdut.xvco.xsub.xmp1.m0[id] @m.xdut.xvco.xsub.xmp2.m0[id] @m.xdut.xvco.xsuad1.xmn1.m0[id] @m.xdut.xvco.xsuad1.xmn2.m0[id] @m.xdut.xvco.xsuad1.xmp1.m0[id] @m.xdut.xvco.xsuad1.xmp2.m0[id] @m.xdut.xvco.xsubd1.xmn1.m0[id] @m.xdut.xvco.xsubd1.xmn2.m0[id] @m.xdut.xvco.xsubd1.xmp1.m0[id] @m.xdut.xvco.xsubd1.xmp2.m0[id] @m.xdut.xvco.xsuad3.xmn1.m0[id]
save @m.xdut.xvco.xsuad3.xmn2.m0[id] @m.xdut.xvco.xsuad3.xmp1.m0[id] @m.xdut.xvco.xsuad3.xmp2.m0[id] @m.xdut.xvco.xsubd3.xmn1.m0[id] @m.xdut.xvco.xsubd3.xmn2.m0[id] @m.xdut.xvco.xsubd3.xmp1.m0[id] @m.xdut.xvco.xsubd3.xmp2.m0[id] @m.xdut.xvco.xsuad4.xmn1.m0[id] @m.xdut.xvco.xsuad4.xmn2.m0[id] @m.xdut.xvco.xsuad4.xmp1.m0[id] @m.xdut.xvco.xsuad4.xmp2.m0[id] @m.xdut.xvco.xsubd4.xmn1.m0[id] @m.xdut.xvco.xsubd4.xmn2.m0[id] @m.xdut.xvco.xsubd4.xmp1.m0[id] @m.xdut.xvco.xsubd4.xmp2.m0[id] @m.xdut.xvco.xsua1.xmn1.m0[id] @m.xdut.xvco.xsua1.xmn2.m0[id] @m.xdut.xvco.xsua1.xmp1.m0[id] @m.xdut.xvco.xsua1.xmp2.m0[id] @m.xdut.xvco.xsua2.xmn.m0[id]
save @m.xdut.xvco.xsua2.xmp.m0[id] @m.xdut.xvco.xsub1.xmn1.m0[id] @m.xdut.xvco.xsub1.xmn2.m0[id] @m.xdut.xvco.xsub1.xmp1.m0[id] @m.xdut.xvco.xsub1.xmp2.m0[id] @m.xdut.xvco.xsub2.xmn.m0[id] @m.xdut.xvco.xsub2.xmp.m0[id] @m.xdut.xrb.xmn1.m0[id] @m.xdut.xrb.xmp1.m0[id] @m.xdut.xrb.xmn2.m0[id] @m.xdut.xrb.xmp2.m0[id] @m.xdut.xpll.xdb.xmn1.m0[id] @m.xdut.xpll.xdb.xmp1.m0[id] @m.xdut.xpll.xdb.xmn2.m0[id] @m.xdut.xpll.xdb.xmp2.m0[id] @m.xdut.xpll.xdiv.xd1.xf.xmp1.m0[id] @m.xdut.xpll.xdiv.xd1.xf.xmp2.m0[id] @m.xdut.xpll.xdiv.xd1.xf.xmn1.m0[id] @m.xdut.xpll.xdiv.xd1.xf.xmp3.m0[id] @m.xdut.xpll.xdiv.xd1.xf.xmn2.m0[id]
save @m.xdut.xpll.xdiv.xd1.xf.xmn3.m0[id] @m.xdut.xpll.xdiv.xd1.xf.xmp4.m0[id] @m.xdut.xpll.xdiv.xd1.xf.xmn4.m0[id] @m.xdut.xpll.xdiv.xd1.xf.xmn5.m0[id] @m.xdut.xpll.xdiv.xd1.xf.xmp5.m0[id] @m.xdut.xpll.xdiv.xd1.xf.xmn6.m0[id] @m.xdut.xpll.xdiv.xd2.xf.xmp1.m0[id] @m.xdut.xpll.xdiv.xd2.xf.xmp2.m0[id] @m.xdut.xpll.xdiv.xd2.xf.xmn1.m0[id] @m.xdut.xpll.xdiv.xd2.xf.xmp3.m0[id] @m.xdut.xpll.xdiv.xd2.xf.xmn2.m0[id] @m.xdut.xpll.xdiv.xd2.xf.xmn3.m0[id] @m.xdut.xpll.xdiv.xd2.xf.xmp4.m0[id] @m.xdut.xpll.xdiv.xd2.xf.xmn4.m0[id] @m.xdut.xpll.xdiv.xd2.xf.xmn5.m0[id] @m.xdut.xpll.xdiv.xd2.xf.xmp5.m0[id] @m.xdut.xpll.xdiv.xd2.xf.xmn6.m0[id] @m.xdut.xpll.xdiv.xd3.xf.xmp1.m0[id] @m.xdut.xpll.xdiv.xd3.xf.xmp2.m0[id] @m.xdut.xpll.xdiv.xd3.xf.xmn1.m0[id]
save @m.xdut.xpll.xdiv.xd3.xf.xmp3.m0[id] @m.xdut.xpll.xdiv.xd3.xf.xmn2.m0[id] @m.xdut.xpll.xdiv.xd3.xf.xmn3.m0[id] @m.xdut.xpll.xdiv.xd3.xf.xmp4.m0[id] @m.xdut.xpll.xdiv.xd3.xf.xmn4.m0[id] @m.xdut.xpll.xdiv.xd3.xf.xmn5.m0[id] @m.xdut.xpll.xdiv.xd3.xf.xmp5.m0[id] @m.xdut.xpll.xdiv.xd3.xf.xmn6.m0[id] @m.xdut.xpll.xdiv.xd5.xf1.xmp1.m0[id] @m.xdut.xpll.xdiv.xd5.xf1.xmp2.m0[id] @m.xdut.xpll.xdiv.xd5.xf1.xmn1.m0[id] @m.xdut.xpll.xdiv.xd5.xf1.xmp3.m0[id] @m.xdut.xpll.xdiv.xd5.xf1.xmn2.m0[id] @m.xdut.xpll.xdiv.xd5.xf1.xmn3.m0[id] @m.xdut.xpll.xdiv.xd5.xf1.xmp4.m0[id] @m.xdut.xpll.xdiv.xd5.xf1.xmn4.m0[id] @m.xdut.xpll.xdiv.xd5.xf1.xmn5.m0[id] @m.xdut.xpll.xdiv.xd5.xf1.xmp5.m0[id] @m.xdut.xpll.xdiv.xd5.xf1.xmn6.m0[id] @m.xdut.xpll.xdiv.xd5.xf2.xmp1.m0[id]
save @m.xdut.xpll.xdiv.xd5.xf2.xmp2.m0[id] @m.xdut.xpll.xdiv.xd5.xf2.xmn1.m0[id] @m.xdut.xpll.xdiv.xd5.xf2.xmp3.m0[id] @m.xdut.xpll.xdiv.xd5.xf2.xmn2.m0[id] @m.xdut.xpll.xdiv.xd5.xf2.xmn3.m0[id] @m.xdut.xpll.xdiv.xd5.xf2.xmp4.m0[id] @m.xdut.xpll.xdiv.xd5.xf2.xmn4.m0[id] @m.xdut.xpll.xdiv.xd5.xf2.xmn5.m0[id] @m.xdut.xpll.xdiv.xd5.xf2.xmp5.m0[id] @m.xdut.xpll.xdiv.xd5.xf2.xmn6.m0[id] @m.xdut.xpll.xdiv.xd5.xn.xmn1.m0[id] @m.xdut.xpll.xdiv.xd5.xn.xmn2.m0[id] @m.xdut.xpll.xdiv.xd5.xn.xmp1.m0[id] @m.xdut.xpll.xdiv.xd5.xn.xmp2.m0[id] @m.xdut.xpll.xdiv.xd6.xf.xmp1.m0[id] @m.xdut.xpll.xdiv.xd6.xf.xmp2.m0[id] @m.xdut.xpll.xdiv.xd6.xf.xmn1.m0[id] @m.xdut.xpll.xdiv.xd6.xf.xmp3.m0[id] @m.xdut.xpll.xdiv.xd6.xf.xmn2.m0[id] @m.xdut.xpll.xdiv.xd6.xf.xmn3.m0[id]
save @m.xdut.xpll.xdiv.xd6.xf.xmp4.m0[id] @m.xdut.xpll.xdiv.xd6.xf.xmn4.m0[id] @m.xdut.xpll.xdiv.xd6.xf.xmn5.m0[id] @m.xdut.xpll.xdiv.xd6.xf.xmp5.m0[id] @m.xdut.xpll.xdiv.xd6.xf.xmn6.m0[id] @m.xdut.xpll.xdiv.xfb1.xmn.m0[id] @m.xdut.xpll.xdiv.xfb1.xmp.m0[id] @m.xdut.xpll.xdiv.xfb2.xmn.m0[id] @m.xdut.xpll.xdiv.xfb2.xmp.m0[id] @m.xdut.xpll.xmcln.m0[id] @m.xdut.xpll.xmclp.m0[id] @m.xdut.xpll.xmtx.m0[id] @m.xdut.xpll.xmthi.m0[id] @m.xdut.xpll.xmtlo.m0[id] @m.xdut.xpll.xpfd.xu.x1.xmn1.m0[id] @m.xdut.xpll.xpfd.xu.x1.xmn2.m0[id] @m.xdut.xpll.xpfd.xu.x1.xmp1.m0[id] @m.xdut.xpll.xpfd.xu.x1.xmp2.m0[id] @m.xdut.xpll.xpfd.xu.x2.xmn1.m0[id] @m.xdut.xpll.xpfd.xu.x2.xmn2.m0[id]
save @m.xdut.xpll.xpfd.xu.x2.xmn3.m0[id] @m.xdut.xpll.xpfd.xu.x2.xmp1.m0[id] @m.xdut.xpll.xpfd.xu.x2.xmp2.m0[id] @m.xdut.xpll.xpfd.xu.x2.xmp3.m0[id] @m.xdut.xpll.xpfd.xu.x3.xmn1.m0[id] @m.xdut.xpll.xpfd.xu.x3.xmn2.m0[id] @m.xdut.xpll.xpfd.xu.x3.xmn3.m0[id] @m.xdut.xpll.xpfd.xu.x3.xmp1.m0[id] @m.xdut.xpll.xpfd.xu.x3.xmp2.m0[id] @m.xdut.xpll.xpfd.xu.x3.xmp3.m0[id] @m.xdut.xpll.xpfd.xu.x4.xmn1.m0[id] @m.xdut.xpll.xpfd.xu.x4.xmn2.m0[id] @m.xdut.xpll.xpfd.xu.x4.xmp1.m0[id] @m.xdut.xpll.xpfd.xu.x4.xmp2.m0[id] @m.xdut.xpll.xpfd.xu.x5.xmn1.m0[id] @m.xdut.xpll.xpfd.xu.x5.xmn2.m0[id] @m.xdut.xpll.xpfd.xu.x5.xmp1.m0[id] @m.xdut.xpll.xpfd.xu.x5.xmp2.m0[id] @m.xdut.xpll.xpfd.xu.x6.xmn1.m0[id] @m.xdut.xpll.xpfd.xu.x6.xmn2.m0[id]
save @m.xdut.xpll.xpfd.xu.x6.xmn3.m0[id] @m.xdut.xpll.xpfd.xu.x6.xmp1.m0[id] @m.xdut.xpll.xpfd.xu.x6.xmp2.m0[id] @m.xdut.xpll.xpfd.xu.x6.xmp3.m0[id] @m.xdut.xpll.xpfd.xd.x1.xmn1.m0[id] @m.xdut.xpll.xpfd.xd.x1.xmn2.m0[id] @m.xdut.xpll.xpfd.xd.x1.xmp1.m0[id] @m.xdut.xpll.xpfd.xd.x1.xmp2.m0[id] @m.xdut.xpll.xpfd.xd.x2.xmn1.m0[id] @m.xdut.xpll.xpfd.xd.x2.xmn2.m0[id] @m.xdut.xpll.xpfd.xd.x2.xmn3.m0[id] @m.xdut.xpll.xpfd.xd.x2.xmp1.m0[id] @m.xdut.xpll.xpfd.xd.x2.xmp2.m0[id] @m.xdut.xpll.xpfd.xd.x2.xmp3.m0[id] @m.xdut.xpll.xpfd.xd.x3.xmn1.m0[id] @m.xdut.xpll.xpfd.xd.x3.xmn2.m0[id] @m.xdut.xpll.xpfd.xd.x3.xmn3.m0[id] @m.xdut.xpll.xpfd.xd.x3.xmp1.m0[id] @m.xdut.xpll.xpfd.xd.x3.xmp2.m0[id] @m.xdut.xpll.xpfd.xd.x3.xmp3.m0[id]
save @m.xdut.xpll.xpfd.xd.x4.xmn1.m0[id] @m.xdut.xpll.xpfd.xd.x4.xmn2.m0[id] @m.xdut.xpll.xpfd.xd.x4.xmp1.m0[id] @m.xdut.xpll.xpfd.xd.x4.xmp2.m0[id] @m.xdut.xpll.xpfd.xd.x5.xmn1.m0[id] @m.xdut.xpll.xpfd.xd.x5.xmn2.m0[id] @m.xdut.xpll.xpfd.xd.x5.xmp1.m0[id] @m.xdut.xpll.xpfd.xd.x5.xmp2.m0[id] @m.xdut.xpll.xpfd.xd.x6.xmn1.m0[id] @m.xdut.xpll.xpfd.xd.x6.xmn2.m0[id] @m.xdut.xpll.xpfd.xd.x6.xmn3.m0[id] @m.xdut.xpll.xpfd.xd.x6.xmp1.m0[id] @m.xdut.xpll.xpfd.xd.x6.xmp2.m0[id] @m.xdut.xpll.xpfd.xd.x6.xmp3.m0[id] @m.xdut.xpll.xpfd.xr.xmn1.m0[id] @m.xdut.xpll.xpfd.xr.xmn2.m0[id] @m.xdut.xpll.xpfd.xr.xmp1.m0[id] @m.xdut.xpll.xpfd.xr.xmp2.m0[id] @m.xdut.xpll.xpfd.xd1.xmn.m0[id] @m.xdut.xpll.xpfd.xd1.xmp.m0[id]
save @m.xdut.xpll.xpfd.xd2.xmn.m0[id] @m.xdut.xpll.xpfd.xd2.xmp.m0[id] @m.xdut.xpll.xpfd.xd3.xmn.m0[id] @m.xdut.xpll.xpfd.xd3.xmp.m0[id] @m.xdut.xpll.xpfd.xd4.xmn.m0[id] @m.xdut.xpll.xpfd.xd4.xmp.m0[id] @m.xdut.xpll.xpfd.xo1.xmn.m0[id] @m.xdut.xpll.xpfd.xo1.xmp.m0[id] @m.xdut.xpll.xpfd.xo2.xmn.m0[id] @m.xdut.xpll.xpfd.xo2.xmp.m0[id] @m.xdut.xpll.xcp.xud.xmn.m0[id] @m.xdut.xpll.xcp.xud.xmp.m0[id] @m.xdut.xpll.xcp.xmpc.m0[id] @m.xdut.xpll.xcp.xmps.m0[id] @m.xdut.xpll.xcp.xmpd.m0[id] @m.xdut.xpll.xcp.xmns.m0[id] @m.xdut.xpll.xcp.xmnd.m0[id] @m.xdut.xpll.xcp.xmnc.m0[id] @m.xdut.xpll.xcp.xhi.xmn.m0[id] @m.xdut.xpll.xcp.xhi.xmp.m0[id]
save @m.xdut.xpll.xcp.xmpc2.m0[id] @m.xdut.xpll.xcp.xmpe2.m0[id] @m.xdut.xpll.xcp.xmps2.m0[id] @m.xdut.xpll.xcp.xmpd2.m0[id] @m.xdut.xpll.xcp.xmns2.m0[id] @m.xdut.xpll.xcp.xmnd2.m0[id] @m.xdut.xpll.xcp.xmne2.m0[id] @m.xdut.xpll.xcp.xmnc2.m0[id] @m.xdut.xpll.xcp.xmbt.m0[id] @m.xdut.xpll.xcp.xmb1.m0[id] @m.xdut.xpll.xcp.xmb2.m0[id] @m.xdut.xpll.xcp.xmbl1.m0[id] @m.xdut.xpll.xcp.xmbl2.m0[id] @m.xdut.xlna.xm1.m0[id] @m.xdut.xlna.xm2.m0[id] @m.xdut.xlna.xmp1.m0[id] @m.xdut.xlna.xm1r.m0[id] @m.xdut.xlna.xmp2.m0[id] @m.xdut.xlna.xm2r.m0[id] @m.xdut.xmix.xmctl1p.m0[id]
save @m.xdut.xmix.xmctl1n.m0[id] @m.xdut.xmix.xmctl2p.m0[id] @m.xdut.xmix.xmctl2n.m0[id] @m.xdut.xmix.xmctl3p.m0[id] @m.xdut.xmix.xmctl3n.m0[id] @m.xdut.xmix.xmctl4p.m0[id] @m.xdut.xmix.xmctl4n.m0[id] @m.xdut.xmix.xmti.m0[id] @m.xdut.xmix.xmg1i.m0[id] @m.xdut.xmix.xmg2i.m0[id] @m.xdut.xmix.xmlapi.m0[id] @m.xdut.xmix.xmlbpi.m0[id] @m.xdut.xmix.xmu1pi.m0[id] @m.xdut.xmix.xmu2pi.m0[id] @m.xdut.xmix.xmu3pi.m0[id] @m.xdut.xmix.xmu4pi.m0[id] @m.xdut.xmix.xmlani.m0[id] @m.xdut.xmix.xmlbni.m0[id] @m.xdut.xmix.xmu1ni.m0[id] @m.xdut.xmix.xmu2ni.m0[id]
save @m.xdut.xmix.xmu3ni.m0[id] @m.xdut.xmix.xmu4ni.m0[id] @m.xdut.xmix.xmtq.m0[id] @m.xdut.xmix.xmg1q.m0[id] @m.xdut.xmix.xmg2q.m0[id] @m.xdut.xmix.xmlapq.m0[id] @m.xdut.xmix.xmlbpq.m0[id] @m.xdut.xmix.xmu1pq.m0[id] @m.xdut.xmix.xmu2pq.m0[id] @m.xdut.xmix.xmu3pq.m0[id] @m.xdut.xmix.xmu4pq.m0[id] @m.xdut.xmix.xmlanq.m0[id] @m.xdut.xmix.xmlbnq.m0[id] @m.xdut.xmix.xmu1nq.m0[id] @m.xdut.xmix.xmu2nq.m0[id] @m.xdut.xmix.xmu3nq.m0[id] @m.xdut.xmix.xmu4nq.m0[id] @m.xdut.xifi.xbif.xmot.m0[id] @m.xdut.xifi.xbif.xmi1.m0[id] @m.xdut.xifi.xbif.xmi2.m0[id]
save @m.xdut.xifi.xbif.xml1.m0[id] @m.xdut.xifi.xbif.xml2.m0[id] @m.xdut.xifi.xbif.xmv.m0[id] @m.xdut.xifi.xbif.xmpd.m0[id] @m.xdut.xifi.xbif.xmpm.m0[id] @m.xdut.xifi.xbif.xmnd.m0[id] @m.xdut.xifi.xbif.xmnp.m0[id] @m.xdut.xifi.xbif.xmpp.m0[id] @m.xdut.xifi.xv1.xm1.m0[id] @m.xdut.xifi.xv1.xm2.m0[id] @m.xdut.xifi.xv1.xmt1.m0[id] @m.xdut.xifi.xv1.xmt2.m0[id] @m.xdut.xifi.xv1.xmsa.m0[id] @m.xdut.xifi.xv1.xmsb.m0[id] @m.xdut.xifi.xf1.xmfp.m0[id] @m.xdut.xifi.xf1.xmip.m0[id] @m.xdut.xifi.xf1.xmfn.m0[id] @m.xdut.xifi.xf1.xmin.m0[id] @m.xdut.xifi.xv2.xm1.m0[id] @m.xdut.xifi.xv2.xm2.m0[id]
save @m.xdut.xifi.xv2.xmt1.m0[id] @m.xdut.xifi.xv2.xmt2.m0[id] @m.xdut.xifi.xv2.xmsa.m0[id] @m.xdut.xifi.xv2.xmsb.m0[id] @m.xdut.xifi.xf2.xmfp.m0[id] @m.xdut.xifi.xf2.xmip.m0[id] @m.xdut.xifi.xf2.xmfn.m0[id] @m.xdut.xifi.xf2.xmin.m0[id] @m.xdut.xifi.xv3.xm1.m0[id] @m.xdut.xifi.xv3.xm2.m0[id] @m.xdut.xifi.xv3.xmt1.m0[id] @m.xdut.xifi.xv3.xmt2.m0[id] @m.xdut.xifi.xv3.xmsa.m0[id] @m.xdut.xifi.xv3.xmsb.m0[id] @m.xdut.xifi.xv4.xm1.m0[id] @m.xdut.xifi.xv4.xm2.m0[id] @m.xdut.xifi.xv4.xmt1.m0[id] @m.xdut.xifi.xv4.xmt2.m0[id] @m.xdut.xifi.xv5.xm1.m0[id] @m.xdut.xifi.xv5.xm2.m0[id]
save @m.xdut.xifi.xv5.xmt1.m0[id] @m.xdut.xifi.xv5.xmt2.m0[id] @m.xdut.xifq.xbif.xmot.m0[id] @m.xdut.xifq.xbif.xmi1.m0[id] @m.xdut.xifq.xbif.xmi2.m0[id] @m.xdut.xifq.xbif.xml1.m0[id] @m.xdut.xifq.xbif.xml2.m0[id] @m.xdut.xifq.xbif.xmv.m0[id] @m.xdut.xifq.xbif.xmpd.m0[id] @m.xdut.xifq.xbif.xmpm.m0[id] @m.xdut.xifq.xbif.xmnd.m0[id] @m.xdut.xifq.xbif.xmnp.m0[id] @m.xdut.xifq.xbif.xmpp.m0[id] @m.xdut.xifq.xv1.xm1.m0[id] @m.xdut.xifq.xv1.xm2.m0[id] @m.xdut.xifq.xv1.xmt1.m0[id] @m.xdut.xifq.xv1.xmt2.m0[id] @m.xdut.xifq.xv1.xmsa.m0[id] @m.xdut.xifq.xv1.xmsb.m0[id] @m.xdut.xifq.xf1.xmfp.m0[id]
save @m.xdut.xifq.xf1.xmip.m0[id] @m.xdut.xifq.xf1.xmfn.m0[id] @m.xdut.xifq.xf1.xmin.m0[id] @m.xdut.xifq.xv2.xm1.m0[id] @m.xdut.xifq.xv2.xm2.m0[id] @m.xdut.xifq.xv2.xmt1.m0[id] @m.xdut.xifq.xv2.xmt2.m0[id] @m.xdut.xifq.xv2.xmsa.m0[id] @m.xdut.xifq.xv2.xmsb.m0[id] @m.xdut.xifq.xf2.xmfp.m0[id] @m.xdut.xifq.xf2.xmip.m0[id] @m.xdut.xifq.xf2.xmfn.m0[id] @m.xdut.xifq.xf2.xmin.m0[id] @m.xdut.xifq.xv3.xm1.m0[id] @m.xdut.xifq.xv3.xm2.m0[id] @m.xdut.xifq.xv3.xmt1.m0[id] @m.xdut.xifq.xv3.xmt2.m0[id] @m.xdut.xifq.xv3.xmsa.m0[id] @m.xdut.xifq.xv3.xmsb.m0[id] @m.xdut.xifq.xv4.xm1.m0[id]
save @m.xdut.xifq.xv4.xm2.m0[id] @m.xdut.xifq.xv4.xmt1.m0[id] @m.xdut.xifq.xv4.xmt2.m0[id] @m.xdut.xifq.xv5.xm1.m0[id] @m.xdut.xifq.xv5.xm2.m0[id] @m.xdut.xifq.xv5.xmt1.m0[id] @m.xdut.xifq.xv5.xmt2.m0[id] @m.xdut.xadi.xcs.xmt.m0[id] @m.xdut.xadi.xcs.xm1.m0[id] @m.xdut.xadi.xcs.xm2.m0[id] @m.xdut.xadi.xcs.xm3.m0[id] @m.xdut.xadi.xcs.xm4.m0[id] @m.xdut.xadi.xcs.xm5.m0[id] @m.xdut.xadi.xcs.xm6.m0[id] @m.xdut.xadi.xcs.xm7.m0[id] @m.xdut.xadi.xcs.xm8.m0[id] @m.xdut.xadi.xcs.xm9.m0[id] @m.xdut.xadi.xcs.xm10.m0[id] @m.xdut.xadi.xcs.xm11.m0[id] @m.xdut.xadi.xcs.xm12.m0[id]
save @m.xdut.xadi.xcs.xi1.xmn.m0[id] @m.xdut.xadi.xcs.xi1.xmp.m0[id] @m.xdut.xadi.xcs.xi2.xmn.m0[id] @m.xdut.xadi.xcs.xi2.xmp.m0[id] @m.xdut.xadi.xcs.xs1.xmn1.m0[id] @m.xdut.xadi.xcs.xs1.xmn2.m0[id] @m.xdut.xadi.xcs.xs1.xmp1.m0[id] @m.xdut.xadi.xcs.xs1.xmp2.m0[id] @m.xdut.xadi.xcs.xs2.xmn1.m0[id] @m.xdut.xadi.xcs.xs2.xmn2.m0[id] @m.xdut.xadi.xcs.xs2.xmp1.m0[id] @m.xdut.xadi.xcs.xs2.xmp2.m0[id] @m.xdut.xadi.xch.xmt.m0[id] @m.xdut.xadi.xch.xm1.m0[id] @m.xdut.xadi.xch.xm2.m0[id] @m.xdut.xadi.xch.xm3.m0[id] @m.xdut.xadi.xch.xm4.m0[id] @m.xdut.xadi.xch.xm5.m0[id] @m.xdut.xadi.xch.xm6.m0[id] @m.xdut.xadi.xch.xm7.m0[id]
save @m.xdut.xadi.xch.xm8.m0[id] @m.xdut.xadi.xch.xm9.m0[id] @m.xdut.xadi.xch.xm10.m0[id] @m.xdut.xadi.xch.xm11.m0[id] @m.xdut.xadi.xch.xm12.m0[id] @m.xdut.xadi.xch.xi1.xmn.m0[id] @m.xdut.xadi.xch.xi1.xmp.m0[id] @m.xdut.xadi.xch.xi2.xmn.m0[id] @m.xdut.xadi.xch.xi2.xmp.m0[id] @m.xdut.xadi.xch.xs1.xmn1.m0[id] @m.xdut.xadi.xch.xs1.xmn2.m0[id] @m.xdut.xadi.xch.xs1.xmp1.m0[id] @m.xdut.xadi.xch.xs1.xmp2.m0[id] @m.xdut.xadi.xch.xs2.xmn1.m0[id] @m.xdut.xadi.xch.xs2.xmn2.m0[id] @m.xdut.xadi.xch.xs2.xmp1.m0[id] @m.xdut.xadi.xch.xs2.xmp2.m0[id] @m.xdut.xadi.xcl.xmt.m0[id] @m.xdut.xadi.xcl.xm1.m0[id] @m.xdut.xadi.xcl.xm2.m0[id]
save @m.xdut.xadi.xcl.xm3.m0[id] @m.xdut.xadi.xcl.xm4.m0[id] @m.xdut.xadi.xcl.xm5.m0[id] @m.xdut.xadi.xcl.xm6.m0[id] @m.xdut.xadi.xcl.xm7.m0[id] @m.xdut.xadi.xcl.xm8.m0[id] @m.xdut.xadi.xcl.xm9.m0[id] @m.xdut.xadi.xcl.xm10.m0[id] @m.xdut.xadi.xcl.xm11.m0[id] @m.xdut.xadi.xcl.xm12.m0[id] @m.xdut.xadi.xcl.xi1.xmn.m0[id] @m.xdut.xadi.xcl.xi1.xmp.m0[id] @m.xdut.xadi.xcl.xi2.xmn.m0[id] @m.xdut.xadi.xcl.xi2.xmp.m0[id] @m.xdut.xadi.xcl.xs1.xmn1.m0[id] @m.xdut.xadi.xcl.xs1.xmn2.m0[id] @m.xdut.xadi.xcl.xs1.xmp1.m0[id] @m.xdut.xadi.xcl.xs1.xmp2.m0[id] @m.xdut.xadi.xcl.xs2.xmn1.m0[id] @m.xdut.xadi.xcl.xs2.xmn2.m0[id]
save @m.xdut.xadi.xcl.xs2.xmp1.m0[id] @m.xdut.xadi.xcl.xs2.xmp2.m0[id] @m.xdut.xadi.xm.xmn1.m0[id] @m.xdut.xadi.xm.xmn2.m0[id] @m.xdut.xadi.xm.xmp1.m0[id] @m.xdut.xadi.xm.xmp2.m0[id] @m.xdut.xadq.xcs.xmt.m0[id] @m.xdut.xadq.xcs.xm1.m0[id] @m.xdut.xadq.xcs.xm2.m0[id] @m.xdut.xadq.xcs.xm3.m0[id] @m.xdut.xadq.xcs.xm4.m0[id] @m.xdut.xadq.xcs.xm5.m0[id] @m.xdut.xadq.xcs.xm6.m0[id] @m.xdut.xadq.xcs.xm7.m0[id] @m.xdut.xadq.xcs.xm8.m0[id] @m.xdut.xadq.xcs.xm9.m0[id] @m.xdut.xadq.xcs.xm10.m0[id] @m.xdut.xadq.xcs.xm11.m0[id] @m.xdut.xadq.xcs.xm12.m0[id] @m.xdut.xadq.xcs.xi1.xmn.m0[id]
save @m.xdut.xadq.xcs.xi1.xmp.m0[id] @m.xdut.xadq.xcs.xi2.xmn.m0[id] @m.xdut.xadq.xcs.xi2.xmp.m0[id] @m.xdut.xadq.xcs.xs1.xmn1.m0[id] @m.xdut.xadq.xcs.xs1.xmn2.m0[id] @m.xdut.xadq.xcs.xs1.xmp1.m0[id] @m.xdut.xadq.xcs.xs1.xmp2.m0[id] @m.xdut.xadq.xcs.xs2.xmn1.m0[id] @m.xdut.xadq.xcs.xs2.xmn2.m0[id] @m.xdut.xadq.xcs.xs2.xmp1.m0[id] @m.xdut.xadq.xcs.xs2.xmp2.m0[id] @m.xdut.xadq.xch.xmt.m0[id] @m.xdut.xadq.xch.xm1.m0[id] @m.xdut.xadq.xch.xm2.m0[id] @m.xdut.xadq.xch.xm3.m0[id] @m.xdut.xadq.xch.xm4.m0[id] @m.xdut.xadq.xch.xm5.m0[id] @m.xdut.xadq.xch.xm6.m0[id] @m.xdut.xadq.xch.xm7.m0[id] @m.xdut.xadq.xch.xm8.m0[id]
save @m.xdut.xadq.xch.xm9.m0[id] @m.xdut.xadq.xch.xm10.m0[id] @m.xdut.xadq.xch.xm11.m0[id] @m.xdut.xadq.xch.xm12.m0[id] @m.xdut.xadq.xch.xi1.xmn.m0[id] @m.xdut.xadq.xch.xi1.xmp.m0[id] @m.xdut.xadq.xch.xi2.xmn.m0[id] @m.xdut.xadq.xch.xi2.xmp.m0[id] @m.xdut.xadq.xch.xs1.xmn1.m0[id] @m.xdut.xadq.xch.xs1.xmn2.m0[id] @m.xdut.xadq.xch.xs1.xmp1.m0[id] @m.xdut.xadq.xch.xs1.xmp2.m0[id] @m.xdut.xadq.xch.xs2.xmn1.m0[id] @m.xdut.xadq.xch.xs2.xmn2.m0[id] @m.xdut.xadq.xch.xs2.xmp1.m0[id] @m.xdut.xadq.xch.xs2.xmp2.m0[id] @m.xdut.xadq.xcl.xmt.m0[id] @m.xdut.xadq.xcl.xm1.m0[id] @m.xdut.xadq.xcl.xm2.m0[id] @m.xdut.xadq.xcl.xm3.m0[id]
save @m.xdut.xadq.xcl.xm4.m0[id] @m.xdut.xadq.xcl.xm5.m0[id] @m.xdut.xadq.xcl.xm6.m0[id] @m.xdut.xadq.xcl.xm7.m0[id] @m.xdut.xadq.xcl.xm8.m0[id] @m.xdut.xadq.xcl.xm9.m0[id] @m.xdut.xadq.xcl.xm10.m0[id] @m.xdut.xadq.xcl.xm11.m0[id] @m.xdut.xadq.xcl.xm12.m0[id] @m.xdut.xadq.xcl.xi1.xmn.m0[id] @m.xdut.xadq.xcl.xi1.xmp.m0[id] @m.xdut.xadq.xcl.xi2.xmn.m0[id] @m.xdut.xadq.xcl.xi2.xmp.m0[id] @m.xdut.xadq.xcl.xs1.xmn1.m0[id] @m.xdut.xadq.xcl.xs1.xmn2.m0[id] @m.xdut.xadq.xcl.xs1.xmp1.m0[id] @m.xdut.xadq.xcl.xs1.xmp2.m0[id] @m.xdut.xadq.xcl.xs2.xmn1.m0[id] @m.xdut.xadq.xcl.xs2.xmn2.m0[id] @m.xdut.xadq.xcl.xs2.xmp1.m0[id]
save @m.xdut.xadq.xcl.xs2.xmp2.m0[id] @m.xdut.xadq.xm.xmn1.m0[id] @m.xdut.xadq.xm.xmn2.m0[id] @m.xdut.xadq.xm.xmp1.m0[id] @m.xdut.xadq.xm.xmp2.m0[id] @m.xdut.xcko1.xmn.m0[id] @m.xdut.xcko1.xmp.m0[id] @m.xdut.xcko2.xmn.m0[id] @m.xdut.xcko2.xmp.m0[id] @m.xdut.xafc.xa0.xmn.m0[id] @m.xdut.xafc.xa0.xmp.m0[id] @m.xdut.xafc.xb0.xmn.m0[id] @m.xdut.xafc.xb0.xmp.m0[id] @m.xdut.xafc.xa1.xmn.m0[id] @m.xdut.xafc.xa1.xmp.m0[id] @m.xdut.xafc.xb1.xmn.m0[id] @m.xdut.xafc.xb1.xmp.m0[id] @m.xdut.xafc.xa2.xmn.m0[id] @m.xdut.xafc.xa2.xmp.m0[id] @m.xdut.xafc.xb2.xmn.m0[id]
save @m.xdut.xafc.xb2.xmp.m0[id] @m.xdut.xafc.xa3.xmn.m0[id] @m.xdut.xafc.xa3.xmp.m0[id] @m.xdut.xafc.xb3.xmn.m0[id] @m.xdut.xafc.xb3.xmp.m0[id] @m.xdut.xafc.xa4.xmn.m0[id] @m.xdut.xafc.xa4.xmp.m0[id] @m.xdut.xafc.xb4.xmn.m0[id] @m.xdut.xafc.xb4.xmp.m0[id] @m.xdut.xafc.xa5.xmn.m0[id] @m.xdut.xafc.xa5.xmp.m0[id] @m.xdut.xafc.xb5.xmn.m0[id] @m.xdut.xafc.xb5.xmp.m0[id] @m.xdut.xafc.xa6.xmn.m0[id] @m.xdut.xafc.xa6.xmp.m0[id] @m.xdut.xafc.xb6.xmn.m0[id] @m.xdut.xafc.xb6.xmp.m0[id] @m.xdut.xafc.xa7.xmn.m0[id] @m.xdut.xafc.xa7.xmp.m0[id] @m.xdut.xafc.xb7.xmn.m0[id]
save @m.xdut.xafc.xb7.xmp.m0[id] @m.xdut.xdec.xmd0.m0[id] @m.xdut.xdec.xmd1.m0[id] @m.xdut.xdec.xmd2.m0[id] @m.xdut.xdec.xmd3.m0[id] @m.xdut.xdec.xmd4.m0[id] @m.xdut.xdec.xmd5.m0[id] @m.xdut.xdec.xmd6.m0[id] @m.xdut.xdec.xmd7.m0[id] @m.xdut.xdec.xmd8.m0[id] @m.xdut.xdec.xmd9.m0[id] @m.xdut.xdec.xmd10.m0[id] @m.xdut.xdec.xmd11.m0[id] @m.xdut.xdec.xmd12.m0[id]
tran 5p 0.5u 0.25u 5p uic
meas tran i0 avg @m.xdut.xspi.xscb.xmn.m0[id] from=0.25u to=0.5u
meas tran i1 avg @m.xdut.xspi.xscb.xmp.m0[id] from=0.25u to=0.5u
meas tran i2 avg @m.xdut.xspi.xscg.xmn1.m0[id] from=0.25u to=0.5u
meas tran i3 avg @m.xdut.xspi.xscg.xmn2.m0[id] from=0.25u to=0.5u
meas tran i4 avg @m.xdut.xspi.xscg.xmp1.m0[id] from=0.25u to=0.5u
meas tran i5 avg @m.xdut.xspi.xscg.xmp2.m0[id] from=0.25u to=0.5u
meas tran i6 avg @m.xdut.xspi.xp1.xmn.m0[id] from=0.25u to=0.5u
meas tran i7 avg @m.xdut.xspi.xp1.xmp.m0[id] from=0.25u to=0.5u
meas tran i8 avg @m.xdut.xspi.xp2.xmn.m0[id] from=0.25u to=0.5u
meas tran i9 avg @m.xdut.xspi.xp2.xmp.m0[id] from=0.25u to=0.5u
meas tran i10 avg @m.xdut.xspi.xp3.xmn.m0[id] from=0.25u to=0.5u
meas tran i11 avg @m.xdut.xspi.xp3.xmp.m0[id] from=0.25u to=0.5u
meas tran i12 avg @m.xdut.xspi.xr0.xci.xmn.m0[id] from=0.25u to=0.5u
meas tran i13 avg @m.xdut.xspi.xr0.xci.xmp.m0[id] from=0.25u to=0.5u
meas tran i14 avg @m.xdut.xspi.xr0.xt1n.m0[id] from=0.25u to=0.5u
meas tran i15 avg @m.xdut.xspi.xr0.xt1p.m0[id] from=0.25u to=0.5u
meas tran i16 avg @m.xdut.xspi.xr0.xm.xmn1.m0[id] from=0.25u to=0.5u
meas tran i17 avg @m.xdut.xspi.xr0.xm.xmn2.m0[id] from=0.25u to=0.5u
meas tran i18 avg @m.xdut.xspi.xr0.xm.xmp1.m0[id] from=0.25u to=0.5u
meas tran i19 avg @m.xdut.xspi.xr0.xm.xmp2.m0[id] from=0.25u to=0.5u
meas tran i20 avg @m.xdut.xspi.xr0.xmf.xmn.m0[id] from=0.25u to=0.5u
meas tran i21 avg @m.xdut.xspi.xr0.xmf.xmp.m0[id] from=0.25u to=0.5u
meas tran i22 avg @m.xdut.xspi.xr0.xt2n.m0[id] from=0.25u to=0.5u
meas tran i23 avg @m.xdut.xspi.xr0.xt2p.m0[id] from=0.25u to=0.5u
meas tran i24 avg @m.xdut.xspi.xr0.xt3n.m0[id] from=0.25u to=0.5u
meas tran i25 avg @m.xdut.xspi.xr0.xt3p.m0[id] from=0.25u to=0.5u
meas tran i26 avg @m.xdut.xspi.xr0.xs.xmn1.m0[id] from=0.25u to=0.5u
meas tran i27 avg @m.xdut.xspi.xr0.xs.xmn2.m0[id] from=0.25u to=0.5u
meas tran i28 avg @m.xdut.xspi.xr0.xs.xmp1.m0[id] from=0.25u to=0.5u
meas tran i29 avg @m.xdut.xspi.xr0.xs.xmp2.m0[id] from=0.25u to=0.5u
meas tran i30 avg @m.xdut.xspi.xr0.xsf.xmn.m0[id] from=0.25u to=0.5u
meas tran i31 avg @m.xdut.xspi.xr0.xsf.xmp.m0[id] from=0.25u to=0.5u
meas tran i32 avg @m.xdut.xspi.xr0.xt4n.m0[id] from=0.25u to=0.5u
meas tran i33 avg @m.xdut.xspi.xr0.xt4p.m0[id] from=0.25u to=0.5u
meas tran i34 avg @m.xdut.xspi.xr1.xci.xmn.m0[id] from=0.25u to=0.5u
meas tran i35 avg @m.xdut.xspi.xr1.xci.xmp.m0[id] from=0.25u to=0.5u
meas tran i36 avg @m.xdut.xspi.xr1.xt1n.m0[id] from=0.25u to=0.5u
meas tran i37 avg @m.xdut.xspi.xr1.xt1p.m0[id] from=0.25u to=0.5u
meas tran i38 avg @m.xdut.xspi.xr1.xm.xmn1.m0[id] from=0.25u to=0.5u
meas tran i39 avg @m.xdut.xspi.xr1.xm.xmn2.m0[id] from=0.25u to=0.5u
meas tran i40 avg @m.xdut.xspi.xr1.xm.xmp1.m0[id] from=0.25u to=0.5u
meas tran i41 avg @m.xdut.xspi.xr1.xm.xmp2.m0[id] from=0.25u to=0.5u
meas tran i42 avg @m.xdut.xspi.xr1.xmf.xmn.m0[id] from=0.25u to=0.5u
meas tran i43 avg @m.xdut.xspi.xr1.xmf.xmp.m0[id] from=0.25u to=0.5u
meas tran i44 avg @m.xdut.xspi.xr1.xt2n.m0[id] from=0.25u to=0.5u
meas tran i45 avg @m.xdut.xspi.xr1.xt2p.m0[id] from=0.25u to=0.5u
meas tran i46 avg @m.xdut.xspi.xr1.xt3n.m0[id] from=0.25u to=0.5u
meas tran i47 avg @m.xdut.xspi.xr1.xt3p.m0[id] from=0.25u to=0.5u
meas tran i48 avg @m.xdut.xspi.xr1.xs.xmn1.m0[id] from=0.25u to=0.5u
meas tran i49 avg @m.xdut.xspi.xr1.xs.xmn2.m0[id] from=0.25u to=0.5u
meas tran i50 avg @m.xdut.xspi.xr1.xs.xmp1.m0[id] from=0.25u to=0.5u
meas tran i51 avg @m.xdut.xspi.xr1.xs.xmp2.m0[id] from=0.25u to=0.5u
meas tran i52 avg @m.xdut.xspi.xr1.xsf.xmn.m0[id] from=0.25u to=0.5u
meas tran i53 avg @m.xdut.xspi.xr1.xsf.xmp.m0[id] from=0.25u to=0.5u
meas tran i54 avg @m.xdut.xspi.xr1.xt4n.m0[id] from=0.25u to=0.5u
meas tran i55 avg @m.xdut.xspi.xr1.xt4p.m0[id] from=0.25u to=0.5u
meas tran i56 avg @m.xdut.xspi.xr2.xci.xmn.m0[id] from=0.25u to=0.5u
meas tran i57 avg @m.xdut.xspi.xr2.xci.xmp.m0[id] from=0.25u to=0.5u
meas tran i58 avg @m.xdut.xspi.xr2.xt1n.m0[id] from=0.25u to=0.5u
meas tran i59 avg @m.xdut.xspi.xr2.xt1p.m0[id] from=0.25u to=0.5u
meas tran i60 avg @m.xdut.xspi.xr2.xm.xmn1.m0[id] from=0.25u to=0.5u
meas tran i61 avg @m.xdut.xspi.xr2.xm.xmn2.m0[id] from=0.25u to=0.5u
meas tran i62 avg @m.xdut.xspi.xr2.xm.xmp1.m0[id] from=0.25u to=0.5u
meas tran i63 avg @m.xdut.xspi.xr2.xm.xmp2.m0[id] from=0.25u to=0.5u
meas tran i64 avg @m.xdut.xspi.xr2.xmf.xmn.m0[id] from=0.25u to=0.5u
meas tran i65 avg @m.xdut.xspi.xr2.xmf.xmp.m0[id] from=0.25u to=0.5u
meas tran i66 avg @m.xdut.xspi.xr2.xt2n.m0[id] from=0.25u to=0.5u
meas tran i67 avg @m.xdut.xspi.xr2.xt2p.m0[id] from=0.25u to=0.5u
meas tran i68 avg @m.xdut.xspi.xr2.xt3n.m0[id] from=0.25u to=0.5u
meas tran i69 avg @m.xdut.xspi.xr2.xt3p.m0[id] from=0.25u to=0.5u
meas tran i70 avg @m.xdut.xspi.xr2.xs.xmn1.m0[id] from=0.25u to=0.5u
meas tran i71 avg @m.xdut.xspi.xr2.xs.xmn2.m0[id] from=0.25u to=0.5u
meas tran i72 avg @m.xdut.xspi.xr2.xs.xmp1.m0[id] from=0.25u to=0.5u
meas tran i73 avg @m.xdut.xspi.xr2.xs.xmp2.m0[id] from=0.25u to=0.5u
meas tran i74 avg @m.xdut.xspi.xr2.xsf.xmn.m0[id] from=0.25u to=0.5u
meas tran i75 avg @m.xdut.xspi.xr2.xsf.xmp.m0[id] from=0.25u to=0.5u
meas tran i76 avg @m.xdut.xspi.xr2.xt4n.m0[id] from=0.25u to=0.5u
meas tran i77 avg @m.xdut.xspi.xr2.xt4p.m0[id] from=0.25u to=0.5u
meas tran i78 avg @m.xdut.xspi.xr3.xci.xmn.m0[id] from=0.25u to=0.5u
meas tran i79 avg @m.xdut.xspi.xr3.xci.xmp.m0[id] from=0.25u to=0.5u
meas tran i80 avg @m.xdut.xspi.xr3.xt1n.m0[id] from=0.25u to=0.5u
meas tran i81 avg @m.xdut.xspi.xr3.xt1p.m0[id] from=0.25u to=0.5u
meas tran i82 avg @m.xdut.xspi.xr3.xm.xmn1.m0[id] from=0.25u to=0.5u
meas tran i83 avg @m.xdut.xspi.xr3.xm.xmn2.m0[id] from=0.25u to=0.5u
meas tran i84 avg @m.xdut.xspi.xr3.xm.xmp1.m0[id] from=0.25u to=0.5u
meas tran i85 avg @m.xdut.xspi.xr3.xm.xmp2.m0[id] from=0.25u to=0.5u
meas tran i86 avg @m.xdut.xspi.xr3.xmf.xmn.m0[id] from=0.25u to=0.5u
meas tran i87 avg @m.xdut.xspi.xr3.xmf.xmp.m0[id] from=0.25u to=0.5u
meas tran i88 avg @m.xdut.xspi.xr3.xt2n.m0[id] from=0.25u to=0.5u
meas tran i89 avg @m.xdut.xspi.xr3.xt2p.m0[id] from=0.25u to=0.5u
meas tran i90 avg @m.xdut.xspi.xr3.xt3n.m0[id] from=0.25u to=0.5u
meas tran i91 avg @m.xdut.xspi.xr3.xt3p.m0[id] from=0.25u to=0.5u
meas tran i92 avg @m.xdut.xspi.xr3.xs.xmn1.m0[id] from=0.25u to=0.5u
meas tran i93 avg @m.xdut.xspi.xr3.xs.xmn2.m0[id] from=0.25u to=0.5u
meas tran i94 avg @m.xdut.xspi.xr3.xs.xmp1.m0[id] from=0.25u to=0.5u
meas tran i95 avg @m.xdut.xspi.xr3.xs.xmp2.m0[id] from=0.25u to=0.5u
meas tran i96 avg @m.xdut.xspi.xr3.xsf.xmn.m0[id] from=0.25u to=0.5u
meas tran i97 avg @m.xdut.xspi.xr3.xsf.xmp.m0[id] from=0.25u to=0.5u
meas tran i98 avg @m.xdut.xspi.xr3.xt4n.m0[id] from=0.25u to=0.5u
meas tran i99 avg @m.xdut.xspi.xr3.xt4p.m0[id] from=0.25u to=0.5u
meas tran i100 avg @m.xdut.xspi.xr4.xci.xmn.m0[id] from=0.25u to=0.5u
meas tran i101 avg @m.xdut.xspi.xr4.xci.xmp.m0[id] from=0.25u to=0.5u
meas tran i102 avg @m.xdut.xspi.xr4.xt1n.m0[id] from=0.25u to=0.5u
meas tran i103 avg @m.xdut.xspi.xr4.xt1p.m0[id] from=0.25u to=0.5u
meas tran i104 avg @m.xdut.xspi.xr4.xm.xmn1.m0[id] from=0.25u to=0.5u
meas tran i105 avg @m.xdut.xspi.xr4.xm.xmn2.m0[id] from=0.25u to=0.5u
meas tran i106 avg @m.xdut.xspi.xr4.xm.xmp1.m0[id] from=0.25u to=0.5u
meas tran i107 avg @m.xdut.xspi.xr4.xm.xmp2.m0[id] from=0.25u to=0.5u
meas tran i108 avg @m.xdut.xspi.xr4.xmf.xmn.m0[id] from=0.25u to=0.5u
meas tran i109 avg @m.xdut.xspi.xr4.xmf.xmp.m0[id] from=0.25u to=0.5u
meas tran i110 avg @m.xdut.xspi.xr4.xt2n.m0[id] from=0.25u to=0.5u
meas tran i111 avg @m.xdut.xspi.xr4.xt2p.m0[id] from=0.25u to=0.5u
meas tran i112 avg @m.xdut.xspi.xr4.xt3n.m0[id] from=0.25u to=0.5u
meas tran i113 avg @m.xdut.xspi.xr4.xt3p.m0[id] from=0.25u to=0.5u
meas tran i114 avg @m.xdut.xspi.xr4.xs.xmn1.m0[id] from=0.25u to=0.5u
meas tran i115 avg @m.xdut.xspi.xr4.xs.xmn2.m0[id] from=0.25u to=0.5u
meas tran i116 avg @m.xdut.xspi.xr4.xs.xmp1.m0[id] from=0.25u to=0.5u
meas tran i117 avg @m.xdut.xspi.xr4.xs.xmp2.m0[id] from=0.25u to=0.5u
meas tran i118 avg @m.xdut.xspi.xr4.xsf.xmn.m0[id] from=0.25u to=0.5u
meas tran i119 avg @m.xdut.xspi.xr4.xsf.xmp.m0[id] from=0.25u to=0.5u
meas tran i120 avg @m.xdut.xspi.xr4.xt4n.m0[id] from=0.25u to=0.5u
meas tran i121 avg @m.xdut.xspi.xr4.xt4p.m0[id] from=0.25u to=0.5u
meas tran i122 avg @m.xdut.xspi.xr5.xci.xmn.m0[id] from=0.25u to=0.5u
meas tran i123 avg @m.xdut.xspi.xr5.xci.xmp.m0[id] from=0.25u to=0.5u
meas tran i124 avg @m.xdut.xspi.xr5.xt1n.m0[id] from=0.25u to=0.5u
meas tran i125 avg @m.xdut.xspi.xr5.xt1p.m0[id] from=0.25u to=0.5u
meas tran i126 avg @m.xdut.xspi.xr5.xm.xmn1.m0[id] from=0.25u to=0.5u
meas tran i127 avg @m.xdut.xspi.xr5.xm.xmn2.m0[id] from=0.25u to=0.5u
meas tran i128 avg @m.xdut.xspi.xr5.xm.xmp1.m0[id] from=0.25u to=0.5u
meas tran i129 avg @m.xdut.xspi.xr5.xm.xmp2.m0[id] from=0.25u to=0.5u
meas tran i130 avg @m.xdut.xspi.xr5.xmf.xmn.m0[id] from=0.25u to=0.5u
meas tran i131 avg @m.xdut.xspi.xr5.xmf.xmp.m0[id] from=0.25u to=0.5u
meas tran i132 avg @m.xdut.xspi.xr5.xt2n.m0[id] from=0.25u to=0.5u
meas tran i133 avg @m.xdut.xspi.xr5.xt2p.m0[id] from=0.25u to=0.5u
meas tran i134 avg @m.xdut.xspi.xr5.xt3n.m0[id] from=0.25u to=0.5u
meas tran i135 avg @m.xdut.xspi.xr5.xt3p.m0[id] from=0.25u to=0.5u
meas tran i136 avg @m.xdut.xspi.xr5.xs.xmn1.m0[id] from=0.25u to=0.5u
meas tran i137 avg @m.xdut.xspi.xr5.xs.xmn2.m0[id] from=0.25u to=0.5u
meas tran i138 avg @m.xdut.xspi.xr5.xs.xmp1.m0[id] from=0.25u to=0.5u
meas tran i139 avg @m.xdut.xspi.xr5.xs.xmp2.m0[id] from=0.25u to=0.5u
meas tran i140 avg @m.xdut.xspi.xr5.xsf.xmn.m0[id] from=0.25u to=0.5u
meas tran i141 avg @m.xdut.xspi.xr5.xsf.xmp.m0[id] from=0.25u to=0.5u
meas tran i142 avg @m.xdut.xspi.xr5.xt4n.m0[id] from=0.25u to=0.5u
meas tran i143 avg @m.xdut.xspi.xr5.xt4p.m0[id] from=0.25u to=0.5u
meas tran i144 avg @m.xdut.xspi.xr6.xci.xmn.m0[id] from=0.25u to=0.5u
meas tran i145 avg @m.xdut.xspi.xr6.xci.xmp.m0[id] from=0.25u to=0.5u
meas tran i146 avg @m.xdut.xspi.xr6.xt1n.m0[id] from=0.25u to=0.5u
meas tran i147 avg @m.xdut.xspi.xr6.xt1p.m0[id] from=0.25u to=0.5u
meas tran i148 avg @m.xdut.xspi.xr6.xm.xmn1.m0[id] from=0.25u to=0.5u
meas tran i149 avg @m.xdut.xspi.xr6.xm.xmn2.m0[id] from=0.25u to=0.5u
meas tran i150 avg @m.xdut.xspi.xr6.xm.xmp1.m0[id] from=0.25u to=0.5u
meas tran i151 avg @m.xdut.xspi.xr6.xm.xmp2.m0[id] from=0.25u to=0.5u
meas tran i152 avg @m.xdut.xspi.xr6.xmf.xmn.m0[id] from=0.25u to=0.5u
meas tran i153 avg @m.xdut.xspi.xr6.xmf.xmp.m0[id] from=0.25u to=0.5u
meas tran i154 avg @m.xdut.xspi.xr6.xt2n.m0[id] from=0.25u to=0.5u
meas tran i155 avg @m.xdut.xspi.xr6.xt2p.m0[id] from=0.25u to=0.5u
meas tran i156 avg @m.xdut.xspi.xr6.xt3n.m0[id] from=0.25u to=0.5u
meas tran i157 avg @m.xdut.xspi.xr6.xt3p.m0[id] from=0.25u to=0.5u
meas tran i158 avg @m.xdut.xspi.xr6.xs.xmn1.m0[id] from=0.25u to=0.5u
meas tran i159 avg @m.xdut.xspi.xr6.xs.xmn2.m0[id] from=0.25u to=0.5u
meas tran i160 avg @m.xdut.xspi.xr6.xs.xmp1.m0[id] from=0.25u to=0.5u
meas tran i161 avg @m.xdut.xspi.xr6.xs.xmp2.m0[id] from=0.25u to=0.5u
meas tran i162 avg @m.xdut.xspi.xr6.xsf.xmn.m0[id] from=0.25u to=0.5u
meas tran i163 avg @m.xdut.xspi.xr6.xsf.xmp.m0[id] from=0.25u to=0.5u
meas tran i164 avg @m.xdut.xspi.xr6.xt4n.m0[id] from=0.25u to=0.5u
meas tran i165 avg @m.xdut.xspi.xr6.xt4p.m0[id] from=0.25u to=0.5u
meas tran i166 avg @m.xdut.xspi.xr7.xci.xmn.m0[id] from=0.25u to=0.5u
meas tran i167 avg @m.xdut.xspi.xr7.xci.xmp.m0[id] from=0.25u to=0.5u
meas tran i168 avg @m.xdut.xspi.xr7.xt1n.m0[id] from=0.25u to=0.5u
meas tran i169 avg @m.xdut.xspi.xr7.xt1p.m0[id] from=0.25u to=0.5u
meas tran i170 avg @m.xdut.xspi.xr7.xm.xmn1.m0[id] from=0.25u to=0.5u
meas tran i171 avg @m.xdut.xspi.xr7.xm.xmn2.m0[id] from=0.25u to=0.5u
meas tran i172 avg @m.xdut.xspi.xr7.xm.xmp1.m0[id] from=0.25u to=0.5u
meas tran i173 avg @m.xdut.xspi.xr7.xm.xmp2.m0[id] from=0.25u to=0.5u
meas tran i174 avg @m.xdut.xspi.xr7.xmf.xmn.m0[id] from=0.25u to=0.5u
meas tran i175 avg @m.xdut.xspi.xr7.xmf.xmp.m0[id] from=0.25u to=0.5u
meas tran i176 avg @m.xdut.xspi.xr7.xt2n.m0[id] from=0.25u to=0.5u
meas tran i177 avg @m.xdut.xspi.xr7.xt2p.m0[id] from=0.25u to=0.5u
meas tran i178 avg @m.xdut.xspi.xr7.xt3n.m0[id] from=0.25u to=0.5u
meas tran i179 avg @m.xdut.xspi.xr7.xt3p.m0[id] from=0.25u to=0.5u
meas tran i180 avg @m.xdut.xspi.xr7.xs.xmn1.m0[id] from=0.25u to=0.5u
meas tran i181 avg @m.xdut.xspi.xr7.xs.xmn2.m0[id] from=0.25u to=0.5u
meas tran i182 avg @m.xdut.xspi.xr7.xs.xmp1.m0[id] from=0.25u to=0.5u
meas tran i183 avg @m.xdut.xspi.xr7.xs.xmp2.m0[id] from=0.25u to=0.5u
meas tran i184 avg @m.xdut.xspi.xr7.xsf.xmn.m0[id] from=0.25u to=0.5u
meas tran i185 avg @m.xdut.xspi.xr7.xsf.xmp.m0[id] from=0.25u to=0.5u
meas tran i186 avg @m.xdut.xspi.xr7.xt4n.m0[id] from=0.25u to=0.5u
meas tran i187 avg @m.xdut.xspi.xr7.xt4p.m0[id] from=0.25u to=0.5u
meas tran i188 avg @m.xdut.xspi.xr8.xci.xmn.m0[id] from=0.25u to=0.5u
meas tran i189 avg @m.xdut.xspi.xr8.xci.xmp.m0[id] from=0.25u to=0.5u
meas tran i190 avg @m.xdut.xspi.xr8.xt1n.m0[id] from=0.25u to=0.5u
meas tran i191 avg @m.xdut.xspi.xr8.xt1p.m0[id] from=0.25u to=0.5u
meas tran i192 avg @m.xdut.xspi.xr8.xm.xmn1.m0[id] from=0.25u to=0.5u
meas tran i193 avg @m.xdut.xspi.xr8.xm.xmn2.m0[id] from=0.25u to=0.5u
meas tran i194 avg @m.xdut.xspi.xr8.xm.xmp1.m0[id] from=0.25u to=0.5u
meas tran i195 avg @m.xdut.xspi.xr8.xm.xmp2.m0[id] from=0.25u to=0.5u
meas tran i196 avg @m.xdut.xspi.xr8.xmf.xmn.m0[id] from=0.25u to=0.5u
meas tran i197 avg @m.xdut.xspi.xr8.xmf.xmp.m0[id] from=0.25u to=0.5u
meas tran i198 avg @m.xdut.xspi.xr8.xt2n.m0[id] from=0.25u to=0.5u
meas tran i199 avg @m.xdut.xspi.xr8.xt2p.m0[id] from=0.25u to=0.5u
meas tran i200 avg @m.xdut.xspi.xr8.xt3n.m0[id] from=0.25u to=0.5u
meas tran i201 avg @m.xdut.xspi.xr8.xt3p.m0[id] from=0.25u to=0.5u
meas tran i202 avg @m.xdut.xspi.xr8.xs.xmn1.m0[id] from=0.25u to=0.5u
meas tran i203 avg @m.xdut.xspi.xr8.xs.xmn2.m0[id] from=0.25u to=0.5u
meas tran i204 avg @m.xdut.xspi.xr8.xs.xmp1.m0[id] from=0.25u to=0.5u
meas tran i205 avg @m.xdut.xspi.xr8.xs.xmp2.m0[id] from=0.25u to=0.5u
meas tran i206 avg @m.xdut.xspi.xr8.xsf.xmn.m0[id] from=0.25u to=0.5u
meas tran i207 avg @m.xdut.xspi.xr8.xsf.xmp.m0[id] from=0.25u to=0.5u
meas tran i208 avg @m.xdut.xspi.xr8.xt4n.m0[id] from=0.25u to=0.5u
meas tran i209 avg @m.xdut.xspi.xr8.xt4p.m0[id] from=0.25u to=0.5u
meas tran i210 avg @m.xdut.xspi.xr9.xci.xmn.m0[id] from=0.25u to=0.5u
meas tran i211 avg @m.xdut.xspi.xr9.xci.xmp.m0[id] from=0.25u to=0.5u
meas tran i212 avg @m.xdut.xspi.xr9.xt1n.m0[id] from=0.25u to=0.5u
meas tran i213 avg @m.xdut.xspi.xr9.xt1p.m0[id] from=0.25u to=0.5u
meas tran i214 avg @m.xdut.xspi.xr9.xm.xmn1.m0[id] from=0.25u to=0.5u
meas tran i215 avg @m.xdut.xspi.xr9.xm.xmn2.m0[id] from=0.25u to=0.5u
meas tran i216 avg @m.xdut.xspi.xr9.xm.xmp1.m0[id] from=0.25u to=0.5u
meas tran i217 avg @m.xdut.xspi.xr9.xm.xmp2.m0[id] from=0.25u to=0.5u
meas tran i218 avg @m.xdut.xspi.xr9.xmf.xmn.m0[id] from=0.25u to=0.5u
meas tran i219 avg @m.xdut.xspi.xr9.xmf.xmp.m0[id] from=0.25u to=0.5u
meas tran i220 avg @m.xdut.xspi.xr9.xt2n.m0[id] from=0.25u to=0.5u
meas tran i221 avg @m.xdut.xspi.xr9.xt2p.m0[id] from=0.25u to=0.5u
meas tran i222 avg @m.xdut.xspi.xr9.xt3n.m0[id] from=0.25u to=0.5u
meas tran i223 avg @m.xdut.xspi.xr9.xt3p.m0[id] from=0.25u to=0.5u
meas tran i224 avg @m.xdut.xspi.xr9.xs.xmn1.m0[id] from=0.25u to=0.5u
meas tran i225 avg @m.xdut.xspi.xr9.xs.xmn2.m0[id] from=0.25u to=0.5u
meas tran i226 avg @m.xdut.xspi.xr9.xs.xmp1.m0[id] from=0.25u to=0.5u
meas tran i227 avg @m.xdut.xspi.xr9.xs.xmp2.m0[id] from=0.25u to=0.5u
meas tran i228 avg @m.xdut.xspi.xr9.xsf.xmn.m0[id] from=0.25u to=0.5u
meas tran i229 avg @m.xdut.xspi.xr9.xsf.xmp.m0[id] from=0.25u to=0.5u
meas tran i230 avg @m.xdut.xspi.xr9.xt4n.m0[id] from=0.25u to=0.5u
meas tran i231 avg @m.xdut.xspi.xr9.xt4p.m0[id] from=0.25u to=0.5u
meas tran i232 avg @m.xdut.xspi.xr10.xci.xmn.m0[id] from=0.25u to=0.5u
meas tran i233 avg @m.xdut.xspi.xr10.xci.xmp.m0[id] from=0.25u to=0.5u
meas tran i234 avg @m.xdut.xspi.xr10.xt1n.m0[id] from=0.25u to=0.5u
meas tran i235 avg @m.xdut.xspi.xr10.xt1p.m0[id] from=0.25u to=0.5u
meas tran i236 avg @m.xdut.xspi.xr10.xm.xmn1.m0[id] from=0.25u to=0.5u
meas tran i237 avg @m.xdut.xspi.xr10.xm.xmn2.m0[id] from=0.25u to=0.5u
meas tran i238 avg @m.xdut.xspi.xr10.xm.xmp1.m0[id] from=0.25u to=0.5u
meas tran i239 avg @m.xdut.xspi.xr10.xm.xmp2.m0[id] from=0.25u to=0.5u
meas tran i240 avg @m.xdut.xspi.xr10.xmf.xmn.m0[id] from=0.25u to=0.5u
meas tran i241 avg @m.xdut.xspi.xr10.xmf.xmp.m0[id] from=0.25u to=0.5u
meas tran i242 avg @m.xdut.xspi.xr10.xt2n.m0[id] from=0.25u to=0.5u
meas tran i243 avg @m.xdut.xspi.xr10.xt2p.m0[id] from=0.25u to=0.5u
meas tran i244 avg @m.xdut.xspi.xr10.xt3n.m0[id] from=0.25u to=0.5u
meas tran i245 avg @m.xdut.xspi.xr10.xt3p.m0[id] from=0.25u to=0.5u
meas tran i246 avg @m.xdut.xspi.xr10.xs.xmn1.m0[id] from=0.25u to=0.5u
meas tran i247 avg @m.xdut.xspi.xr10.xs.xmn2.m0[id] from=0.25u to=0.5u
meas tran i248 avg @m.xdut.xspi.xr10.xs.xmp1.m0[id] from=0.25u to=0.5u
meas tran i249 avg @m.xdut.xspi.xr10.xs.xmp2.m0[id] from=0.25u to=0.5u
meas tran i250 avg @m.xdut.xspi.xr10.xsf.xmn.m0[id] from=0.25u to=0.5u
meas tran i251 avg @m.xdut.xspi.xr10.xsf.xmp.m0[id] from=0.25u to=0.5u
meas tran i252 avg @m.xdut.xspi.xr10.xt4n.m0[id] from=0.25u to=0.5u
meas tran i253 avg @m.xdut.xspi.xr10.xt4p.m0[id] from=0.25u to=0.5u
meas tran i254 avg @m.xdut.xspi.xr11.xci.xmn.m0[id] from=0.25u to=0.5u
meas tran i255 avg @m.xdut.xspi.xr11.xci.xmp.m0[id] from=0.25u to=0.5u
meas tran i256 avg @m.xdut.xspi.xr11.xt1n.m0[id] from=0.25u to=0.5u
meas tran i257 avg @m.xdut.xspi.xr11.xt1p.m0[id] from=0.25u to=0.5u
meas tran i258 avg @m.xdut.xspi.xr11.xm.xmn1.m0[id] from=0.25u to=0.5u
meas tran i259 avg @m.xdut.xspi.xr11.xm.xmn2.m0[id] from=0.25u to=0.5u
meas tran i260 avg @m.xdut.xspi.xr11.xm.xmp1.m0[id] from=0.25u to=0.5u
meas tran i261 avg @m.xdut.xspi.xr11.xm.xmp2.m0[id] from=0.25u to=0.5u
meas tran i262 avg @m.xdut.xspi.xr11.xmf.xmn.m0[id] from=0.25u to=0.5u
meas tran i263 avg @m.xdut.xspi.xr11.xmf.xmp.m0[id] from=0.25u to=0.5u
meas tran i264 avg @m.xdut.xspi.xr11.xt2n.m0[id] from=0.25u to=0.5u
meas tran i265 avg @m.xdut.xspi.xr11.xt2p.m0[id] from=0.25u to=0.5u
meas tran i266 avg @m.xdut.xspi.xr11.xt3n.m0[id] from=0.25u to=0.5u
meas tran i267 avg @m.xdut.xspi.xr11.xt3p.m0[id] from=0.25u to=0.5u
meas tran i268 avg @m.xdut.xspi.xr11.xs.xmn1.m0[id] from=0.25u to=0.5u
meas tran i269 avg @m.xdut.xspi.xr11.xs.xmn2.m0[id] from=0.25u to=0.5u
meas tran i270 avg @m.xdut.xspi.xr11.xs.xmp1.m0[id] from=0.25u to=0.5u
meas tran i271 avg @m.xdut.xspi.xr11.xs.xmp2.m0[id] from=0.25u to=0.5u
meas tran i272 avg @m.xdut.xspi.xr11.xsf.xmn.m0[id] from=0.25u to=0.5u
meas tran i273 avg @m.xdut.xspi.xr11.xsf.xmp.m0[id] from=0.25u to=0.5u
meas tran i274 avg @m.xdut.xspi.xr11.xt4n.m0[id] from=0.25u to=0.5u
meas tran i275 avg @m.xdut.xspi.xr11.xt4p.m0[id] from=0.25u to=0.5u
meas tran i276 avg @m.xdut.xspi.xr12.xci.xmn.m0[id] from=0.25u to=0.5u
meas tran i277 avg @m.xdut.xspi.xr12.xci.xmp.m0[id] from=0.25u to=0.5u
meas tran i278 avg @m.xdut.xspi.xr12.xt1n.m0[id] from=0.25u to=0.5u
meas tran i279 avg @m.xdut.xspi.xr12.xt1p.m0[id] from=0.25u to=0.5u
meas tran i280 avg @m.xdut.xspi.xr12.xm.xmn1.m0[id] from=0.25u to=0.5u
meas tran i281 avg @m.xdut.xspi.xr12.xm.xmn2.m0[id] from=0.25u to=0.5u
meas tran i282 avg @m.xdut.xspi.xr12.xm.xmp1.m0[id] from=0.25u to=0.5u
meas tran i283 avg @m.xdut.xspi.xr12.xm.xmp2.m0[id] from=0.25u to=0.5u
meas tran i284 avg @m.xdut.xspi.xr12.xmf.xmn.m0[id] from=0.25u to=0.5u
meas tran i285 avg @m.xdut.xspi.xr12.xmf.xmp.m0[id] from=0.25u to=0.5u
meas tran i286 avg @m.xdut.xspi.xr12.xt2n.m0[id] from=0.25u to=0.5u
meas tran i287 avg @m.xdut.xspi.xr12.xt2p.m0[id] from=0.25u to=0.5u
meas tran i288 avg @m.xdut.xspi.xr12.xt3n.m0[id] from=0.25u to=0.5u
meas tran i289 avg @m.xdut.xspi.xr12.xt3p.m0[id] from=0.25u to=0.5u
meas tran i290 avg @m.xdut.xspi.xr12.xs.xmn1.m0[id] from=0.25u to=0.5u
meas tran i291 avg @m.xdut.xspi.xr12.xs.xmn2.m0[id] from=0.25u to=0.5u
meas tran i292 avg @m.xdut.xspi.xr12.xs.xmp1.m0[id] from=0.25u to=0.5u
meas tran i293 avg @m.xdut.xspi.xr12.xs.xmp2.m0[id] from=0.25u to=0.5u
meas tran i294 avg @m.xdut.xspi.xr12.xsf.xmn.m0[id] from=0.25u to=0.5u
meas tran i295 avg @m.xdut.xspi.xr12.xsf.xmp.m0[id] from=0.25u to=0.5u
meas tran i296 avg @m.xdut.xspi.xr12.xt4n.m0[id] from=0.25u to=0.5u
meas tran i297 avg @m.xdut.xspi.xr12.xt4p.m0[id] from=0.25u to=0.5u
meas tran i298 avg @m.xdut.xspi.xr13.xci.xmn.m0[id] from=0.25u to=0.5u
meas tran i299 avg @m.xdut.xspi.xr13.xci.xmp.m0[id] from=0.25u to=0.5u
meas tran i300 avg @m.xdut.xspi.xr13.xt1n.m0[id] from=0.25u to=0.5u
meas tran i301 avg @m.xdut.xspi.xr13.xt1p.m0[id] from=0.25u to=0.5u
meas tran i302 avg @m.xdut.xspi.xr13.xm.xmn1.m0[id] from=0.25u to=0.5u
meas tran i303 avg @m.xdut.xspi.xr13.xm.xmn2.m0[id] from=0.25u to=0.5u
meas tran i304 avg @m.xdut.xspi.xr13.xm.xmp1.m0[id] from=0.25u to=0.5u
meas tran i305 avg @m.xdut.xspi.xr13.xm.xmp2.m0[id] from=0.25u to=0.5u
meas tran i306 avg @m.xdut.xspi.xr13.xmf.xmn.m0[id] from=0.25u to=0.5u
meas tran i307 avg @m.xdut.xspi.xr13.xmf.xmp.m0[id] from=0.25u to=0.5u
meas tran i308 avg @m.xdut.xspi.xr13.xt2n.m0[id] from=0.25u to=0.5u
meas tran i309 avg @m.xdut.xspi.xr13.xt2p.m0[id] from=0.25u to=0.5u
meas tran i310 avg @m.xdut.xspi.xr13.xt3n.m0[id] from=0.25u to=0.5u
meas tran i311 avg @m.xdut.xspi.xr13.xt3p.m0[id] from=0.25u to=0.5u
meas tran i312 avg @m.xdut.xspi.xr13.xs.xmn1.m0[id] from=0.25u to=0.5u
meas tran i313 avg @m.xdut.xspi.xr13.xs.xmn2.m0[id] from=0.25u to=0.5u
meas tran i314 avg @m.xdut.xspi.xr13.xs.xmp1.m0[id] from=0.25u to=0.5u
meas tran i315 avg @m.xdut.xspi.xr13.xs.xmp2.m0[id] from=0.25u to=0.5u
meas tran i316 avg @m.xdut.xspi.xr13.xsf.xmn.m0[id] from=0.25u to=0.5u
meas tran i317 avg @m.xdut.xspi.xr13.xsf.xmp.m0[id] from=0.25u to=0.5u
meas tran i318 avg @m.xdut.xspi.xr13.xt4n.m0[id] from=0.25u to=0.5u
meas tran i319 avg @m.xdut.xspi.xr13.xt4p.m0[id] from=0.25u to=0.5u
meas tran i320 avg @m.xdut.xspi.xr14.xci.xmn.m0[id] from=0.25u to=0.5u
meas tran i321 avg @m.xdut.xspi.xr14.xci.xmp.m0[id] from=0.25u to=0.5u
meas tran i322 avg @m.xdut.xspi.xr14.xt1n.m0[id] from=0.25u to=0.5u
meas tran i323 avg @m.xdut.xspi.xr14.xt1p.m0[id] from=0.25u to=0.5u
meas tran i324 avg @m.xdut.xspi.xr14.xm.xmn1.m0[id] from=0.25u to=0.5u
meas tran i325 avg @m.xdut.xspi.xr14.xm.xmn2.m0[id] from=0.25u to=0.5u
meas tran i326 avg @m.xdut.xspi.xr14.xm.xmp1.m0[id] from=0.25u to=0.5u
meas tran i327 avg @m.xdut.xspi.xr14.xm.xmp2.m0[id] from=0.25u to=0.5u
meas tran i328 avg @m.xdut.xspi.xr14.xmf.xmn.m0[id] from=0.25u to=0.5u
meas tran i329 avg @m.xdut.xspi.xr14.xmf.xmp.m0[id] from=0.25u to=0.5u
meas tran i330 avg @m.xdut.xspi.xr14.xt2n.m0[id] from=0.25u to=0.5u
meas tran i331 avg @m.xdut.xspi.xr14.xt2p.m0[id] from=0.25u to=0.5u
meas tran i332 avg @m.xdut.xspi.xr14.xt3n.m0[id] from=0.25u to=0.5u
meas tran i333 avg @m.xdut.xspi.xr14.xt3p.m0[id] from=0.25u to=0.5u
meas tran i334 avg @m.xdut.xspi.xr14.xs.xmn1.m0[id] from=0.25u to=0.5u
meas tran i335 avg @m.xdut.xspi.xr14.xs.xmn2.m0[id] from=0.25u to=0.5u
meas tran i336 avg @m.xdut.xspi.xr14.xs.xmp1.m0[id] from=0.25u to=0.5u
meas tran i337 avg @m.xdut.xspi.xr14.xs.xmp2.m0[id] from=0.25u to=0.5u
meas tran i338 avg @m.xdut.xspi.xr14.xsf.xmn.m0[id] from=0.25u to=0.5u
meas tran i339 avg @m.xdut.xspi.xr14.xsf.xmp.m0[id] from=0.25u to=0.5u
meas tran i340 avg @m.xdut.xspi.xr14.xt4n.m0[id] from=0.25u to=0.5u
meas tran i341 avg @m.xdut.xspi.xr14.xt4p.m0[id] from=0.25u to=0.5u
meas tran i342 avg @m.xdut.xspi.xr15.xci.xmn.m0[id] from=0.25u to=0.5u
meas tran i343 avg @m.xdut.xspi.xr15.xci.xmp.m0[id] from=0.25u to=0.5u
meas tran i344 avg @m.xdut.xspi.xr15.xt1n.m0[id] from=0.25u to=0.5u
meas tran i345 avg @m.xdut.xspi.xr15.xt1p.m0[id] from=0.25u to=0.5u
meas tran i346 avg @m.xdut.xspi.xr15.xm.xmn1.m0[id] from=0.25u to=0.5u
meas tran i347 avg @m.xdut.xspi.xr15.xm.xmn2.m0[id] from=0.25u to=0.5u
meas tran i348 avg @m.xdut.xspi.xr15.xm.xmp1.m0[id] from=0.25u to=0.5u
meas tran i349 avg @m.xdut.xspi.xr15.xm.xmp2.m0[id] from=0.25u to=0.5u
meas tran i350 avg @m.xdut.xspi.xr15.xmf.xmn.m0[id] from=0.25u to=0.5u
meas tran i351 avg @m.xdut.xspi.xr15.xmf.xmp.m0[id] from=0.25u to=0.5u
meas tran i352 avg @m.xdut.xspi.xr15.xt2n.m0[id] from=0.25u to=0.5u
meas tran i353 avg @m.xdut.xspi.xr15.xt2p.m0[id] from=0.25u to=0.5u
meas tran i354 avg @m.xdut.xspi.xr15.xt3n.m0[id] from=0.25u to=0.5u
meas tran i355 avg @m.xdut.xspi.xr15.xt3p.m0[id] from=0.25u to=0.5u
meas tran i356 avg @m.xdut.xspi.xr15.xs.xmn1.m0[id] from=0.25u to=0.5u
meas tran i357 avg @m.xdut.xspi.xr15.xs.xmn2.m0[id] from=0.25u to=0.5u
meas tran i358 avg @m.xdut.xspi.xr15.xs.xmp1.m0[id] from=0.25u to=0.5u
meas tran i359 avg @m.xdut.xspi.xr15.xs.xmp2.m0[id] from=0.25u to=0.5u
meas tran i360 avg @m.xdut.xspi.xr15.xsf.xmn.m0[id] from=0.25u to=0.5u
meas tran i361 avg @m.xdut.xspi.xr15.xsf.xmp.m0[id] from=0.25u to=0.5u
meas tran i362 avg @m.xdut.xspi.xr15.xt4n.m0[id] from=0.25u to=0.5u
meas tran i363 avg @m.xdut.xspi.xr15.xt4p.m0[id] from=0.25u to=0.5u
meas tran i364 avg @m.xdut.xspi.xr16.xci.xmn.m0[id] from=0.25u to=0.5u
meas tran i365 avg @m.xdut.xspi.xr16.xci.xmp.m0[id] from=0.25u to=0.5u
meas tran i366 avg @m.xdut.xspi.xr16.xt1n.m0[id] from=0.25u to=0.5u
meas tran i367 avg @m.xdut.xspi.xr16.xt1p.m0[id] from=0.25u to=0.5u
meas tran i368 avg @m.xdut.xspi.xr16.xm.xmn1.m0[id] from=0.25u to=0.5u
meas tran i369 avg @m.xdut.xspi.xr16.xm.xmn2.m0[id] from=0.25u to=0.5u
meas tran i370 avg @m.xdut.xspi.xr16.xm.xmp1.m0[id] from=0.25u to=0.5u
meas tran i371 avg @m.xdut.xspi.xr16.xm.xmp2.m0[id] from=0.25u to=0.5u
meas tran i372 avg @m.xdut.xspi.xr16.xmf.xmn.m0[id] from=0.25u to=0.5u
meas tran i373 avg @m.xdut.xspi.xr16.xmf.xmp.m0[id] from=0.25u to=0.5u
meas tran i374 avg @m.xdut.xspi.xr16.xt2n.m0[id] from=0.25u to=0.5u
meas tran i375 avg @m.xdut.xspi.xr16.xt2p.m0[id] from=0.25u to=0.5u
meas tran i376 avg @m.xdut.xspi.xr16.xt3n.m0[id] from=0.25u to=0.5u
meas tran i377 avg @m.xdut.xspi.xr16.xt3p.m0[id] from=0.25u to=0.5u
meas tran i378 avg @m.xdut.xspi.xr16.xs.xmn1.m0[id] from=0.25u to=0.5u
meas tran i379 avg @m.xdut.xspi.xr16.xs.xmn2.m0[id] from=0.25u to=0.5u
meas tran i380 avg @m.xdut.xspi.xr16.xs.xmp1.m0[id] from=0.25u to=0.5u
meas tran i381 avg @m.xdut.xspi.xr16.xs.xmp2.m0[id] from=0.25u to=0.5u
meas tran i382 avg @m.xdut.xspi.xr16.xsf.xmn.m0[id] from=0.25u to=0.5u
meas tran i383 avg @m.xdut.xspi.xr16.xsf.xmp.m0[id] from=0.25u to=0.5u
meas tran i384 avg @m.xdut.xspi.xr16.xt4n.m0[id] from=0.25u to=0.5u
meas tran i385 avg @m.xdut.xspi.xr16.xt4p.m0[id] from=0.25u to=0.5u
meas tran i386 avg @m.xdut.xspi.xr17.xci.xmn.m0[id] from=0.25u to=0.5u
meas tran i387 avg @m.xdut.xspi.xr17.xci.xmp.m0[id] from=0.25u to=0.5u
meas tran i388 avg @m.xdut.xspi.xr17.xt1n.m0[id] from=0.25u to=0.5u
meas tran i389 avg @m.xdut.xspi.xr17.xt1p.m0[id] from=0.25u to=0.5u
meas tran i390 avg @m.xdut.xspi.xr17.xm.xmn1.m0[id] from=0.25u to=0.5u
meas tran i391 avg @m.xdut.xspi.xr17.xm.xmn2.m0[id] from=0.25u to=0.5u
meas tran i392 avg @m.xdut.xspi.xr17.xm.xmp1.m0[id] from=0.25u to=0.5u
meas tran i393 avg @m.xdut.xspi.xr17.xm.xmp2.m0[id] from=0.25u to=0.5u
meas tran i394 avg @m.xdut.xspi.xr17.xmf.xmn.m0[id] from=0.25u to=0.5u
meas tran i395 avg @m.xdut.xspi.xr17.xmf.xmp.m0[id] from=0.25u to=0.5u
meas tran i396 avg @m.xdut.xspi.xr17.xt2n.m0[id] from=0.25u to=0.5u
meas tran i397 avg @m.xdut.xspi.xr17.xt2p.m0[id] from=0.25u to=0.5u
meas tran i398 avg @m.xdut.xspi.xr17.xt3n.m0[id] from=0.25u to=0.5u
meas tran i399 avg @m.xdut.xspi.xr17.xt3p.m0[id] from=0.25u to=0.5u
meas tran i400 avg @m.xdut.xspi.xr17.xs.xmn1.m0[id] from=0.25u to=0.5u
meas tran i401 avg @m.xdut.xspi.xr17.xs.xmn2.m0[id] from=0.25u to=0.5u
meas tran i402 avg @m.xdut.xspi.xr17.xs.xmp1.m0[id] from=0.25u to=0.5u
meas tran i403 avg @m.xdut.xspi.xr17.xs.xmp2.m0[id] from=0.25u to=0.5u
meas tran i404 avg @m.xdut.xspi.xr17.xsf.xmn.m0[id] from=0.25u to=0.5u
meas tran i405 avg @m.xdut.xspi.xr17.xsf.xmp.m0[id] from=0.25u to=0.5u
meas tran i406 avg @m.xdut.xspi.xr17.xt4n.m0[id] from=0.25u to=0.5u
meas tran i407 avg @m.xdut.xspi.xr17.xt4p.m0[id] from=0.25u to=0.5u
meas tran i408 avg @m.xdut.xspi.xr18.xci.xmn.m0[id] from=0.25u to=0.5u
meas tran i409 avg @m.xdut.xspi.xr18.xci.xmp.m0[id] from=0.25u to=0.5u
meas tran i410 avg @m.xdut.xspi.xr18.xt1n.m0[id] from=0.25u to=0.5u
meas tran i411 avg @m.xdut.xspi.xr18.xt1p.m0[id] from=0.25u to=0.5u
meas tran i412 avg @m.xdut.xspi.xr18.xm.xmn1.m0[id] from=0.25u to=0.5u
meas tran i413 avg @m.xdut.xspi.xr18.xm.xmn2.m0[id] from=0.25u to=0.5u
meas tran i414 avg @m.xdut.xspi.xr18.xm.xmp1.m0[id] from=0.25u to=0.5u
meas tran i415 avg @m.xdut.xspi.xr18.xm.xmp2.m0[id] from=0.25u to=0.5u
meas tran i416 avg @m.xdut.xspi.xr18.xmf.xmn.m0[id] from=0.25u to=0.5u
meas tran i417 avg @m.xdut.xspi.xr18.xmf.xmp.m0[id] from=0.25u to=0.5u
meas tran i418 avg @m.xdut.xspi.xr18.xt2n.m0[id] from=0.25u to=0.5u
meas tran i419 avg @m.xdut.xspi.xr18.xt2p.m0[id] from=0.25u to=0.5u
meas tran i420 avg @m.xdut.xspi.xr18.xt3n.m0[id] from=0.25u to=0.5u
meas tran i421 avg @m.xdut.xspi.xr18.xt3p.m0[id] from=0.25u to=0.5u
meas tran i422 avg @m.xdut.xspi.xr18.xs.xmn1.m0[id] from=0.25u to=0.5u
meas tran i423 avg @m.xdut.xspi.xr18.xs.xmn2.m0[id] from=0.25u to=0.5u
meas tran i424 avg @m.xdut.xspi.xr18.xs.xmp1.m0[id] from=0.25u to=0.5u
meas tran i425 avg @m.xdut.xspi.xr18.xs.xmp2.m0[id] from=0.25u to=0.5u
meas tran i426 avg @m.xdut.xspi.xr18.xsf.xmn.m0[id] from=0.25u to=0.5u
meas tran i427 avg @m.xdut.xspi.xr18.xsf.xmp.m0[id] from=0.25u to=0.5u
meas tran i428 avg @m.xdut.xspi.xr18.xt4n.m0[id] from=0.25u to=0.5u
meas tran i429 avg @m.xdut.xspi.xr18.xt4p.m0[id] from=0.25u to=0.5u
meas tran i430 avg @m.xdut.xspi.xr19.xci.xmn.m0[id] from=0.25u to=0.5u
meas tran i431 avg @m.xdut.xspi.xr19.xci.xmp.m0[id] from=0.25u to=0.5u
meas tran i432 avg @m.xdut.xspi.xr19.xt1n.m0[id] from=0.25u to=0.5u
meas tran i433 avg @m.xdut.xspi.xr19.xt1p.m0[id] from=0.25u to=0.5u
meas tran i434 avg @m.xdut.xspi.xr19.xm.xmn1.m0[id] from=0.25u to=0.5u
meas tran i435 avg @m.xdut.xspi.xr19.xm.xmn2.m0[id] from=0.25u to=0.5u
meas tran i436 avg @m.xdut.xspi.xr19.xm.xmp1.m0[id] from=0.25u to=0.5u
meas tran i437 avg @m.xdut.xspi.xr19.xm.xmp2.m0[id] from=0.25u to=0.5u
meas tran i438 avg @m.xdut.xspi.xr19.xmf.xmn.m0[id] from=0.25u to=0.5u
meas tran i439 avg @m.xdut.xspi.xr19.xmf.xmp.m0[id] from=0.25u to=0.5u
meas tran i440 avg @m.xdut.xspi.xr19.xt2n.m0[id] from=0.25u to=0.5u
meas tran i441 avg @m.xdut.xspi.xr19.xt2p.m0[id] from=0.25u to=0.5u
meas tran i442 avg @m.xdut.xspi.xr19.xt3n.m0[id] from=0.25u to=0.5u
meas tran i443 avg @m.xdut.xspi.xr19.xt3p.m0[id] from=0.25u to=0.5u
meas tran i444 avg @m.xdut.xspi.xr19.xs.xmn1.m0[id] from=0.25u to=0.5u
meas tran i445 avg @m.xdut.xspi.xr19.xs.xmn2.m0[id] from=0.25u to=0.5u
meas tran i446 avg @m.xdut.xspi.xr19.xs.xmp1.m0[id] from=0.25u to=0.5u
meas tran i447 avg @m.xdut.xspi.xr19.xs.xmp2.m0[id] from=0.25u to=0.5u
meas tran i448 avg @m.xdut.xspi.xr19.xsf.xmn.m0[id] from=0.25u to=0.5u
meas tran i449 avg @m.xdut.xspi.xr19.xsf.xmp.m0[id] from=0.25u to=0.5u
meas tran i450 avg @m.xdut.xspi.xr19.xt4n.m0[id] from=0.25u to=0.5u
meas tran i451 avg @m.xdut.xspi.xr19.xt4p.m0[id] from=0.25u to=0.5u
meas tran i452 avg @m.xdut.xspi.xr20.xci.xmn.m0[id] from=0.25u to=0.5u
meas tran i453 avg @m.xdut.xspi.xr20.xci.xmp.m0[id] from=0.25u to=0.5u
meas tran i454 avg @m.xdut.xspi.xr20.xt1n.m0[id] from=0.25u to=0.5u
meas tran i455 avg @m.xdut.xspi.xr20.xt1p.m0[id] from=0.25u to=0.5u
meas tran i456 avg @m.xdut.xspi.xr20.xm.xmn1.m0[id] from=0.25u to=0.5u
meas tran i457 avg @m.xdut.xspi.xr20.xm.xmn2.m0[id] from=0.25u to=0.5u
meas tran i458 avg @m.xdut.xspi.xr20.xm.xmp1.m0[id] from=0.25u to=0.5u
meas tran i459 avg @m.xdut.xspi.xr20.xm.xmp2.m0[id] from=0.25u to=0.5u
meas tran i460 avg @m.xdut.xspi.xr20.xmf.xmn.m0[id] from=0.25u to=0.5u
meas tran i461 avg @m.xdut.xspi.xr20.xmf.xmp.m0[id] from=0.25u to=0.5u
meas tran i462 avg @m.xdut.xspi.xr20.xt2n.m0[id] from=0.25u to=0.5u
meas tran i463 avg @m.xdut.xspi.xr20.xt2p.m0[id] from=0.25u to=0.5u
meas tran i464 avg @m.xdut.xspi.xr20.xt3n.m0[id] from=0.25u to=0.5u
meas tran i465 avg @m.xdut.xspi.xr20.xt3p.m0[id] from=0.25u to=0.5u
meas tran i466 avg @m.xdut.xspi.xr20.xs.xmn1.m0[id] from=0.25u to=0.5u
meas tran i467 avg @m.xdut.xspi.xr20.xs.xmn2.m0[id] from=0.25u to=0.5u
meas tran i468 avg @m.xdut.xspi.xr20.xs.xmp1.m0[id] from=0.25u to=0.5u
meas tran i469 avg @m.xdut.xspi.xr20.xs.xmp2.m0[id] from=0.25u to=0.5u
meas tran i470 avg @m.xdut.xspi.xr20.xsf.xmn.m0[id] from=0.25u to=0.5u
meas tran i471 avg @m.xdut.xspi.xr20.xsf.xmp.m0[id] from=0.25u to=0.5u
meas tran i472 avg @m.xdut.xspi.xr20.xt4n.m0[id] from=0.25u to=0.5u
meas tran i473 avg @m.xdut.xspi.xr20.xt4p.m0[id] from=0.25u to=0.5u
meas tran i474 avg @m.xdut.xspi.xr21.xci.xmn.m0[id] from=0.25u to=0.5u
meas tran i475 avg @m.xdut.xspi.xr21.xci.xmp.m0[id] from=0.25u to=0.5u
meas tran i476 avg @m.xdut.xspi.xr21.xt1n.m0[id] from=0.25u to=0.5u
meas tran i477 avg @m.xdut.xspi.xr21.xt1p.m0[id] from=0.25u to=0.5u
meas tran i478 avg @m.xdut.xspi.xr21.xm.xmn1.m0[id] from=0.25u to=0.5u
meas tran i479 avg @m.xdut.xspi.xr21.xm.xmn2.m0[id] from=0.25u to=0.5u
meas tran i480 avg @m.xdut.xspi.xr21.xm.xmp1.m0[id] from=0.25u to=0.5u
meas tran i481 avg @m.xdut.xspi.xr21.xm.xmp2.m0[id] from=0.25u to=0.5u
meas tran i482 avg @m.xdut.xspi.xr21.xmf.xmn.m0[id] from=0.25u to=0.5u
meas tran i483 avg @m.xdut.xspi.xr21.xmf.xmp.m0[id] from=0.25u to=0.5u
meas tran i484 avg @m.xdut.xspi.xr21.xt2n.m0[id] from=0.25u to=0.5u
meas tran i485 avg @m.xdut.xspi.xr21.xt2p.m0[id] from=0.25u to=0.5u
meas tran i486 avg @m.xdut.xspi.xr21.xt3n.m0[id] from=0.25u to=0.5u
meas tran i487 avg @m.xdut.xspi.xr21.xt3p.m0[id] from=0.25u to=0.5u
meas tran i488 avg @m.xdut.xspi.xr21.xs.xmn1.m0[id] from=0.25u to=0.5u
meas tran i489 avg @m.xdut.xspi.xr21.xs.xmn2.m0[id] from=0.25u to=0.5u
meas tran i490 avg @m.xdut.xspi.xr21.xs.xmp1.m0[id] from=0.25u to=0.5u
meas tran i491 avg @m.xdut.xspi.xr21.xs.xmp2.m0[id] from=0.25u to=0.5u
meas tran i492 avg @m.xdut.xspi.xr21.xsf.xmn.m0[id] from=0.25u to=0.5u
meas tran i493 avg @m.xdut.xspi.xr21.xsf.xmp.m0[id] from=0.25u to=0.5u
meas tran i494 avg @m.xdut.xspi.xr21.xt4n.m0[id] from=0.25u to=0.5u
meas tran i495 avg @m.xdut.xspi.xr21.xt4p.m0[id] from=0.25u to=0.5u
meas tran i496 avg @m.xdut.xspi.xr22.xci.xmn.m0[id] from=0.25u to=0.5u
meas tran i497 avg @m.xdut.xspi.xr22.xci.xmp.m0[id] from=0.25u to=0.5u
meas tran i498 avg @m.xdut.xspi.xr22.xt1n.m0[id] from=0.25u to=0.5u
meas tran i499 avg @m.xdut.xspi.xr22.xt1p.m0[id] from=0.25u to=0.5u
meas tran i500 avg @m.xdut.xspi.xr22.xm.xmn1.m0[id] from=0.25u to=0.5u
meas tran i501 avg @m.xdut.xspi.xr22.xm.xmn2.m0[id] from=0.25u to=0.5u
meas tran i502 avg @m.xdut.xspi.xr22.xm.xmp1.m0[id] from=0.25u to=0.5u
meas tran i503 avg @m.xdut.xspi.xr22.xm.xmp2.m0[id] from=0.25u to=0.5u
meas tran i504 avg @m.xdut.xspi.xr22.xmf.xmn.m0[id] from=0.25u to=0.5u
meas tran i505 avg @m.xdut.xspi.xr22.xmf.xmp.m0[id] from=0.25u to=0.5u
meas tran i506 avg @m.xdut.xspi.xr22.xt2n.m0[id] from=0.25u to=0.5u
meas tran i507 avg @m.xdut.xspi.xr22.xt2p.m0[id] from=0.25u to=0.5u
meas tran i508 avg @m.xdut.xspi.xr22.xt3n.m0[id] from=0.25u to=0.5u
meas tran i509 avg @m.xdut.xspi.xr22.xt3p.m0[id] from=0.25u to=0.5u
meas tran i510 avg @m.xdut.xspi.xr22.xs.xmn1.m0[id] from=0.25u to=0.5u
meas tran i511 avg @m.xdut.xspi.xr22.xs.xmn2.m0[id] from=0.25u to=0.5u
meas tran i512 avg @m.xdut.xspi.xr22.xs.xmp1.m0[id] from=0.25u to=0.5u
meas tran i513 avg @m.xdut.xspi.xr22.xs.xmp2.m0[id] from=0.25u to=0.5u
meas tran i514 avg @m.xdut.xspi.xr22.xsf.xmn.m0[id] from=0.25u to=0.5u
meas tran i515 avg @m.xdut.xspi.xr22.xsf.xmp.m0[id] from=0.25u to=0.5u
meas tran i516 avg @m.xdut.xspi.xr22.xt4n.m0[id] from=0.25u to=0.5u
meas tran i517 avg @m.xdut.xspi.xr22.xt4p.m0[id] from=0.25u to=0.5u
meas tran i518 avg @m.xdut.xspi.xr23.xci.xmn.m0[id] from=0.25u to=0.5u
meas tran i519 avg @m.xdut.xspi.xr23.xci.xmp.m0[id] from=0.25u to=0.5u
meas tran i520 avg @m.xdut.xspi.xr23.xt1n.m0[id] from=0.25u to=0.5u
meas tran i521 avg @m.xdut.xspi.xr23.xt1p.m0[id] from=0.25u to=0.5u
meas tran i522 avg @m.xdut.xspi.xr23.xm.xmn1.m0[id] from=0.25u to=0.5u
meas tran i523 avg @m.xdut.xspi.xr23.xm.xmn2.m0[id] from=0.25u to=0.5u
meas tran i524 avg @m.xdut.xspi.xr23.xm.xmp1.m0[id] from=0.25u to=0.5u
meas tran i525 avg @m.xdut.xspi.xr23.xm.xmp2.m0[id] from=0.25u to=0.5u
meas tran i526 avg @m.xdut.xspi.xr23.xmf.xmn.m0[id] from=0.25u to=0.5u
meas tran i527 avg @m.xdut.xspi.xr23.xmf.xmp.m0[id] from=0.25u to=0.5u
meas tran i528 avg @m.xdut.xspi.xr23.xt2n.m0[id] from=0.25u to=0.5u
meas tran i529 avg @m.xdut.xspi.xr23.xt2p.m0[id] from=0.25u to=0.5u
meas tran i530 avg @m.xdut.xspi.xr23.xt3n.m0[id] from=0.25u to=0.5u
meas tran i531 avg @m.xdut.xspi.xr23.xt3p.m0[id] from=0.25u to=0.5u
meas tran i532 avg @m.xdut.xspi.xr23.xs.xmn1.m0[id] from=0.25u to=0.5u
meas tran i533 avg @m.xdut.xspi.xr23.xs.xmn2.m0[id] from=0.25u to=0.5u
meas tran i534 avg @m.xdut.xspi.xr23.xs.xmp1.m0[id] from=0.25u to=0.5u
meas tran i535 avg @m.xdut.xspi.xr23.xs.xmp2.m0[id] from=0.25u to=0.5u
meas tran i536 avg @m.xdut.xspi.xr23.xsf.xmn.m0[id] from=0.25u to=0.5u
meas tran i537 avg @m.xdut.xspi.xr23.xsf.xmp.m0[id] from=0.25u to=0.5u
meas tran i538 avg @m.xdut.xspi.xr23.xt4n.m0[id] from=0.25u to=0.5u
meas tran i539 avg @m.xdut.xspi.xr23.xt4p.m0[id] from=0.25u to=0.5u
meas tran i540 avg @m.xdut.xspi.xl0.xei.xmn.m0[id] from=0.25u to=0.5u
meas tran i541 avg @m.xdut.xspi.xl0.xei.xmp.m0[id] from=0.25u to=0.5u
meas tran i542 avg @m.xdut.xspi.xl0.xtin.m0[id] from=0.25u to=0.5u
meas tran i543 avg @m.xdut.xspi.xl0.xtip.m0[id] from=0.25u to=0.5u
meas tran i544 avg @m.xdut.xspi.xl0.x1.xmn.m0[id] from=0.25u to=0.5u
meas tran i545 avg @m.xdut.xspi.xl0.x1.xmp.m0[id] from=0.25u to=0.5u
meas tran i546 avg @m.xdut.xspi.xl0.x2.xmn.m0[id] from=0.25u to=0.5u
meas tran i547 avg @m.xdut.xspi.xl0.x2.xmp.m0[id] from=0.25u to=0.5u
meas tran i548 avg @m.xdut.xspi.xl0.xtfn.m0[id] from=0.25u to=0.5u
meas tran i549 avg @m.xdut.xspi.xl0.xtfp.m0[id] from=0.25u to=0.5u
meas tran i550 avg @m.xdut.xspi.xl1.xei.xmn.m0[id] from=0.25u to=0.5u
meas tran i551 avg @m.xdut.xspi.xl1.xei.xmp.m0[id] from=0.25u to=0.5u
meas tran i552 avg @m.xdut.xspi.xl1.xtin.m0[id] from=0.25u to=0.5u
meas tran i553 avg @m.xdut.xspi.xl1.xtip.m0[id] from=0.25u to=0.5u
meas tran i554 avg @m.xdut.xspi.xl1.x1.xmn.m0[id] from=0.25u to=0.5u
meas tran i555 avg @m.xdut.xspi.xl1.x1.xmp.m0[id] from=0.25u to=0.5u
meas tran i556 avg @m.xdut.xspi.xl1.x2.xmn.m0[id] from=0.25u to=0.5u
meas tran i557 avg @m.xdut.xspi.xl1.x2.xmp.m0[id] from=0.25u to=0.5u
meas tran i558 avg @m.xdut.xspi.xl1.xtfn.m0[id] from=0.25u to=0.5u
meas tran i559 avg @m.xdut.xspi.xl1.xtfp.m0[id] from=0.25u to=0.5u
meas tran i560 avg @m.xdut.xspi.xl2.xei.xmn.m0[id] from=0.25u to=0.5u
meas tran i561 avg @m.xdut.xspi.xl2.xei.xmp.m0[id] from=0.25u to=0.5u
meas tran i562 avg @m.xdut.xspi.xl2.xtin.m0[id] from=0.25u to=0.5u
meas tran i563 avg @m.xdut.xspi.xl2.xtip.m0[id] from=0.25u to=0.5u
meas tran i564 avg @m.xdut.xspi.xl2.x1.xmn.m0[id] from=0.25u to=0.5u
meas tran i565 avg @m.xdut.xspi.xl2.x1.xmp.m0[id] from=0.25u to=0.5u
meas tran i566 avg @m.xdut.xspi.xl2.x2.xmn.m0[id] from=0.25u to=0.5u
meas tran i567 avg @m.xdut.xspi.xl2.x2.xmp.m0[id] from=0.25u to=0.5u
meas tran i568 avg @m.xdut.xspi.xl2.xtfn.m0[id] from=0.25u to=0.5u
meas tran i569 avg @m.xdut.xspi.xl2.xtfp.m0[id] from=0.25u to=0.5u
meas tran i570 avg @m.xdut.xspi.xl3.xei.xmn.m0[id] from=0.25u to=0.5u
meas tran i571 avg @m.xdut.xspi.xl3.xei.xmp.m0[id] from=0.25u to=0.5u
meas tran i572 avg @m.xdut.xspi.xl3.xtin.m0[id] from=0.25u to=0.5u
meas tran i573 avg @m.xdut.xspi.xl3.xtip.m0[id] from=0.25u to=0.5u
meas tran i574 avg @m.xdut.xspi.xl3.x1.xmn.m0[id] from=0.25u to=0.5u
meas tran i575 avg @m.xdut.xspi.xl3.x1.xmp.m0[id] from=0.25u to=0.5u
meas tran i576 avg @m.xdut.xspi.xl3.x2.xmn.m0[id] from=0.25u to=0.5u
meas tran i577 avg @m.xdut.xspi.xl3.x2.xmp.m0[id] from=0.25u to=0.5u
meas tran i578 avg @m.xdut.xspi.xl3.xtfn.m0[id] from=0.25u to=0.5u
meas tran i579 avg @m.xdut.xspi.xl3.xtfp.m0[id] from=0.25u to=0.5u
meas tran i580 avg @m.xdut.xspi.xl4.xei.xmn.m0[id] from=0.25u to=0.5u
meas tran i581 avg @m.xdut.xspi.xl4.xei.xmp.m0[id] from=0.25u to=0.5u
meas tran i582 avg @m.xdut.xspi.xl4.xtin.m0[id] from=0.25u to=0.5u
meas tran i583 avg @m.xdut.xspi.xl4.xtip.m0[id] from=0.25u to=0.5u
meas tran i584 avg @m.xdut.xspi.xl4.x1.xmn.m0[id] from=0.25u to=0.5u
meas tran i585 avg @m.xdut.xspi.xl4.x1.xmp.m0[id] from=0.25u to=0.5u
meas tran i586 avg @m.xdut.xspi.xl4.x2.xmn.m0[id] from=0.25u to=0.5u
meas tran i587 avg @m.xdut.xspi.xl4.x2.xmp.m0[id] from=0.25u to=0.5u
meas tran i588 avg @m.xdut.xspi.xl4.xtfn.m0[id] from=0.25u to=0.5u
meas tran i589 avg @m.xdut.xspi.xl4.xtfp.m0[id] from=0.25u to=0.5u
meas tran i590 avg @m.xdut.xspi.xl5.xei.xmn.m0[id] from=0.25u to=0.5u
meas tran i591 avg @m.xdut.xspi.xl5.xei.xmp.m0[id] from=0.25u to=0.5u
meas tran i592 avg @m.xdut.xspi.xl5.xtin.m0[id] from=0.25u to=0.5u
meas tran i593 avg @m.xdut.xspi.xl5.xtip.m0[id] from=0.25u to=0.5u
meas tran i594 avg @m.xdut.xspi.xl5.x1.xmn.m0[id] from=0.25u to=0.5u
meas tran i595 avg @m.xdut.xspi.xl5.x1.xmp.m0[id] from=0.25u to=0.5u
meas tran i596 avg @m.xdut.xspi.xl5.x2.xmn.m0[id] from=0.25u to=0.5u
meas tran i597 avg @m.xdut.xspi.xl5.x2.xmp.m0[id] from=0.25u to=0.5u
meas tran i598 avg @m.xdut.xspi.xl5.xtfn.m0[id] from=0.25u to=0.5u
meas tran i599 avg @m.xdut.xspi.xl5.xtfp.m0[id] from=0.25u to=0.5u
meas tran i600 avg @m.xdut.xspi.xl6.xei.xmn.m0[id] from=0.25u to=0.5u
meas tran i601 avg @m.xdut.xspi.xl6.xei.xmp.m0[id] from=0.25u to=0.5u
meas tran i602 avg @m.xdut.xspi.xl6.xtin.m0[id] from=0.25u to=0.5u
meas tran i603 avg @m.xdut.xspi.xl6.xtip.m0[id] from=0.25u to=0.5u
meas tran i604 avg @m.xdut.xspi.xl6.x1.xmn.m0[id] from=0.25u to=0.5u
meas tran i605 avg @m.xdut.xspi.xl6.x1.xmp.m0[id] from=0.25u to=0.5u
meas tran i606 avg @m.xdut.xspi.xl6.x2.xmn.m0[id] from=0.25u to=0.5u
meas tran i607 avg @m.xdut.xspi.xl6.x2.xmp.m0[id] from=0.25u to=0.5u
meas tran i608 avg @m.xdut.xspi.xl6.xtfn.m0[id] from=0.25u to=0.5u
meas tran i609 avg @m.xdut.xspi.xl6.xtfp.m0[id] from=0.25u to=0.5u
meas tran i610 avg @m.xdut.xspi.xl7.xei.xmn.m0[id] from=0.25u to=0.5u
meas tran i611 avg @m.xdut.xspi.xl7.xei.xmp.m0[id] from=0.25u to=0.5u
meas tran i612 avg @m.xdut.xspi.xl7.xtin.m0[id] from=0.25u to=0.5u
meas tran i613 avg @m.xdut.xspi.xl7.xtip.m0[id] from=0.25u to=0.5u
meas tran i614 avg @m.xdut.xspi.xl7.x1.xmn.m0[id] from=0.25u to=0.5u
meas tran i615 avg @m.xdut.xspi.xl7.x1.xmp.m0[id] from=0.25u to=0.5u
meas tran i616 avg @m.xdut.xspi.xl7.x2.xmn.m0[id] from=0.25u to=0.5u
meas tran i617 avg @m.xdut.xspi.xl7.x2.xmp.m0[id] from=0.25u to=0.5u
meas tran i618 avg @m.xdut.xspi.xl7.xtfn.m0[id] from=0.25u to=0.5u
meas tran i619 avg @m.xdut.xspi.xl7.xtfp.m0[id] from=0.25u to=0.5u
meas tran i620 avg @m.xdut.xspi.xl8.xei.xmn.m0[id] from=0.25u to=0.5u
meas tran i621 avg @m.xdut.xspi.xl8.xei.xmp.m0[id] from=0.25u to=0.5u
meas tran i622 avg @m.xdut.xspi.xl8.xtin.m0[id] from=0.25u to=0.5u
meas tran i623 avg @m.xdut.xspi.xl8.xtip.m0[id] from=0.25u to=0.5u
meas tran i624 avg @m.xdut.xspi.xl8.x1.xmn.m0[id] from=0.25u to=0.5u
meas tran i625 avg @m.xdut.xspi.xl8.x1.xmp.m0[id] from=0.25u to=0.5u
meas tran i626 avg @m.xdut.xspi.xl8.x2.xmn.m0[id] from=0.25u to=0.5u
meas tran i627 avg @m.xdut.xspi.xl8.x2.xmp.m0[id] from=0.25u to=0.5u
meas tran i628 avg @m.xdut.xspi.xl8.xtfn.m0[id] from=0.25u to=0.5u
meas tran i629 avg @m.xdut.xspi.xl8.xtfp.m0[id] from=0.25u to=0.5u
meas tran i630 avg @m.xdut.xspi.xl9.xei.xmn.m0[id] from=0.25u to=0.5u
meas tran i631 avg @m.xdut.xspi.xl9.xei.xmp.m0[id] from=0.25u to=0.5u
meas tran i632 avg @m.xdut.xspi.xl9.xtin.m0[id] from=0.25u to=0.5u
meas tran i633 avg @m.xdut.xspi.xl9.xtip.m0[id] from=0.25u to=0.5u
meas tran i634 avg @m.xdut.xspi.xl9.x1.xmn.m0[id] from=0.25u to=0.5u
meas tran i635 avg @m.xdut.xspi.xl9.x1.xmp.m0[id] from=0.25u to=0.5u
meas tran i636 avg @m.xdut.xspi.xl9.x2.xmn.m0[id] from=0.25u to=0.5u
meas tran i637 avg @m.xdut.xspi.xl9.x2.xmp.m0[id] from=0.25u to=0.5u
meas tran i638 avg @m.xdut.xspi.xl9.xtfn.m0[id] from=0.25u to=0.5u
meas tran i639 avg @m.xdut.xspi.xl9.xtfp.m0[id] from=0.25u to=0.5u
meas tran i640 avg @m.xdut.xspi.xl10.xei.xmn.m0[id] from=0.25u to=0.5u
meas tran i641 avg @m.xdut.xspi.xl10.xei.xmp.m0[id] from=0.25u to=0.5u
meas tran i642 avg @m.xdut.xspi.xl10.xtin.m0[id] from=0.25u to=0.5u
meas tran i643 avg @m.xdut.xspi.xl10.xtip.m0[id] from=0.25u to=0.5u
meas tran i644 avg @m.xdut.xspi.xl10.x1.xmn.m0[id] from=0.25u to=0.5u
meas tran i645 avg @m.xdut.xspi.xl10.x1.xmp.m0[id] from=0.25u to=0.5u
meas tran i646 avg @m.xdut.xspi.xl10.x2.xmn.m0[id] from=0.25u to=0.5u
meas tran i647 avg @m.xdut.xspi.xl10.x2.xmp.m0[id] from=0.25u to=0.5u
meas tran i648 avg @m.xdut.xspi.xl10.xtfn.m0[id] from=0.25u to=0.5u
meas tran i649 avg @m.xdut.xspi.xl10.xtfp.m0[id] from=0.25u to=0.5u
meas tran i650 avg @m.xdut.xspi.xl11.xei.xmn.m0[id] from=0.25u to=0.5u
meas tran i651 avg @m.xdut.xspi.xl11.xei.xmp.m0[id] from=0.25u to=0.5u
meas tran i652 avg @m.xdut.xspi.xl11.xtin.m0[id] from=0.25u to=0.5u
meas tran i653 avg @m.xdut.xspi.xl11.xtip.m0[id] from=0.25u to=0.5u
meas tran i654 avg @m.xdut.xspi.xl11.x1.xmn.m0[id] from=0.25u to=0.5u
meas tran i655 avg @m.xdut.xspi.xl11.x1.xmp.m0[id] from=0.25u to=0.5u
meas tran i656 avg @m.xdut.xspi.xl11.x2.xmn.m0[id] from=0.25u to=0.5u
meas tran i657 avg @m.xdut.xspi.xl11.x2.xmp.m0[id] from=0.25u to=0.5u
meas tran i658 avg @m.xdut.xspi.xl11.xtfn.m0[id] from=0.25u to=0.5u
meas tran i659 avg @m.xdut.xspi.xl11.xtfp.m0[id] from=0.25u to=0.5u
meas tran i660 avg @m.xdut.xspi.xl12.xei.xmn.m0[id] from=0.25u to=0.5u
meas tran i661 avg @m.xdut.xspi.xl12.xei.xmp.m0[id] from=0.25u to=0.5u
meas tran i662 avg @m.xdut.xspi.xl12.xtin.m0[id] from=0.25u to=0.5u
meas tran i663 avg @m.xdut.xspi.xl12.xtip.m0[id] from=0.25u to=0.5u
meas tran i664 avg @m.xdut.xspi.xl12.x1.xmn.m0[id] from=0.25u to=0.5u
meas tran i665 avg @m.xdut.xspi.xl12.x1.xmp.m0[id] from=0.25u to=0.5u
meas tran i666 avg @m.xdut.xspi.xl12.x2.xmn.m0[id] from=0.25u to=0.5u
meas tran i667 avg @m.xdut.xspi.xl12.x2.xmp.m0[id] from=0.25u to=0.5u
meas tran i668 avg @m.xdut.xspi.xl12.xtfn.m0[id] from=0.25u to=0.5u
meas tran i669 avg @m.xdut.xspi.xl12.xtfp.m0[id] from=0.25u to=0.5u
meas tran i670 avg @m.xdut.xspi.xl13.xei.xmn.m0[id] from=0.25u to=0.5u
meas tran i671 avg @m.xdut.xspi.xl13.xei.xmp.m0[id] from=0.25u to=0.5u
meas tran i672 avg @m.xdut.xspi.xl13.xtin.m0[id] from=0.25u to=0.5u
meas tran i673 avg @m.xdut.xspi.xl13.xtip.m0[id] from=0.25u to=0.5u
meas tran i674 avg @m.xdut.xspi.xl13.x1.xmn.m0[id] from=0.25u to=0.5u
meas tran i675 avg @m.xdut.xspi.xl13.x1.xmp.m0[id] from=0.25u to=0.5u
meas tran i676 avg @m.xdut.xspi.xl13.x2.xmn.m0[id] from=0.25u to=0.5u
meas tran i677 avg @m.xdut.xspi.xl13.x2.xmp.m0[id] from=0.25u to=0.5u
meas tran i678 avg @m.xdut.xspi.xl13.xtfn.m0[id] from=0.25u to=0.5u
meas tran i679 avg @m.xdut.xspi.xl13.xtfp.m0[id] from=0.25u to=0.5u
meas tran i680 avg @m.xdut.xspi.xl14.xei.xmn.m0[id] from=0.25u to=0.5u
meas tran i681 avg @m.xdut.xspi.xl14.xei.xmp.m0[id] from=0.25u to=0.5u
meas tran i682 avg @m.xdut.xspi.xl14.xtin.m0[id] from=0.25u to=0.5u
meas tran i683 avg @m.xdut.xspi.xl14.xtip.m0[id] from=0.25u to=0.5u
meas tran i684 avg @m.xdut.xspi.xl14.x1.xmn.m0[id] from=0.25u to=0.5u
meas tran i685 avg @m.xdut.xspi.xl14.x1.xmp.m0[id] from=0.25u to=0.5u
meas tran i686 avg @m.xdut.xspi.xl14.x2.xmn.m0[id] from=0.25u to=0.5u
meas tran i687 avg @m.xdut.xspi.xl14.x2.xmp.m0[id] from=0.25u to=0.5u
meas tran i688 avg @m.xdut.xspi.xl14.xtfn.m0[id] from=0.25u to=0.5u
meas tran i689 avg @m.xdut.xspi.xl14.xtfp.m0[id] from=0.25u to=0.5u
meas tran i690 avg @m.xdut.xspi.xl15.xei.xmn.m0[id] from=0.25u to=0.5u
meas tran i691 avg @m.xdut.xspi.xl15.xei.xmp.m0[id] from=0.25u to=0.5u
meas tran i692 avg @m.xdut.xspi.xl15.xtin.m0[id] from=0.25u to=0.5u
meas tran i693 avg @m.xdut.xspi.xl15.xtip.m0[id] from=0.25u to=0.5u
meas tran i694 avg @m.xdut.xspi.xl15.x1.xmn.m0[id] from=0.25u to=0.5u
meas tran i695 avg @m.xdut.xspi.xl15.x1.xmp.m0[id] from=0.25u to=0.5u
meas tran i696 avg @m.xdut.xspi.xl15.x2.xmn.m0[id] from=0.25u to=0.5u
meas tran i697 avg @m.xdut.xspi.xl15.x2.xmp.m0[id] from=0.25u to=0.5u
meas tran i698 avg @m.xdut.xspi.xl15.xtfn.m0[id] from=0.25u to=0.5u
meas tran i699 avg @m.xdut.xspi.xl15.xtfp.m0[id] from=0.25u to=0.5u
meas tran i700 avg @m.xdut.xspi.xafc7.xmn.m0[id] from=0.25u to=0.5u
meas tran i701 avg @m.xdut.xspi.xafc7.xmp.m0[id] from=0.25u to=0.5u
meas tran i702 avg @m.xdut.xspi.xl16.xei.xmn.m0[id] from=0.25u to=0.5u
meas tran i703 avg @m.xdut.xspi.xl16.xei.xmp.m0[id] from=0.25u to=0.5u
meas tran i704 avg @m.xdut.xspi.xl16.xtin.m0[id] from=0.25u to=0.5u
meas tran i705 avg @m.xdut.xspi.xl16.xtip.m0[id] from=0.25u to=0.5u
meas tran i706 avg @m.xdut.xspi.xl16.x1.xmn.m0[id] from=0.25u to=0.5u
meas tran i707 avg @m.xdut.xspi.xl16.x1.xmp.m0[id] from=0.25u to=0.5u
meas tran i708 avg @m.xdut.xspi.xl16.x2.xmn.m0[id] from=0.25u to=0.5u
meas tran i709 avg @m.xdut.xspi.xl16.x2.xmp.m0[id] from=0.25u to=0.5u
meas tran i710 avg @m.xdut.xspi.xl16.xtfn.m0[id] from=0.25u to=0.5u
meas tran i711 avg @m.xdut.xspi.xl16.xtfp.m0[id] from=0.25u to=0.5u
meas tran i712 avg @m.xdut.xbias.xmn1.m0[id] from=0.25u to=0.5u
meas tran i713 avg @m.xdut.xbias.xmn2.m0[id] from=0.25u to=0.5u
meas tran i714 avg @m.xdut.xbias.xmp1.m0[id] from=0.25u to=0.5u
meas tran i715 avg @m.xdut.xbias.xmp2.m0[id] from=0.25u to=0.5u
meas tran i716 avg @m.xdut.xbias.xmsp.m0[id] from=0.25u to=0.5u
meas tran i717 avg @m.xdut.xbias.xmsn.m0[id] from=0.25u to=0.5u
meas tran i718 avg @m.xdut.xbias.xmsu.m0[id] from=0.25u to=0.5u
meas tran i719 avg @m.xdut.xbias.xmp3.m0[id] from=0.25u to=0.5u
meas tran i720 avg @m.xdut.xbias.xmn3.m0[id] from=0.25u to=0.5u
meas tran i721 avg @m.xdut.xbias.xmn4.m0[id] from=0.25u to=0.5u
meas tran i722 avg @m.xdut.xbias.xmp4.m0[id] from=0.25u to=0.5u
meas tran i723 avg @m.xdut.xvco.xmvi.m0[id] from=0.25u to=0.5u
meas tran i724 avg @m.xdut.xvco.xmpd.m0[id] from=0.25u to=0.5u
meas tran i725 avg @m.xdut.xvco.xmpo.m0[id] from=0.25u to=0.5u
meas tran i726 avg @m.xdut.xvco.xmmin.m0[id] from=0.25u to=0.5u
meas tran i727 avg @m.xdut.xvco.xb0.xmn.m0[id] from=0.25u to=0.5u
meas tran i728 avg @m.xdut.xvco.xb0.xmp.m0[id] from=0.25u to=0.5u
meas tran i729 avg @m.xdut.xvco.xb1.xmn.m0[id] from=0.25u to=0.5u
meas tran i730 avg @m.xdut.xvco.xb1.xmp.m0[id] from=0.25u to=0.5u
meas tran i731 avg @m.xdut.xvco.xmpb0.m0[id] from=0.25u to=0.5u
meas tran i732 avg @m.xdut.xvco.xmsb0.m0[id] from=0.25u to=0.5u
meas tran i733 avg @m.xdut.xvco.xmpb1.m0[id] from=0.25u to=0.5u
meas tran i734 avg @m.xdut.xvco.xmsb1.m0[id] from=0.25u to=0.5u
meas tran i735 avg @m.xdut.xvco.xcore.xmna1.m0[id] from=0.25u to=0.5u
meas tran i736 avg @m.xdut.xvco.xcore.xmnb1.m0[id] from=0.25u to=0.5u
meas tran i737 avg @m.xdut.xvco.xcore.xmpa1.m0[id] from=0.25u to=0.5u
meas tran i738 avg @m.xdut.xvco.xcore.xmpb1.m0[id] from=0.25u to=0.5u
meas tran i739 avg @m.xdut.xvco.xcore.xmnc1.m0[id] from=0.25u to=0.5u
meas tran i740 avg @m.xdut.xvco.xcore.xmnd1.m0[id] from=0.25u to=0.5u
meas tran i741 avg @m.xdut.xvco.xcore.xmpc1.m0[id] from=0.25u to=0.5u
meas tran i742 avg @m.xdut.xvco.xcore.xmpd1.m0[id] from=0.25u to=0.5u
meas tran i743 avg @m.xdut.xvco.xcore.xmna2.m0[id] from=0.25u to=0.5u
meas tran i744 avg @m.xdut.xvco.xcore.xmnb2.m0[id] from=0.25u to=0.5u
meas tran i745 avg @m.xdut.xvco.xcore.xmpa2.m0[id] from=0.25u to=0.5u
meas tran i746 avg @m.xdut.xvco.xcore.xmpb2.m0[id] from=0.25u to=0.5u
meas tran i747 avg @m.xdut.xvco.xcore.xmnc2.m0[id] from=0.25u to=0.5u
meas tran i748 avg @m.xdut.xvco.xcore.xmnd2.m0[id] from=0.25u to=0.5u
meas tran i749 avg @m.xdut.xvco.xcore.xmpc2.m0[id] from=0.25u to=0.5u
meas tran i750 avg @m.xdut.xvco.xcore.xmpd2.m0[id] from=0.25u to=0.5u
meas tran i751 avg @m.xdut.xvco.xcore.xmna3.m0[id] from=0.25u to=0.5u
meas tran i752 avg @m.xdut.xvco.xcore.xmnb3.m0[id] from=0.25u to=0.5u
meas tran i753 avg @m.xdut.xvco.xcore.xmpa3.m0[id] from=0.25u to=0.5u
meas tran i754 avg @m.xdut.xvco.xcore.xmpb3.m0[id] from=0.25u to=0.5u
meas tran i755 avg @m.xdut.xvco.xcore.xmnc3.m0[id] from=0.25u to=0.5u
meas tran i756 avg @m.xdut.xvco.xcore.xmnd3.m0[id] from=0.25u to=0.5u
meas tran i757 avg @m.xdut.xvco.xcore.xmpc3.m0[id] from=0.25u to=0.5u
meas tran i758 avg @m.xdut.xvco.xcore.xmpd3.m0[id] from=0.25u to=0.5u
meas tran i759 avg @m.xdut.xvco.xcore.xmna4.m0[id] from=0.25u to=0.5u
meas tran i760 avg @m.xdut.xvco.xcore.xmnb4.m0[id] from=0.25u to=0.5u
meas tran i761 avg @m.xdut.xvco.xcore.xmpa4.m0[id] from=0.25u to=0.5u
meas tran i762 avg @m.xdut.xvco.xcore.xmpb4.m0[id] from=0.25u to=0.5u
meas tran i763 avg @m.xdut.xvco.xcore.xmnc4.m0[id] from=0.25u to=0.5u
meas tran i764 avg @m.xdut.xvco.xcore.xmnd4.m0[id] from=0.25u to=0.5u
meas tran i765 avg @m.xdut.xvco.xcore.xmpc4.m0[id] from=0.25u to=0.5u
meas tran i766 avg @m.xdut.xvco.xcore.xmpd4.m0[id] from=0.25u to=0.5u
meas tran i767 avg @m.xdut.xvco.xcore.xmbnp1.m0[id] from=0.25u to=0.5u
meas tran i768 avg @m.xdut.xvco.xcore.xmbpp1.m0[id] from=0.25u to=0.5u
meas tran i769 avg @m.xdut.xvco.xcore.xmdnp1.m0[id] from=0.25u to=0.5u
meas tran i770 avg @m.xdut.xvco.xcore.xmdpp1.m0[id] from=0.25u to=0.5u
meas tran i771 avg @m.xdut.xvco.xcore.xmcnp1.m0[id] from=0.25u to=0.5u
meas tran i772 avg @m.xdut.xvco.xcore.xmcpp1.m0[id] from=0.25u to=0.5u
meas tran i773 avg @m.xdut.xvco.xcore.xmbnn1.m0[id] from=0.25u to=0.5u
meas tran i774 avg @m.xdut.xvco.xcore.xmbpn1.m0[id] from=0.25u to=0.5u
meas tran i775 avg @m.xdut.xvco.xcore.xmdnn1.m0[id] from=0.25u to=0.5u
meas tran i776 avg @m.xdut.xvco.xcore.xmdpn1.m0[id] from=0.25u to=0.5u
meas tran i777 avg @m.xdut.xvco.xcore.xmcnn1.m0[id] from=0.25u to=0.5u
meas tran i778 avg @m.xdut.xvco.xcore.xmcpn1.m0[id] from=0.25u to=0.5u
meas tran i779 avg @m.xdut.xvco.xcore.xmbnp2.m0[id] from=0.25u to=0.5u
meas tran i780 avg @m.xdut.xvco.xcore.xmbpp2.m0[id] from=0.25u to=0.5u
meas tran i781 avg @m.xdut.xvco.xcore.xmdnp2.m0[id] from=0.25u to=0.5u
meas tran i782 avg @m.xdut.xvco.xcore.xmdpp2.m0[id] from=0.25u to=0.5u
meas tran i783 avg @m.xdut.xvco.xcore.xmcnp2.m0[id] from=0.25u to=0.5u
meas tran i784 avg @m.xdut.xvco.xcore.xmcpp2.m0[id] from=0.25u to=0.5u
meas tran i785 avg @m.xdut.xvco.xcore.xmbnn2.m0[id] from=0.25u to=0.5u
meas tran i786 avg @m.xdut.xvco.xcore.xmbpn2.m0[id] from=0.25u to=0.5u
meas tran i787 avg @m.xdut.xvco.xcore.xmdnn2.m0[id] from=0.25u to=0.5u
meas tran i788 avg @m.xdut.xvco.xcore.xmdpn2.m0[id] from=0.25u to=0.5u
meas tran i789 avg @m.xdut.xvco.xcore.xmcnn2.m0[id] from=0.25u to=0.5u
meas tran i790 avg @m.xdut.xvco.xcore.xmcpn2.m0[id] from=0.25u to=0.5u
meas tran i791 avg @m.xdut.xvco.xcore.xmbnp3.m0[id] from=0.25u to=0.5u
meas tran i792 avg @m.xdut.xvco.xcore.xmbpp3.m0[id] from=0.25u to=0.5u
meas tran i793 avg @m.xdut.xvco.xcore.xmdnp3.m0[id] from=0.25u to=0.5u
meas tran i794 avg @m.xdut.xvco.xcore.xmdpp3.m0[id] from=0.25u to=0.5u
meas tran i795 avg @m.xdut.xvco.xcore.xmcnp3.m0[id] from=0.25u to=0.5u
meas tran i796 avg @m.xdut.xvco.xcore.xmcpp3.m0[id] from=0.25u to=0.5u
meas tran i797 avg @m.xdut.xvco.xcore.xmbnn3.m0[id] from=0.25u to=0.5u
meas tran i798 avg @m.xdut.xvco.xcore.xmbpn3.m0[id] from=0.25u to=0.5u
meas tran i799 avg @m.xdut.xvco.xcore.xmdnn3.m0[id] from=0.25u to=0.5u
meas tran i800 avg @m.xdut.xvco.xcore.xmdpn3.m0[id] from=0.25u to=0.5u
meas tran i801 avg @m.xdut.xvco.xcore.xmcnn3.m0[id] from=0.25u to=0.5u
meas tran i802 avg @m.xdut.xvco.xcore.xmcpn3.m0[id] from=0.25u to=0.5u
meas tran i803 avg @m.xdut.xvco.xcore.xmbnp4.m0[id] from=0.25u to=0.5u
meas tran i804 avg @m.xdut.xvco.xcore.xmbpp4.m0[id] from=0.25u to=0.5u
meas tran i805 avg @m.xdut.xvco.xcore.xmdnp4.m0[id] from=0.25u to=0.5u
meas tran i806 avg @m.xdut.xvco.xcore.xmdpp4.m0[id] from=0.25u to=0.5u
meas tran i807 avg @m.xdut.xvco.xcore.xmcnp4.m0[id] from=0.25u to=0.5u
meas tran i808 avg @m.xdut.xvco.xcore.xmcpp4.m0[id] from=0.25u to=0.5u
meas tran i809 avg @m.xdut.xvco.xcore.xmbnn4.m0[id] from=0.25u to=0.5u
meas tran i810 avg @m.xdut.xvco.xcore.xmbpn4.m0[id] from=0.25u to=0.5u
meas tran i811 avg @m.xdut.xvco.xcore.xmdnn4.m0[id] from=0.25u to=0.5u
meas tran i812 avg @m.xdut.xvco.xcore.xmdpn4.m0[id] from=0.25u to=0.5u
meas tran i813 avg @m.xdut.xvco.xcore.xmcnn4.m0[id] from=0.25u to=0.5u
meas tran i814 avg @m.xdut.xvco.xcore.xmcpn4.m0[id] from=0.25u to=0.5u
meas tran i815 avg @m.xdut.xvco.xcore.xmk1.m0[id] from=0.25u to=0.5u
meas tran i816 avg @m.xdut.xvco.xcore.xmkd1.m0[id] from=0.25u to=0.5u
meas tran i817 avg @m.xdut.xvco.xcore.xmk2.m0[id] from=0.25u to=0.5u
meas tran i818 avg @m.xdut.xvco.xcore.xmkd2.m0[id] from=0.25u to=0.5u
meas tran i819 avg @m.xdut.xvco.xcore.xmk3.m0[id] from=0.25u to=0.5u
meas tran i820 avg @m.xdut.xvco.xcore.xmkd3.m0[id] from=0.25u to=0.5u
meas tran i821 avg @m.xdut.xvco.xcore.xmk4.m0[id] from=0.25u to=0.5u
meas tran i822 avg @m.xdut.xvco.xcore.xmkd4.m0[id] from=0.25u to=0.5u
meas tran i823 avg @m.xdut.xvco.xsua.xmn1.m0[id] from=0.25u to=0.5u
meas tran i824 avg @m.xdut.xvco.xsua.xmn2.m0[id] from=0.25u to=0.5u
meas tran i825 avg @m.xdut.xvco.xsua.xmp1.m0[id] from=0.25u to=0.5u
meas tran i826 avg @m.xdut.xvco.xsua.xmp2.m0[id] from=0.25u to=0.5u
meas tran i827 avg @m.xdut.xvco.xsub.xmn1.m0[id] from=0.25u to=0.5u
meas tran i828 avg @m.xdut.xvco.xsub.xmn2.m0[id] from=0.25u to=0.5u
meas tran i829 avg @m.xdut.xvco.xsub.xmp1.m0[id] from=0.25u to=0.5u
meas tran i830 avg @m.xdut.xvco.xsub.xmp2.m0[id] from=0.25u to=0.5u
meas tran i831 avg @m.xdut.xvco.xsuad1.xmn1.m0[id] from=0.25u to=0.5u
meas tran i832 avg @m.xdut.xvco.xsuad1.xmn2.m0[id] from=0.25u to=0.5u
meas tran i833 avg @m.xdut.xvco.xsuad1.xmp1.m0[id] from=0.25u to=0.5u
meas tran i834 avg @m.xdut.xvco.xsuad1.xmp2.m0[id] from=0.25u to=0.5u
meas tran i835 avg @m.xdut.xvco.xsubd1.xmn1.m0[id] from=0.25u to=0.5u
meas tran i836 avg @m.xdut.xvco.xsubd1.xmn2.m0[id] from=0.25u to=0.5u
meas tran i837 avg @m.xdut.xvco.xsubd1.xmp1.m0[id] from=0.25u to=0.5u
meas tran i838 avg @m.xdut.xvco.xsubd1.xmp2.m0[id] from=0.25u to=0.5u
meas tran i839 avg @m.xdut.xvco.xsuad3.xmn1.m0[id] from=0.25u to=0.5u
meas tran i840 avg @m.xdut.xvco.xsuad3.xmn2.m0[id] from=0.25u to=0.5u
meas tran i841 avg @m.xdut.xvco.xsuad3.xmp1.m0[id] from=0.25u to=0.5u
meas tran i842 avg @m.xdut.xvco.xsuad3.xmp2.m0[id] from=0.25u to=0.5u
meas tran i843 avg @m.xdut.xvco.xsubd3.xmn1.m0[id] from=0.25u to=0.5u
meas tran i844 avg @m.xdut.xvco.xsubd3.xmn2.m0[id] from=0.25u to=0.5u
meas tran i845 avg @m.xdut.xvco.xsubd3.xmp1.m0[id] from=0.25u to=0.5u
meas tran i846 avg @m.xdut.xvco.xsubd3.xmp2.m0[id] from=0.25u to=0.5u
meas tran i847 avg @m.xdut.xvco.xsuad4.xmn1.m0[id] from=0.25u to=0.5u
meas tran i848 avg @m.xdut.xvco.xsuad4.xmn2.m0[id] from=0.25u to=0.5u
meas tran i849 avg @m.xdut.xvco.xsuad4.xmp1.m0[id] from=0.25u to=0.5u
meas tran i850 avg @m.xdut.xvco.xsuad4.xmp2.m0[id] from=0.25u to=0.5u
meas tran i851 avg @m.xdut.xvco.xsubd4.xmn1.m0[id] from=0.25u to=0.5u
meas tran i852 avg @m.xdut.xvco.xsubd4.xmn2.m0[id] from=0.25u to=0.5u
meas tran i853 avg @m.xdut.xvco.xsubd4.xmp1.m0[id] from=0.25u to=0.5u
meas tran i854 avg @m.xdut.xvco.xsubd4.xmp2.m0[id] from=0.25u to=0.5u
meas tran i855 avg @m.xdut.xvco.xsua1.xmn1.m0[id] from=0.25u to=0.5u
meas tran i856 avg @m.xdut.xvco.xsua1.xmn2.m0[id] from=0.25u to=0.5u
meas tran i857 avg @m.xdut.xvco.xsua1.xmp1.m0[id] from=0.25u to=0.5u
meas tran i858 avg @m.xdut.xvco.xsua1.xmp2.m0[id] from=0.25u to=0.5u
meas tran i859 avg @m.xdut.xvco.xsua2.xmn.m0[id] from=0.25u to=0.5u
meas tran i860 avg @m.xdut.xvco.xsua2.xmp.m0[id] from=0.25u to=0.5u
meas tran i861 avg @m.xdut.xvco.xsub1.xmn1.m0[id] from=0.25u to=0.5u
meas tran i862 avg @m.xdut.xvco.xsub1.xmn2.m0[id] from=0.25u to=0.5u
meas tran i863 avg @m.xdut.xvco.xsub1.xmp1.m0[id] from=0.25u to=0.5u
meas tran i864 avg @m.xdut.xvco.xsub1.xmp2.m0[id] from=0.25u to=0.5u
meas tran i865 avg @m.xdut.xvco.xsub2.xmn.m0[id] from=0.25u to=0.5u
meas tran i866 avg @m.xdut.xvco.xsub2.xmp.m0[id] from=0.25u to=0.5u
meas tran i867 avg @m.xdut.xrb.xmn1.m0[id] from=0.25u to=0.5u
meas tran i868 avg @m.xdut.xrb.xmp1.m0[id] from=0.25u to=0.5u
meas tran i869 avg @m.xdut.xrb.xmn2.m0[id] from=0.25u to=0.5u
meas tran i870 avg @m.xdut.xrb.xmp2.m0[id] from=0.25u to=0.5u
meas tran i871 avg @m.xdut.xpll.xdb.xmn1.m0[id] from=0.25u to=0.5u
meas tran i872 avg @m.xdut.xpll.xdb.xmp1.m0[id] from=0.25u to=0.5u
meas tran i873 avg @m.xdut.xpll.xdb.xmn2.m0[id] from=0.25u to=0.5u
meas tran i874 avg @m.xdut.xpll.xdb.xmp2.m0[id] from=0.25u to=0.5u
meas tran i875 avg @m.xdut.xpll.xdiv.xd1.xf.xmp1.m0[id] from=0.25u to=0.5u
meas tran i876 avg @m.xdut.xpll.xdiv.xd1.xf.xmp2.m0[id] from=0.25u to=0.5u
meas tran i877 avg @m.xdut.xpll.xdiv.xd1.xf.xmn1.m0[id] from=0.25u to=0.5u
meas tran i878 avg @m.xdut.xpll.xdiv.xd1.xf.xmp3.m0[id] from=0.25u to=0.5u
meas tran i879 avg @m.xdut.xpll.xdiv.xd1.xf.xmn2.m0[id] from=0.25u to=0.5u
meas tran i880 avg @m.xdut.xpll.xdiv.xd1.xf.xmn3.m0[id] from=0.25u to=0.5u
meas tran i881 avg @m.xdut.xpll.xdiv.xd1.xf.xmp4.m0[id] from=0.25u to=0.5u
meas tran i882 avg @m.xdut.xpll.xdiv.xd1.xf.xmn4.m0[id] from=0.25u to=0.5u
meas tran i883 avg @m.xdut.xpll.xdiv.xd1.xf.xmn5.m0[id] from=0.25u to=0.5u
meas tran i884 avg @m.xdut.xpll.xdiv.xd1.xf.xmp5.m0[id] from=0.25u to=0.5u
meas tran i885 avg @m.xdut.xpll.xdiv.xd1.xf.xmn6.m0[id] from=0.25u to=0.5u
meas tran i886 avg @m.xdut.xpll.xdiv.xd2.xf.xmp1.m0[id] from=0.25u to=0.5u
meas tran i887 avg @m.xdut.xpll.xdiv.xd2.xf.xmp2.m0[id] from=0.25u to=0.5u
meas tran i888 avg @m.xdut.xpll.xdiv.xd2.xf.xmn1.m0[id] from=0.25u to=0.5u
meas tran i889 avg @m.xdut.xpll.xdiv.xd2.xf.xmp3.m0[id] from=0.25u to=0.5u
meas tran i890 avg @m.xdut.xpll.xdiv.xd2.xf.xmn2.m0[id] from=0.25u to=0.5u
meas tran i891 avg @m.xdut.xpll.xdiv.xd2.xf.xmn3.m0[id] from=0.25u to=0.5u
meas tran i892 avg @m.xdut.xpll.xdiv.xd2.xf.xmp4.m0[id] from=0.25u to=0.5u
meas tran i893 avg @m.xdut.xpll.xdiv.xd2.xf.xmn4.m0[id] from=0.25u to=0.5u
meas tran i894 avg @m.xdut.xpll.xdiv.xd2.xf.xmn5.m0[id] from=0.25u to=0.5u
meas tran i895 avg @m.xdut.xpll.xdiv.xd2.xf.xmp5.m0[id] from=0.25u to=0.5u
meas tran i896 avg @m.xdut.xpll.xdiv.xd2.xf.xmn6.m0[id] from=0.25u to=0.5u
meas tran i897 avg @m.xdut.xpll.xdiv.xd3.xf.xmp1.m0[id] from=0.25u to=0.5u
meas tran i898 avg @m.xdut.xpll.xdiv.xd3.xf.xmp2.m0[id] from=0.25u to=0.5u
meas tran i899 avg @m.xdut.xpll.xdiv.xd3.xf.xmn1.m0[id] from=0.25u to=0.5u
meas tran i900 avg @m.xdut.xpll.xdiv.xd3.xf.xmp3.m0[id] from=0.25u to=0.5u
meas tran i901 avg @m.xdut.xpll.xdiv.xd3.xf.xmn2.m0[id] from=0.25u to=0.5u
meas tran i902 avg @m.xdut.xpll.xdiv.xd3.xf.xmn3.m0[id] from=0.25u to=0.5u
meas tran i903 avg @m.xdut.xpll.xdiv.xd3.xf.xmp4.m0[id] from=0.25u to=0.5u
meas tran i904 avg @m.xdut.xpll.xdiv.xd3.xf.xmn4.m0[id] from=0.25u to=0.5u
meas tran i905 avg @m.xdut.xpll.xdiv.xd3.xf.xmn5.m0[id] from=0.25u to=0.5u
meas tran i906 avg @m.xdut.xpll.xdiv.xd3.xf.xmp5.m0[id] from=0.25u to=0.5u
meas tran i907 avg @m.xdut.xpll.xdiv.xd3.xf.xmn6.m0[id] from=0.25u to=0.5u
meas tran i908 avg @m.xdut.xpll.xdiv.xd5.xf1.xmp1.m0[id] from=0.25u to=0.5u
meas tran i909 avg @m.xdut.xpll.xdiv.xd5.xf1.xmp2.m0[id] from=0.25u to=0.5u
meas tran i910 avg @m.xdut.xpll.xdiv.xd5.xf1.xmn1.m0[id] from=0.25u to=0.5u
meas tran i911 avg @m.xdut.xpll.xdiv.xd5.xf1.xmp3.m0[id] from=0.25u to=0.5u
meas tran i912 avg @m.xdut.xpll.xdiv.xd5.xf1.xmn2.m0[id] from=0.25u to=0.5u
meas tran i913 avg @m.xdut.xpll.xdiv.xd5.xf1.xmn3.m0[id] from=0.25u to=0.5u
meas tran i914 avg @m.xdut.xpll.xdiv.xd5.xf1.xmp4.m0[id] from=0.25u to=0.5u
meas tran i915 avg @m.xdut.xpll.xdiv.xd5.xf1.xmn4.m0[id] from=0.25u to=0.5u
meas tran i916 avg @m.xdut.xpll.xdiv.xd5.xf1.xmn5.m0[id] from=0.25u to=0.5u
meas tran i917 avg @m.xdut.xpll.xdiv.xd5.xf1.xmp5.m0[id] from=0.25u to=0.5u
meas tran i918 avg @m.xdut.xpll.xdiv.xd5.xf1.xmn6.m0[id] from=0.25u to=0.5u
meas tran i919 avg @m.xdut.xpll.xdiv.xd5.xf2.xmp1.m0[id] from=0.25u to=0.5u
meas tran i920 avg @m.xdut.xpll.xdiv.xd5.xf2.xmp2.m0[id] from=0.25u to=0.5u
meas tran i921 avg @m.xdut.xpll.xdiv.xd5.xf2.xmn1.m0[id] from=0.25u to=0.5u
meas tran i922 avg @m.xdut.xpll.xdiv.xd5.xf2.xmp3.m0[id] from=0.25u to=0.5u
meas tran i923 avg @m.xdut.xpll.xdiv.xd5.xf2.xmn2.m0[id] from=0.25u to=0.5u
meas tran i924 avg @m.xdut.xpll.xdiv.xd5.xf2.xmn3.m0[id] from=0.25u to=0.5u
meas tran i925 avg @m.xdut.xpll.xdiv.xd5.xf2.xmp4.m0[id] from=0.25u to=0.5u
meas tran i926 avg @m.xdut.xpll.xdiv.xd5.xf2.xmn4.m0[id] from=0.25u to=0.5u
meas tran i927 avg @m.xdut.xpll.xdiv.xd5.xf2.xmn5.m0[id] from=0.25u to=0.5u
meas tran i928 avg @m.xdut.xpll.xdiv.xd5.xf2.xmp5.m0[id] from=0.25u to=0.5u
meas tran i929 avg @m.xdut.xpll.xdiv.xd5.xf2.xmn6.m0[id] from=0.25u to=0.5u
meas tran i930 avg @m.xdut.xpll.xdiv.xd5.xn.xmn1.m0[id] from=0.25u to=0.5u
meas tran i931 avg @m.xdut.xpll.xdiv.xd5.xn.xmn2.m0[id] from=0.25u to=0.5u
meas tran i932 avg @m.xdut.xpll.xdiv.xd5.xn.xmp1.m0[id] from=0.25u to=0.5u
meas tran i933 avg @m.xdut.xpll.xdiv.xd5.xn.xmp2.m0[id] from=0.25u to=0.5u
meas tran i934 avg @m.xdut.xpll.xdiv.xd6.xf.xmp1.m0[id] from=0.25u to=0.5u
meas tran i935 avg @m.xdut.xpll.xdiv.xd6.xf.xmp2.m0[id] from=0.25u to=0.5u
meas tran i936 avg @m.xdut.xpll.xdiv.xd6.xf.xmn1.m0[id] from=0.25u to=0.5u
meas tran i937 avg @m.xdut.xpll.xdiv.xd6.xf.xmp3.m0[id] from=0.25u to=0.5u
meas tran i938 avg @m.xdut.xpll.xdiv.xd6.xf.xmn2.m0[id] from=0.25u to=0.5u
meas tran i939 avg @m.xdut.xpll.xdiv.xd6.xf.xmn3.m0[id] from=0.25u to=0.5u
meas tran i940 avg @m.xdut.xpll.xdiv.xd6.xf.xmp4.m0[id] from=0.25u to=0.5u
meas tran i941 avg @m.xdut.xpll.xdiv.xd6.xf.xmn4.m0[id] from=0.25u to=0.5u
meas tran i942 avg @m.xdut.xpll.xdiv.xd6.xf.xmn5.m0[id] from=0.25u to=0.5u
meas tran i943 avg @m.xdut.xpll.xdiv.xd6.xf.xmp5.m0[id] from=0.25u to=0.5u
meas tran i944 avg @m.xdut.xpll.xdiv.xd6.xf.xmn6.m0[id] from=0.25u to=0.5u
meas tran i945 avg @m.xdut.xpll.xdiv.xfb1.xmn.m0[id] from=0.25u to=0.5u
meas tran i946 avg @m.xdut.xpll.xdiv.xfb1.xmp.m0[id] from=0.25u to=0.5u
meas tran i947 avg @m.xdut.xpll.xdiv.xfb2.xmn.m0[id] from=0.25u to=0.5u
meas tran i948 avg @m.xdut.xpll.xdiv.xfb2.xmp.m0[id] from=0.25u to=0.5u
meas tran i949 avg @m.xdut.xpll.xmcln.m0[id] from=0.25u to=0.5u
meas tran i950 avg @m.xdut.xpll.xmclp.m0[id] from=0.25u to=0.5u
meas tran i951 avg @m.xdut.xpll.xmtx.m0[id] from=0.25u to=0.5u
meas tran i952 avg @m.xdut.xpll.xmthi.m0[id] from=0.25u to=0.5u
meas tran i953 avg @m.xdut.xpll.xmtlo.m0[id] from=0.25u to=0.5u
meas tran i954 avg @m.xdut.xpll.xpfd.xu.x1.xmn1.m0[id] from=0.25u to=0.5u
meas tran i955 avg @m.xdut.xpll.xpfd.xu.x1.xmn2.m0[id] from=0.25u to=0.5u
meas tran i956 avg @m.xdut.xpll.xpfd.xu.x1.xmp1.m0[id] from=0.25u to=0.5u
meas tran i957 avg @m.xdut.xpll.xpfd.xu.x1.xmp2.m0[id] from=0.25u to=0.5u
meas tran i958 avg @m.xdut.xpll.xpfd.xu.x2.xmn1.m0[id] from=0.25u to=0.5u
meas tran i959 avg @m.xdut.xpll.xpfd.xu.x2.xmn2.m0[id] from=0.25u to=0.5u
meas tran i960 avg @m.xdut.xpll.xpfd.xu.x2.xmn3.m0[id] from=0.25u to=0.5u
meas tran i961 avg @m.xdut.xpll.xpfd.xu.x2.xmp1.m0[id] from=0.25u to=0.5u
meas tran i962 avg @m.xdut.xpll.xpfd.xu.x2.xmp2.m0[id] from=0.25u to=0.5u
meas tran i963 avg @m.xdut.xpll.xpfd.xu.x2.xmp3.m0[id] from=0.25u to=0.5u
meas tran i964 avg @m.xdut.xpll.xpfd.xu.x3.xmn1.m0[id] from=0.25u to=0.5u
meas tran i965 avg @m.xdut.xpll.xpfd.xu.x3.xmn2.m0[id] from=0.25u to=0.5u
meas tran i966 avg @m.xdut.xpll.xpfd.xu.x3.xmn3.m0[id] from=0.25u to=0.5u
meas tran i967 avg @m.xdut.xpll.xpfd.xu.x3.xmp1.m0[id] from=0.25u to=0.5u
meas tran i968 avg @m.xdut.xpll.xpfd.xu.x3.xmp2.m0[id] from=0.25u to=0.5u
meas tran i969 avg @m.xdut.xpll.xpfd.xu.x3.xmp3.m0[id] from=0.25u to=0.5u
meas tran i970 avg @m.xdut.xpll.xpfd.xu.x4.xmn1.m0[id] from=0.25u to=0.5u
meas tran i971 avg @m.xdut.xpll.xpfd.xu.x4.xmn2.m0[id] from=0.25u to=0.5u
meas tran i972 avg @m.xdut.xpll.xpfd.xu.x4.xmp1.m0[id] from=0.25u to=0.5u
meas tran i973 avg @m.xdut.xpll.xpfd.xu.x4.xmp2.m0[id] from=0.25u to=0.5u
meas tran i974 avg @m.xdut.xpll.xpfd.xu.x5.xmn1.m0[id] from=0.25u to=0.5u
meas tran i975 avg @m.xdut.xpll.xpfd.xu.x5.xmn2.m0[id] from=0.25u to=0.5u
meas tran i976 avg @m.xdut.xpll.xpfd.xu.x5.xmp1.m0[id] from=0.25u to=0.5u
meas tran i977 avg @m.xdut.xpll.xpfd.xu.x5.xmp2.m0[id] from=0.25u to=0.5u
meas tran i978 avg @m.xdut.xpll.xpfd.xu.x6.xmn1.m0[id] from=0.25u to=0.5u
meas tran i979 avg @m.xdut.xpll.xpfd.xu.x6.xmn2.m0[id] from=0.25u to=0.5u
meas tran i980 avg @m.xdut.xpll.xpfd.xu.x6.xmn3.m0[id] from=0.25u to=0.5u
meas tran i981 avg @m.xdut.xpll.xpfd.xu.x6.xmp1.m0[id] from=0.25u to=0.5u
meas tran i982 avg @m.xdut.xpll.xpfd.xu.x6.xmp2.m0[id] from=0.25u to=0.5u
meas tran i983 avg @m.xdut.xpll.xpfd.xu.x6.xmp3.m0[id] from=0.25u to=0.5u
meas tran i984 avg @m.xdut.xpll.xpfd.xd.x1.xmn1.m0[id] from=0.25u to=0.5u
meas tran i985 avg @m.xdut.xpll.xpfd.xd.x1.xmn2.m0[id] from=0.25u to=0.5u
meas tran i986 avg @m.xdut.xpll.xpfd.xd.x1.xmp1.m0[id] from=0.25u to=0.5u
meas tran i987 avg @m.xdut.xpll.xpfd.xd.x1.xmp2.m0[id] from=0.25u to=0.5u
meas tran i988 avg @m.xdut.xpll.xpfd.xd.x2.xmn1.m0[id] from=0.25u to=0.5u
meas tran i989 avg @m.xdut.xpll.xpfd.xd.x2.xmn2.m0[id] from=0.25u to=0.5u
meas tran i990 avg @m.xdut.xpll.xpfd.xd.x2.xmn3.m0[id] from=0.25u to=0.5u
meas tran i991 avg @m.xdut.xpll.xpfd.xd.x2.xmp1.m0[id] from=0.25u to=0.5u
meas tran i992 avg @m.xdut.xpll.xpfd.xd.x2.xmp2.m0[id] from=0.25u to=0.5u
meas tran i993 avg @m.xdut.xpll.xpfd.xd.x2.xmp3.m0[id] from=0.25u to=0.5u
meas tran i994 avg @m.xdut.xpll.xpfd.xd.x3.xmn1.m0[id] from=0.25u to=0.5u
meas tran i995 avg @m.xdut.xpll.xpfd.xd.x3.xmn2.m0[id] from=0.25u to=0.5u
meas tran i996 avg @m.xdut.xpll.xpfd.xd.x3.xmn3.m0[id] from=0.25u to=0.5u
meas tran i997 avg @m.xdut.xpll.xpfd.xd.x3.xmp1.m0[id] from=0.25u to=0.5u
meas tran i998 avg @m.xdut.xpll.xpfd.xd.x3.xmp2.m0[id] from=0.25u to=0.5u
meas tran i999 avg @m.xdut.xpll.xpfd.xd.x3.xmp3.m0[id] from=0.25u to=0.5u
meas tran i1000 avg @m.xdut.xpll.xpfd.xd.x4.xmn1.m0[id] from=0.25u to=0.5u
meas tran i1001 avg @m.xdut.xpll.xpfd.xd.x4.xmn2.m0[id] from=0.25u to=0.5u
meas tran i1002 avg @m.xdut.xpll.xpfd.xd.x4.xmp1.m0[id] from=0.25u to=0.5u
meas tran i1003 avg @m.xdut.xpll.xpfd.xd.x4.xmp2.m0[id] from=0.25u to=0.5u
meas tran i1004 avg @m.xdut.xpll.xpfd.xd.x5.xmn1.m0[id] from=0.25u to=0.5u
meas tran i1005 avg @m.xdut.xpll.xpfd.xd.x5.xmn2.m0[id] from=0.25u to=0.5u
meas tran i1006 avg @m.xdut.xpll.xpfd.xd.x5.xmp1.m0[id] from=0.25u to=0.5u
meas tran i1007 avg @m.xdut.xpll.xpfd.xd.x5.xmp2.m0[id] from=0.25u to=0.5u
meas tran i1008 avg @m.xdut.xpll.xpfd.xd.x6.xmn1.m0[id] from=0.25u to=0.5u
meas tran i1009 avg @m.xdut.xpll.xpfd.xd.x6.xmn2.m0[id] from=0.25u to=0.5u
meas tran i1010 avg @m.xdut.xpll.xpfd.xd.x6.xmn3.m0[id] from=0.25u to=0.5u
meas tran i1011 avg @m.xdut.xpll.xpfd.xd.x6.xmp1.m0[id] from=0.25u to=0.5u
meas tran i1012 avg @m.xdut.xpll.xpfd.xd.x6.xmp2.m0[id] from=0.25u to=0.5u
meas tran i1013 avg @m.xdut.xpll.xpfd.xd.x6.xmp3.m0[id] from=0.25u to=0.5u
meas tran i1014 avg @m.xdut.xpll.xpfd.xr.xmn1.m0[id] from=0.25u to=0.5u
meas tran i1015 avg @m.xdut.xpll.xpfd.xr.xmn2.m0[id] from=0.25u to=0.5u
meas tran i1016 avg @m.xdut.xpll.xpfd.xr.xmp1.m0[id] from=0.25u to=0.5u
meas tran i1017 avg @m.xdut.xpll.xpfd.xr.xmp2.m0[id] from=0.25u to=0.5u
meas tran i1018 avg @m.xdut.xpll.xpfd.xd1.xmn.m0[id] from=0.25u to=0.5u
meas tran i1019 avg @m.xdut.xpll.xpfd.xd1.xmp.m0[id] from=0.25u to=0.5u
meas tran i1020 avg @m.xdut.xpll.xpfd.xd2.xmn.m0[id] from=0.25u to=0.5u
meas tran i1021 avg @m.xdut.xpll.xpfd.xd2.xmp.m0[id] from=0.25u to=0.5u
meas tran i1022 avg @m.xdut.xpll.xpfd.xd3.xmn.m0[id] from=0.25u to=0.5u
meas tran i1023 avg @m.xdut.xpll.xpfd.xd3.xmp.m0[id] from=0.25u to=0.5u
meas tran i1024 avg @m.xdut.xpll.xpfd.xd4.xmn.m0[id] from=0.25u to=0.5u
meas tran i1025 avg @m.xdut.xpll.xpfd.xd4.xmp.m0[id] from=0.25u to=0.5u
meas tran i1026 avg @m.xdut.xpll.xpfd.xo1.xmn.m0[id] from=0.25u to=0.5u
meas tran i1027 avg @m.xdut.xpll.xpfd.xo1.xmp.m0[id] from=0.25u to=0.5u
meas tran i1028 avg @m.xdut.xpll.xpfd.xo2.xmn.m0[id] from=0.25u to=0.5u
meas tran i1029 avg @m.xdut.xpll.xpfd.xo2.xmp.m0[id] from=0.25u to=0.5u
meas tran i1030 avg @m.xdut.xpll.xcp.xud.xmn.m0[id] from=0.25u to=0.5u
meas tran i1031 avg @m.xdut.xpll.xcp.xud.xmp.m0[id] from=0.25u to=0.5u
meas tran i1032 avg @m.xdut.xpll.xcp.xmpc.m0[id] from=0.25u to=0.5u
meas tran i1033 avg @m.xdut.xpll.xcp.xmps.m0[id] from=0.25u to=0.5u
meas tran i1034 avg @m.xdut.xpll.xcp.xmpd.m0[id] from=0.25u to=0.5u
meas tran i1035 avg @m.xdut.xpll.xcp.xmns.m0[id] from=0.25u to=0.5u
meas tran i1036 avg @m.xdut.xpll.xcp.xmnd.m0[id] from=0.25u to=0.5u
meas tran i1037 avg @m.xdut.xpll.xcp.xmnc.m0[id] from=0.25u to=0.5u
meas tran i1038 avg @m.xdut.xpll.xcp.xhi.xmn.m0[id] from=0.25u to=0.5u
meas tran i1039 avg @m.xdut.xpll.xcp.xhi.xmp.m0[id] from=0.25u to=0.5u
meas tran i1040 avg @m.xdut.xpll.xcp.xmpc2.m0[id] from=0.25u to=0.5u
meas tran i1041 avg @m.xdut.xpll.xcp.xmpe2.m0[id] from=0.25u to=0.5u
meas tran i1042 avg @m.xdut.xpll.xcp.xmps2.m0[id] from=0.25u to=0.5u
meas tran i1043 avg @m.xdut.xpll.xcp.xmpd2.m0[id] from=0.25u to=0.5u
meas tran i1044 avg @m.xdut.xpll.xcp.xmns2.m0[id] from=0.25u to=0.5u
meas tran i1045 avg @m.xdut.xpll.xcp.xmnd2.m0[id] from=0.25u to=0.5u
meas tran i1046 avg @m.xdut.xpll.xcp.xmne2.m0[id] from=0.25u to=0.5u
meas tran i1047 avg @m.xdut.xpll.xcp.xmnc2.m0[id] from=0.25u to=0.5u
meas tran i1048 avg @m.xdut.xpll.xcp.xmbt.m0[id] from=0.25u to=0.5u
meas tran i1049 avg @m.xdut.xpll.xcp.xmb1.m0[id] from=0.25u to=0.5u
meas tran i1050 avg @m.xdut.xpll.xcp.xmb2.m0[id] from=0.25u to=0.5u
meas tran i1051 avg @m.xdut.xpll.xcp.xmbl1.m0[id] from=0.25u to=0.5u
meas tran i1052 avg @m.xdut.xpll.xcp.xmbl2.m0[id] from=0.25u to=0.5u
meas tran i1053 avg @m.xdut.xlna.xm1.m0[id] from=0.25u to=0.5u
meas tran i1054 avg @m.xdut.xlna.xm2.m0[id] from=0.25u to=0.5u
meas tran i1055 avg @m.xdut.xlna.xmp1.m0[id] from=0.25u to=0.5u
meas tran i1056 avg @m.xdut.xlna.xm1r.m0[id] from=0.25u to=0.5u
meas tran i1057 avg @m.xdut.xlna.xmp2.m0[id] from=0.25u to=0.5u
meas tran i1058 avg @m.xdut.xlna.xm2r.m0[id] from=0.25u to=0.5u
meas tran i1059 avg @m.xdut.xmix.xmctl1p.m0[id] from=0.25u to=0.5u
meas tran i1060 avg @m.xdut.xmix.xmctl1n.m0[id] from=0.25u to=0.5u
meas tran i1061 avg @m.xdut.xmix.xmctl2p.m0[id] from=0.25u to=0.5u
meas tran i1062 avg @m.xdut.xmix.xmctl2n.m0[id] from=0.25u to=0.5u
meas tran i1063 avg @m.xdut.xmix.xmctl3p.m0[id] from=0.25u to=0.5u
meas tran i1064 avg @m.xdut.xmix.xmctl3n.m0[id] from=0.25u to=0.5u
meas tran i1065 avg @m.xdut.xmix.xmctl4p.m0[id] from=0.25u to=0.5u
meas tran i1066 avg @m.xdut.xmix.xmctl4n.m0[id] from=0.25u to=0.5u
meas tran i1067 avg @m.xdut.xmix.xmti.m0[id] from=0.25u to=0.5u
meas tran i1068 avg @m.xdut.xmix.xmg1i.m0[id] from=0.25u to=0.5u
meas tran i1069 avg @m.xdut.xmix.xmg2i.m0[id] from=0.25u to=0.5u
meas tran i1070 avg @m.xdut.xmix.xmlapi.m0[id] from=0.25u to=0.5u
meas tran i1071 avg @m.xdut.xmix.xmlbpi.m0[id] from=0.25u to=0.5u
meas tran i1072 avg @m.xdut.xmix.xmu1pi.m0[id] from=0.25u to=0.5u
meas tran i1073 avg @m.xdut.xmix.xmu2pi.m0[id] from=0.25u to=0.5u
meas tran i1074 avg @m.xdut.xmix.xmu3pi.m0[id] from=0.25u to=0.5u
meas tran i1075 avg @m.xdut.xmix.xmu4pi.m0[id] from=0.25u to=0.5u
meas tran i1076 avg @m.xdut.xmix.xmlani.m0[id] from=0.25u to=0.5u
meas tran i1077 avg @m.xdut.xmix.xmlbni.m0[id] from=0.25u to=0.5u
meas tran i1078 avg @m.xdut.xmix.xmu1ni.m0[id] from=0.25u to=0.5u
meas tran i1079 avg @m.xdut.xmix.xmu2ni.m0[id] from=0.25u to=0.5u
meas tran i1080 avg @m.xdut.xmix.xmu3ni.m0[id] from=0.25u to=0.5u
meas tran i1081 avg @m.xdut.xmix.xmu4ni.m0[id] from=0.25u to=0.5u
meas tran i1082 avg @m.xdut.xmix.xmtq.m0[id] from=0.25u to=0.5u
meas tran i1083 avg @m.xdut.xmix.xmg1q.m0[id] from=0.25u to=0.5u
meas tran i1084 avg @m.xdut.xmix.xmg2q.m0[id] from=0.25u to=0.5u
meas tran i1085 avg @m.xdut.xmix.xmlapq.m0[id] from=0.25u to=0.5u
meas tran i1086 avg @m.xdut.xmix.xmlbpq.m0[id] from=0.25u to=0.5u
meas tran i1087 avg @m.xdut.xmix.xmu1pq.m0[id] from=0.25u to=0.5u
meas tran i1088 avg @m.xdut.xmix.xmu2pq.m0[id] from=0.25u to=0.5u
meas tran i1089 avg @m.xdut.xmix.xmu3pq.m0[id] from=0.25u to=0.5u
meas tran i1090 avg @m.xdut.xmix.xmu4pq.m0[id] from=0.25u to=0.5u
meas tran i1091 avg @m.xdut.xmix.xmlanq.m0[id] from=0.25u to=0.5u
meas tran i1092 avg @m.xdut.xmix.xmlbnq.m0[id] from=0.25u to=0.5u
meas tran i1093 avg @m.xdut.xmix.xmu1nq.m0[id] from=0.25u to=0.5u
meas tran i1094 avg @m.xdut.xmix.xmu2nq.m0[id] from=0.25u to=0.5u
meas tran i1095 avg @m.xdut.xmix.xmu3nq.m0[id] from=0.25u to=0.5u
meas tran i1096 avg @m.xdut.xmix.xmu4nq.m0[id] from=0.25u to=0.5u
meas tran i1097 avg @m.xdut.xifi.xbif.xmot.m0[id] from=0.25u to=0.5u
meas tran i1098 avg @m.xdut.xifi.xbif.xmi1.m0[id] from=0.25u to=0.5u
meas tran i1099 avg @m.xdut.xifi.xbif.xmi2.m0[id] from=0.25u to=0.5u
meas tran i1100 avg @m.xdut.xifi.xbif.xml1.m0[id] from=0.25u to=0.5u
meas tran i1101 avg @m.xdut.xifi.xbif.xml2.m0[id] from=0.25u to=0.5u
meas tran i1102 avg @m.xdut.xifi.xbif.xmv.m0[id] from=0.25u to=0.5u
meas tran i1103 avg @m.xdut.xifi.xbif.xmpd.m0[id] from=0.25u to=0.5u
meas tran i1104 avg @m.xdut.xifi.xbif.xmpm.m0[id] from=0.25u to=0.5u
meas tran i1105 avg @m.xdut.xifi.xbif.xmnd.m0[id] from=0.25u to=0.5u
meas tran i1106 avg @m.xdut.xifi.xbif.xmnp.m0[id] from=0.25u to=0.5u
meas tran i1107 avg @m.xdut.xifi.xbif.xmpp.m0[id] from=0.25u to=0.5u
meas tran i1108 avg @m.xdut.xifi.xv1.xm1.m0[id] from=0.25u to=0.5u
meas tran i1109 avg @m.xdut.xifi.xv1.xm2.m0[id] from=0.25u to=0.5u
meas tran i1110 avg @m.xdut.xifi.xv1.xmt1.m0[id] from=0.25u to=0.5u
meas tran i1111 avg @m.xdut.xifi.xv1.xmt2.m0[id] from=0.25u to=0.5u
meas tran i1112 avg @m.xdut.xifi.xv1.xmsa.m0[id] from=0.25u to=0.5u
meas tran i1113 avg @m.xdut.xifi.xv1.xmsb.m0[id] from=0.25u to=0.5u
meas tran i1114 avg @m.xdut.xifi.xf1.xmfp.m0[id] from=0.25u to=0.5u
meas tran i1115 avg @m.xdut.xifi.xf1.xmip.m0[id] from=0.25u to=0.5u
meas tran i1116 avg @m.xdut.xifi.xf1.xmfn.m0[id] from=0.25u to=0.5u
meas tran i1117 avg @m.xdut.xifi.xf1.xmin.m0[id] from=0.25u to=0.5u
meas tran i1118 avg @m.xdut.xifi.xv2.xm1.m0[id] from=0.25u to=0.5u
meas tran i1119 avg @m.xdut.xifi.xv2.xm2.m0[id] from=0.25u to=0.5u
meas tran i1120 avg @m.xdut.xifi.xv2.xmt1.m0[id] from=0.25u to=0.5u
meas tran i1121 avg @m.xdut.xifi.xv2.xmt2.m0[id] from=0.25u to=0.5u
meas tran i1122 avg @m.xdut.xifi.xv2.xmsa.m0[id] from=0.25u to=0.5u
meas tran i1123 avg @m.xdut.xifi.xv2.xmsb.m0[id] from=0.25u to=0.5u
meas tran i1124 avg @m.xdut.xifi.xf2.xmfp.m0[id] from=0.25u to=0.5u
meas tran i1125 avg @m.xdut.xifi.xf2.xmip.m0[id] from=0.25u to=0.5u
meas tran i1126 avg @m.xdut.xifi.xf2.xmfn.m0[id] from=0.25u to=0.5u
meas tran i1127 avg @m.xdut.xifi.xf2.xmin.m0[id] from=0.25u to=0.5u
meas tran i1128 avg @m.xdut.xifi.xv3.xm1.m0[id] from=0.25u to=0.5u
meas tran i1129 avg @m.xdut.xifi.xv3.xm2.m0[id] from=0.25u to=0.5u
meas tran i1130 avg @m.xdut.xifi.xv3.xmt1.m0[id] from=0.25u to=0.5u
meas tran i1131 avg @m.xdut.xifi.xv3.xmt2.m0[id] from=0.25u to=0.5u
meas tran i1132 avg @m.xdut.xifi.xv3.xmsa.m0[id] from=0.25u to=0.5u
meas tran i1133 avg @m.xdut.xifi.xv3.xmsb.m0[id] from=0.25u to=0.5u
meas tran i1134 avg @m.xdut.xifi.xv4.xm1.m0[id] from=0.25u to=0.5u
meas tran i1135 avg @m.xdut.xifi.xv4.xm2.m0[id] from=0.25u to=0.5u
meas tran i1136 avg @m.xdut.xifi.xv4.xmt1.m0[id] from=0.25u to=0.5u
meas tran i1137 avg @m.xdut.xifi.xv4.xmt2.m0[id] from=0.25u to=0.5u
meas tran i1138 avg @m.xdut.xifi.xv5.xm1.m0[id] from=0.25u to=0.5u
meas tran i1139 avg @m.xdut.xifi.xv5.xm2.m0[id] from=0.25u to=0.5u
meas tran i1140 avg @m.xdut.xifi.xv5.xmt1.m0[id] from=0.25u to=0.5u
meas tran i1141 avg @m.xdut.xifi.xv5.xmt2.m0[id] from=0.25u to=0.5u
meas tran i1142 avg @m.xdut.xifq.xbif.xmot.m0[id] from=0.25u to=0.5u
meas tran i1143 avg @m.xdut.xifq.xbif.xmi1.m0[id] from=0.25u to=0.5u
meas tran i1144 avg @m.xdut.xifq.xbif.xmi2.m0[id] from=0.25u to=0.5u
meas tran i1145 avg @m.xdut.xifq.xbif.xml1.m0[id] from=0.25u to=0.5u
meas tran i1146 avg @m.xdut.xifq.xbif.xml2.m0[id] from=0.25u to=0.5u
meas tran i1147 avg @m.xdut.xifq.xbif.xmv.m0[id] from=0.25u to=0.5u
meas tran i1148 avg @m.xdut.xifq.xbif.xmpd.m0[id] from=0.25u to=0.5u
meas tran i1149 avg @m.xdut.xifq.xbif.xmpm.m0[id] from=0.25u to=0.5u
meas tran i1150 avg @m.xdut.xifq.xbif.xmnd.m0[id] from=0.25u to=0.5u
meas tran i1151 avg @m.xdut.xifq.xbif.xmnp.m0[id] from=0.25u to=0.5u
meas tran i1152 avg @m.xdut.xifq.xbif.xmpp.m0[id] from=0.25u to=0.5u
meas tran i1153 avg @m.xdut.xifq.xv1.xm1.m0[id] from=0.25u to=0.5u
meas tran i1154 avg @m.xdut.xifq.xv1.xm2.m0[id] from=0.25u to=0.5u
meas tran i1155 avg @m.xdut.xifq.xv1.xmt1.m0[id] from=0.25u to=0.5u
meas tran i1156 avg @m.xdut.xifq.xv1.xmt2.m0[id] from=0.25u to=0.5u
meas tran i1157 avg @m.xdut.xifq.xv1.xmsa.m0[id] from=0.25u to=0.5u
meas tran i1158 avg @m.xdut.xifq.xv1.xmsb.m0[id] from=0.25u to=0.5u
meas tran i1159 avg @m.xdut.xifq.xf1.xmfp.m0[id] from=0.25u to=0.5u
meas tran i1160 avg @m.xdut.xifq.xf1.xmip.m0[id] from=0.25u to=0.5u
meas tran i1161 avg @m.xdut.xifq.xf1.xmfn.m0[id] from=0.25u to=0.5u
meas tran i1162 avg @m.xdut.xifq.xf1.xmin.m0[id] from=0.25u to=0.5u
meas tran i1163 avg @m.xdut.xifq.xv2.xm1.m0[id] from=0.25u to=0.5u
meas tran i1164 avg @m.xdut.xifq.xv2.xm2.m0[id] from=0.25u to=0.5u
meas tran i1165 avg @m.xdut.xifq.xv2.xmt1.m0[id] from=0.25u to=0.5u
meas tran i1166 avg @m.xdut.xifq.xv2.xmt2.m0[id] from=0.25u to=0.5u
meas tran i1167 avg @m.xdut.xifq.xv2.xmsa.m0[id] from=0.25u to=0.5u
meas tran i1168 avg @m.xdut.xifq.xv2.xmsb.m0[id] from=0.25u to=0.5u
meas tran i1169 avg @m.xdut.xifq.xf2.xmfp.m0[id] from=0.25u to=0.5u
meas tran i1170 avg @m.xdut.xifq.xf2.xmip.m0[id] from=0.25u to=0.5u
meas tran i1171 avg @m.xdut.xifq.xf2.xmfn.m0[id] from=0.25u to=0.5u
meas tran i1172 avg @m.xdut.xifq.xf2.xmin.m0[id] from=0.25u to=0.5u
meas tran i1173 avg @m.xdut.xifq.xv3.xm1.m0[id] from=0.25u to=0.5u
meas tran i1174 avg @m.xdut.xifq.xv3.xm2.m0[id] from=0.25u to=0.5u
meas tran i1175 avg @m.xdut.xifq.xv3.xmt1.m0[id] from=0.25u to=0.5u
meas tran i1176 avg @m.xdut.xifq.xv3.xmt2.m0[id] from=0.25u to=0.5u
meas tran i1177 avg @m.xdut.xifq.xv3.xmsa.m0[id] from=0.25u to=0.5u
meas tran i1178 avg @m.xdut.xifq.xv3.xmsb.m0[id] from=0.25u to=0.5u
meas tran i1179 avg @m.xdut.xifq.xv4.xm1.m0[id] from=0.25u to=0.5u
meas tran i1180 avg @m.xdut.xifq.xv4.xm2.m0[id] from=0.25u to=0.5u
meas tran i1181 avg @m.xdut.xifq.xv4.xmt1.m0[id] from=0.25u to=0.5u
meas tran i1182 avg @m.xdut.xifq.xv4.xmt2.m0[id] from=0.25u to=0.5u
meas tran i1183 avg @m.xdut.xifq.xv5.xm1.m0[id] from=0.25u to=0.5u
meas tran i1184 avg @m.xdut.xifq.xv5.xm2.m0[id] from=0.25u to=0.5u
meas tran i1185 avg @m.xdut.xifq.xv5.xmt1.m0[id] from=0.25u to=0.5u
meas tran i1186 avg @m.xdut.xifq.xv5.xmt2.m0[id] from=0.25u to=0.5u
meas tran i1187 avg @m.xdut.xadi.xcs.xmt.m0[id] from=0.25u to=0.5u
meas tran i1188 avg @m.xdut.xadi.xcs.xm1.m0[id] from=0.25u to=0.5u
meas tran i1189 avg @m.xdut.xadi.xcs.xm2.m0[id] from=0.25u to=0.5u
meas tran i1190 avg @m.xdut.xadi.xcs.xm3.m0[id] from=0.25u to=0.5u
meas tran i1191 avg @m.xdut.xadi.xcs.xm4.m0[id] from=0.25u to=0.5u
meas tran i1192 avg @m.xdut.xadi.xcs.xm5.m0[id] from=0.25u to=0.5u
meas tran i1193 avg @m.xdut.xadi.xcs.xm6.m0[id] from=0.25u to=0.5u
meas tran i1194 avg @m.xdut.xadi.xcs.xm7.m0[id] from=0.25u to=0.5u
meas tran i1195 avg @m.xdut.xadi.xcs.xm8.m0[id] from=0.25u to=0.5u
meas tran i1196 avg @m.xdut.xadi.xcs.xm9.m0[id] from=0.25u to=0.5u
meas tran i1197 avg @m.xdut.xadi.xcs.xm10.m0[id] from=0.25u to=0.5u
meas tran i1198 avg @m.xdut.xadi.xcs.xm11.m0[id] from=0.25u to=0.5u
meas tran i1199 avg @m.xdut.xadi.xcs.xm12.m0[id] from=0.25u to=0.5u
meas tran i1200 avg @m.xdut.xadi.xcs.xi1.xmn.m0[id] from=0.25u to=0.5u
meas tran i1201 avg @m.xdut.xadi.xcs.xi1.xmp.m0[id] from=0.25u to=0.5u
meas tran i1202 avg @m.xdut.xadi.xcs.xi2.xmn.m0[id] from=0.25u to=0.5u
meas tran i1203 avg @m.xdut.xadi.xcs.xi2.xmp.m0[id] from=0.25u to=0.5u
meas tran i1204 avg @m.xdut.xadi.xcs.xs1.xmn1.m0[id] from=0.25u to=0.5u
meas tran i1205 avg @m.xdut.xadi.xcs.xs1.xmn2.m0[id] from=0.25u to=0.5u
meas tran i1206 avg @m.xdut.xadi.xcs.xs1.xmp1.m0[id] from=0.25u to=0.5u
meas tran i1207 avg @m.xdut.xadi.xcs.xs1.xmp2.m0[id] from=0.25u to=0.5u
meas tran i1208 avg @m.xdut.xadi.xcs.xs2.xmn1.m0[id] from=0.25u to=0.5u
meas tran i1209 avg @m.xdut.xadi.xcs.xs2.xmn2.m0[id] from=0.25u to=0.5u
meas tran i1210 avg @m.xdut.xadi.xcs.xs2.xmp1.m0[id] from=0.25u to=0.5u
meas tran i1211 avg @m.xdut.xadi.xcs.xs2.xmp2.m0[id] from=0.25u to=0.5u
meas tran i1212 avg @m.xdut.xadi.xch.xmt.m0[id] from=0.25u to=0.5u
meas tran i1213 avg @m.xdut.xadi.xch.xm1.m0[id] from=0.25u to=0.5u
meas tran i1214 avg @m.xdut.xadi.xch.xm2.m0[id] from=0.25u to=0.5u
meas tran i1215 avg @m.xdut.xadi.xch.xm3.m0[id] from=0.25u to=0.5u
meas tran i1216 avg @m.xdut.xadi.xch.xm4.m0[id] from=0.25u to=0.5u
meas tran i1217 avg @m.xdut.xadi.xch.xm5.m0[id] from=0.25u to=0.5u
meas tran i1218 avg @m.xdut.xadi.xch.xm6.m0[id] from=0.25u to=0.5u
meas tran i1219 avg @m.xdut.xadi.xch.xm7.m0[id] from=0.25u to=0.5u
meas tran i1220 avg @m.xdut.xadi.xch.xm8.m0[id] from=0.25u to=0.5u
meas tran i1221 avg @m.xdut.xadi.xch.xm9.m0[id] from=0.25u to=0.5u
meas tran i1222 avg @m.xdut.xadi.xch.xm10.m0[id] from=0.25u to=0.5u
meas tran i1223 avg @m.xdut.xadi.xch.xm11.m0[id] from=0.25u to=0.5u
meas tran i1224 avg @m.xdut.xadi.xch.xm12.m0[id] from=0.25u to=0.5u
meas tran i1225 avg @m.xdut.xadi.xch.xi1.xmn.m0[id] from=0.25u to=0.5u
meas tran i1226 avg @m.xdut.xadi.xch.xi1.xmp.m0[id] from=0.25u to=0.5u
meas tran i1227 avg @m.xdut.xadi.xch.xi2.xmn.m0[id] from=0.25u to=0.5u
meas tran i1228 avg @m.xdut.xadi.xch.xi2.xmp.m0[id] from=0.25u to=0.5u
meas tran i1229 avg @m.xdut.xadi.xch.xs1.xmn1.m0[id] from=0.25u to=0.5u
meas tran i1230 avg @m.xdut.xadi.xch.xs1.xmn2.m0[id] from=0.25u to=0.5u
meas tran i1231 avg @m.xdut.xadi.xch.xs1.xmp1.m0[id] from=0.25u to=0.5u
meas tran i1232 avg @m.xdut.xadi.xch.xs1.xmp2.m0[id] from=0.25u to=0.5u
meas tran i1233 avg @m.xdut.xadi.xch.xs2.xmn1.m0[id] from=0.25u to=0.5u
meas tran i1234 avg @m.xdut.xadi.xch.xs2.xmn2.m0[id] from=0.25u to=0.5u
meas tran i1235 avg @m.xdut.xadi.xch.xs2.xmp1.m0[id] from=0.25u to=0.5u
meas tran i1236 avg @m.xdut.xadi.xch.xs2.xmp2.m0[id] from=0.25u to=0.5u
meas tran i1237 avg @m.xdut.xadi.xcl.xmt.m0[id] from=0.25u to=0.5u
meas tran i1238 avg @m.xdut.xadi.xcl.xm1.m0[id] from=0.25u to=0.5u
meas tran i1239 avg @m.xdut.xadi.xcl.xm2.m0[id] from=0.25u to=0.5u
meas tran i1240 avg @m.xdut.xadi.xcl.xm3.m0[id] from=0.25u to=0.5u
meas tran i1241 avg @m.xdut.xadi.xcl.xm4.m0[id] from=0.25u to=0.5u
meas tran i1242 avg @m.xdut.xadi.xcl.xm5.m0[id] from=0.25u to=0.5u
meas tran i1243 avg @m.xdut.xadi.xcl.xm6.m0[id] from=0.25u to=0.5u
meas tran i1244 avg @m.xdut.xadi.xcl.xm7.m0[id] from=0.25u to=0.5u
meas tran i1245 avg @m.xdut.xadi.xcl.xm8.m0[id] from=0.25u to=0.5u
meas tran i1246 avg @m.xdut.xadi.xcl.xm9.m0[id] from=0.25u to=0.5u
meas tran i1247 avg @m.xdut.xadi.xcl.xm10.m0[id] from=0.25u to=0.5u
meas tran i1248 avg @m.xdut.xadi.xcl.xm11.m0[id] from=0.25u to=0.5u
meas tran i1249 avg @m.xdut.xadi.xcl.xm12.m0[id] from=0.25u to=0.5u
meas tran i1250 avg @m.xdut.xadi.xcl.xi1.xmn.m0[id] from=0.25u to=0.5u
meas tran i1251 avg @m.xdut.xadi.xcl.xi1.xmp.m0[id] from=0.25u to=0.5u
meas tran i1252 avg @m.xdut.xadi.xcl.xi2.xmn.m0[id] from=0.25u to=0.5u
meas tran i1253 avg @m.xdut.xadi.xcl.xi2.xmp.m0[id] from=0.25u to=0.5u
meas tran i1254 avg @m.xdut.xadi.xcl.xs1.xmn1.m0[id] from=0.25u to=0.5u
meas tran i1255 avg @m.xdut.xadi.xcl.xs1.xmn2.m0[id] from=0.25u to=0.5u
meas tran i1256 avg @m.xdut.xadi.xcl.xs1.xmp1.m0[id] from=0.25u to=0.5u
meas tran i1257 avg @m.xdut.xadi.xcl.xs1.xmp2.m0[id] from=0.25u to=0.5u
meas tran i1258 avg @m.xdut.xadi.xcl.xs2.xmn1.m0[id] from=0.25u to=0.5u
meas tran i1259 avg @m.xdut.xadi.xcl.xs2.xmn2.m0[id] from=0.25u to=0.5u
meas tran i1260 avg @m.xdut.xadi.xcl.xs2.xmp1.m0[id] from=0.25u to=0.5u
meas tran i1261 avg @m.xdut.xadi.xcl.xs2.xmp2.m0[id] from=0.25u to=0.5u
meas tran i1262 avg @m.xdut.xadi.xm.xmn1.m0[id] from=0.25u to=0.5u
meas tran i1263 avg @m.xdut.xadi.xm.xmn2.m0[id] from=0.25u to=0.5u
meas tran i1264 avg @m.xdut.xadi.xm.xmp1.m0[id] from=0.25u to=0.5u
meas tran i1265 avg @m.xdut.xadi.xm.xmp2.m0[id] from=0.25u to=0.5u
meas tran i1266 avg @m.xdut.xadq.xcs.xmt.m0[id] from=0.25u to=0.5u
meas tran i1267 avg @m.xdut.xadq.xcs.xm1.m0[id] from=0.25u to=0.5u
meas tran i1268 avg @m.xdut.xadq.xcs.xm2.m0[id] from=0.25u to=0.5u
meas tran i1269 avg @m.xdut.xadq.xcs.xm3.m0[id] from=0.25u to=0.5u
meas tran i1270 avg @m.xdut.xadq.xcs.xm4.m0[id] from=0.25u to=0.5u
meas tran i1271 avg @m.xdut.xadq.xcs.xm5.m0[id] from=0.25u to=0.5u
meas tran i1272 avg @m.xdut.xadq.xcs.xm6.m0[id] from=0.25u to=0.5u
meas tran i1273 avg @m.xdut.xadq.xcs.xm7.m0[id] from=0.25u to=0.5u
meas tran i1274 avg @m.xdut.xadq.xcs.xm8.m0[id] from=0.25u to=0.5u
meas tran i1275 avg @m.xdut.xadq.xcs.xm9.m0[id] from=0.25u to=0.5u
meas tran i1276 avg @m.xdut.xadq.xcs.xm10.m0[id] from=0.25u to=0.5u
meas tran i1277 avg @m.xdut.xadq.xcs.xm11.m0[id] from=0.25u to=0.5u
meas tran i1278 avg @m.xdut.xadq.xcs.xm12.m0[id] from=0.25u to=0.5u
meas tran i1279 avg @m.xdut.xadq.xcs.xi1.xmn.m0[id] from=0.25u to=0.5u
meas tran i1280 avg @m.xdut.xadq.xcs.xi1.xmp.m0[id] from=0.25u to=0.5u
meas tran i1281 avg @m.xdut.xadq.xcs.xi2.xmn.m0[id] from=0.25u to=0.5u
meas tran i1282 avg @m.xdut.xadq.xcs.xi2.xmp.m0[id] from=0.25u to=0.5u
meas tran i1283 avg @m.xdut.xadq.xcs.xs1.xmn1.m0[id] from=0.25u to=0.5u
meas tran i1284 avg @m.xdut.xadq.xcs.xs1.xmn2.m0[id] from=0.25u to=0.5u
meas tran i1285 avg @m.xdut.xadq.xcs.xs1.xmp1.m0[id] from=0.25u to=0.5u
meas tran i1286 avg @m.xdut.xadq.xcs.xs1.xmp2.m0[id] from=0.25u to=0.5u
meas tran i1287 avg @m.xdut.xadq.xcs.xs2.xmn1.m0[id] from=0.25u to=0.5u
meas tran i1288 avg @m.xdut.xadq.xcs.xs2.xmn2.m0[id] from=0.25u to=0.5u
meas tran i1289 avg @m.xdut.xadq.xcs.xs2.xmp1.m0[id] from=0.25u to=0.5u
meas tran i1290 avg @m.xdut.xadq.xcs.xs2.xmp2.m0[id] from=0.25u to=0.5u
meas tran i1291 avg @m.xdut.xadq.xch.xmt.m0[id] from=0.25u to=0.5u
meas tran i1292 avg @m.xdut.xadq.xch.xm1.m0[id] from=0.25u to=0.5u
meas tran i1293 avg @m.xdut.xadq.xch.xm2.m0[id] from=0.25u to=0.5u
meas tran i1294 avg @m.xdut.xadq.xch.xm3.m0[id] from=0.25u to=0.5u
meas tran i1295 avg @m.xdut.xadq.xch.xm4.m0[id] from=0.25u to=0.5u
meas tran i1296 avg @m.xdut.xadq.xch.xm5.m0[id] from=0.25u to=0.5u
meas tran i1297 avg @m.xdut.xadq.xch.xm6.m0[id] from=0.25u to=0.5u
meas tran i1298 avg @m.xdut.xadq.xch.xm7.m0[id] from=0.25u to=0.5u
meas tran i1299 avg @m.xdut.xadq.xch.xm8.m0[id] from=0.25u to=0.5u
meas tran i1300 avg @m.xdut.xadq.xch.xm9.m0[id] from=0.25u to=0.5u
meas tran i1301 avg @m.xdut.xadq.xch.xm10.m0[id] from=0.25u to=0.5u
meas tran i1302 avg @m.xdut.xadq.xch.xm11.m0[id] from=0.25u to=0.5u
meas tran i1303 avg @m.xdut.xadq.xch.xm12.m0[id] from=0.25u to=0.5u
meas tran i1304 avg @m.xdut.xadq.xch.xi1.xmn.m0[id] from=0.25u to=0.5u
meas tran i1305 avg @m.xdut.xadq.xch.xi1.xmp.m0[id] from=0.25u to=0.5u
meas tran i1306 avg @m.xdut.xadq.xch.xi2.xmn.m0[id] from=0.25u to=0.5u
meas tran i1307 avg @m.xdut.xadq.xch.xi2.xmp.m0[id] from=0.25u to=0.5u
meas tran i1308 avg @m.xdut.xadq.xch.xs1.xmn1.m0[id] from=0.25u to=0.5u
meas tran i1309 avg @m.xdut.xadq.xch.xs1.xmn2.m0[id] from=0.25u to=0.5u
meas tran i1310 avg @m.xdut.xadq.xch.xs1.xmp1.m0[id] from=0.25u to=0.5u
meas tran i1311 avg @m.xdut.xadq.xch.xs1.xmp2.m0[id] from=0.25u to=0.5u
meas tran i1312 avg @m.xdut.xadq.xch.xs2.xmn1.m0[id] from=0.25u to=0.5u
meas tran i1313 avg @m.xdut.xadq.xch.xs2.xmn2.m0[id] from=0.25u to=0.5u
meas tran i1314 avg @m.xdut.xadq.xch.xs2.xmp1.m0[id] from=0.25u to=0.5u
meas tran i1315 avg @m.xdut.xadq.xch.xs2.xmp2.m0[id] from=0.25u to=0.5u
meas tran i1316 avg @m.xdut.xadq.xcl.xmt.m0[id] from=0.25u to=0.5u
meas tran i1317 avg @m.xdut.xadq.xcl.xm1.m0[id] from=0.25u to=0.5u
meas tran i1318 avg @m.xdut.xadq.xcl.xm2.m0[id] from=0.25u to=0.5u
meas tran i1319 avg @m.xdut.xadq.xcl.xm3.m0[id] from=0.25u to=0.5u
meas tran i1320 avg @m.xdut.xadq.xcl.xm4.m0[id] from=0.25u to=0.5u
meas tran i1321 avg @m.xdut.xadq.xcl.xm5.m0[id] from=0.25u to=0.5u
meas tran i1322 avg @m.xdut.xadq.xcl.xm6.m0[id] from=0.25u to=0.5u
meas tran i1323 avg @m.xdut.xadq.xcl.xm7.m0[id] from=0.25u to=0.5u
meas tran i1324 avg @m.xdut.xadq.xcl.xm8.m0[id] from=0.25u to=0.5u
meas tran i1325 avg @m.xdut.xadq.xcl.xm9.m0[id] from=0.25u to=0.5u
meas tran i1326 avg @m.xdut.xadq.xcl.xm10.m0[id] from=0.25u to=0.5u
meas tran i1327 avg @m.xdut.xadq.xcl.xm11.m0[id] from=0.25u to=0.5u
meas tran i1328 avg @m.xdut.xadq.xcl.xm12.m0[id] from=0.25u to=0.5u
meas tran i1329 avg @m.xdut.xadq.xcl.xi1.xmn.m0[id] from=0.25u to=0.5u
meas tran i1330 avg @m.xdut.xadq.xcl.xi1.xmp.m0[id] from=0.25u to=0.5u
meas tran i1331 avg @m.xdut.xadq.xcl.xi2.xmn.m0[id] from=0.25u to=0.5u
meas tran i1332 avg @m.xdut.xadq.xcl.xi2.xmp.m0[id] from=0.25u to=0.5u
meas tran i1333 avg @m.xdut.xadq.xcl.xs1.xmn1.m0[id] from=0.25u to=0.5u
meas tran i1334 avg @m.xdut.xadq.xcl.xs1.xmn2.m0[id] from=0.25u to=0.5u
meas tran i1335 avg @m.xdut.xadq.xcl.xs1.xmp1.m0[id] from=0.25u to=0.5u
meas tran i1336 avg @m.xdut.xadq.xcl.xs1.xmp2.m0[id] from=0.25u to=0.5u
meas tran i1337 avg @m.xdut.xadq.xcl.xs2.xmn1.m0[id] from=0.25u to=0.5u
meas tran i1338 avg @m.xdut.xadq.xcl.xs2.xmn2.m0[id] from=0.25u to=0.5u
meas tran i1339 avg @m.xdut.xadq.xcl.xs2.xmp1.m0[id] from=0.25u to=0.5u
meas tran i1340 avg @m.xdut.xadq.xcl.xs2.xmp2.m0[id] from=0.25u to=0.5u
meas tran i1341 avg @m.xdut.xadq.xm.xmn1.m0[id] from=0.25u to=0.5u
meas tran i1342 avg @m.xdut.xadq.xm.xmn2.m0[id] from=0.25u to=0.5u
meas tran i1343 avg @m.xdut.xadq.xm.xmp1.m0[id] from=0.25u to=0.5u
meas tran i1344 avg @m.xdut.xadq.xm.xmp2.m0[id] from=0.25u to=0.5u
meas tran i1345 avg @m.xdut.xcko1.xmn.m0[id] from=0.25u to=0.5u
meas tran i1346 avg @m.xdut.xcko1.xmp.m0[id] from=0.25u to=0.5u
meas tran i1347 avg @m.xdut.xcko2.xmn.m0[id] from=0.25u to=0.5u
meas tran i1348 avg @m.xdut.xcko2.xmp.m0[id] from=0.25u to=0.5u
meas tran i1349 avg @m.xdut.xafc.xa0.xmn.m0[id] from=0.25u to=0.5u
meas tran i1350 avg @m.xdut.xafc.xa0.xmp.m0[id] from=0.25u to=0.5u
meas tran i1351 avg @m.xdut.xafc.xb0.xmn.m0[id] from=0.25u to=0.5u
meas tran i1352 avg @m.xdut.xafc.xb0.xmp.m0[id] from=0.25u to=0.5u
meas tran i1353 avg @m.xdut.xafc.xa1.xmn.m0[id] from=0.25u to=0.5u
meas tran i1354 avg @m.xdut.xafc.xa1.xmp.m0[id] from=0.25u to=0.5u
meas tran i1355 avg @m.xdut.xafc.xb1.xmn.m0[id] from=0.25u to=0.5u
meas tran i1356 avg @m.xdut.xafc.xb1.xmp.m0[id] from=0.25u to=0.5u
meas tran i1357 avg @m.xdut.xafc.xa2.xmn.m0[id] from=0.25u to=0.5u
meas tran i1358 avg @m.xdut.xafc.xa2.xmp.m0[id] from=0.25u to=0.5u
meas tran i1359 avg @m.xdut.xafc.xb2.xmn.m0[id] from=0.25u to=0.5u
meas tran i1360 avg @m.xdut.xafc.xb2.xmp.m0[id] from=0.25u to=0.5u
meas tran i1361 avg @m.xdut.xafc.xa3.xmn.m0[id] from=0.25u to=0.5u
meas tran i1362 avg @m.xdut.xafc.xa3.xmp.m0[id] from=0.25u to=0.5u
meas tran i1363 avg @m.xdut.xafc.xb3.xmn.m0[id] from=0.25u to=0.5u
meas tran i1364 avg @m.xdut.xafc.xb3.xmp.m0[id] from=0.25u to=0.5u
meas tran i1365 avg @m.xdut.xafc.xa4.xmn.m0[id] from=0.25u to=0.5u
meas tran i1366 avg @m.xdut.xafc.xa4.xmp.m0[id] from=0.25u to=0.5u
meas tran i1367 avg @m.xdut.xafc.xb4.xmn.m0[id] from=0.25u to=0.5u
meas tran i1368 avg @m.xdut.xafc.xb4.xmp.m0[id] from=0.25u to=0.5u
meas tran i1369 avg @m.xdut.xafc.xa5.xmn.m0[id] from=0.25u to=0.5u
meas tran i1370 avg @m.xdut.xafc.xa5.xmp.m0[id] from=0.25u to=0.5u
meas tran i1371 avg @m.xdut.xafc.xb5.xmn.m0[id] from=0.25u to=0.5u
meas tran i1372 avg @m.xdut.xafc.xb5.xmp.m0[id] from=0.25u to=0.5u
meas tran i1373 avg @m.xdut.xafc.xa6.xmn.m0[id] from=0.25u to=0.5u
meas tran i1374 avg @m.xdut.xafc.xa6.xmp.m0[id] from=0.25u to=0.5u
meas tran i1375 avg @m.xdut.xafc.xb6.xmn.m0[id] from=0.25u to=0.5u
meas tran i1376 avg @m.xdut.xafc.xb6.xmp.m0[id] from=0.25u to=0.5u
meas tran i1377 avg @m.xdut.xafc.xa7.xmn.m0[id] from=0.25u to=0.5u
meas tran i1378 avg @m.xdut.xafc.xa7.xmp.m0[id] from=0.25u to=0.5u
meas tran i1379 avg @m.xdut.xafc.xb7.xmn.m0[id] from=0.25u to=0.5u
meas tran i1380 avg @m.xdut.xafc.xb7.xmp.m0[id] from=0.25u to=0.5u
meas tran i1381 avg @m.xdut.xdec.xmd0.m0[id] from=0.25u to=0.5u
meas tran i1382 avg @m.xdut.xdec.xmd1.m0[id] from=0.25u to=0.5u
meas tran i1383 avg @m.xdut.xdec.xmd2.m0[id] from=0.25u to=0.5u
meas tran i1384 avg @m.xdut.xdec.xmd3.m0[id] from=0.25u to=0.5u
meas tran i1385 avg @m.xdut.xdec.xmd4.m0[id] from=0.25u to=0.5u
meas tran i1386 avg @m.xdut.xdec.xmd5.m0[id] from=0.25u to=0.5u
meas tran i1387 avg @m.xdut.xdec.xmd6.m0[id] from=0.25u to=0.5u
meas tran i1388 avg @m.xdut.xdec.xmd7.m0[id] from=0.25u to=0.5u
meas tran i1389 avg @m.xdut.xdec.xmd8.m0[id] from=0.25u to=0.5u
meas tran i1390 avg @m.xdut.xdec.xmd9.m0[id] from=0.25u to=0.5u
meas tran i1391 avg @m.xdut.xdec.xmd10.m0[id] from=0.25u to=0.5u
meas tran i1392 avg @m.xdut.xdec.xmd11.m0[id] from=0.25u to=0.5u
meas tran i1393 avg @m.xdut.xdec.xmd12.m0[id] from=0.25u to=0.5u
.endc

**** end user architecture code
**.ends

* expanding   symbol:  gnss_afe_top.sym # of pins=15
** sym_path: /home/noritsuna/GPS/xschem/gnss_afe_top.sym
** sch_path: /home/noritsuna/GPS/xschem/gnss_afe_top.sch
.subckt gnss_afe_top RFIN REFIN SCLK SDI CS_N I_SIGN I_MAG Q_SIGN Q_MAG CLKOUT AFCOUT VCTRL VDDV VDD VSS
*.ipin RFIN
*.ipin REFIN
*.ipin SCLK
*.ipin SDI
*.ipin CS_N
*.opin I_SIGN
*.opin I_MAG
*.opin Q_SIGN
*.opin Q_MAG
*.opin CLKOUT
*.opin AFCOUT
*.opin VCTRL
*.iopin VDDV
*.iopin VDD
*.iopin VSS
XSPI SCLK SDI CS_N IG1A IG1B IG2A IG2B IG3A IG3B B0 B1 AFC0 AFC1 AFC2 AFC3 AFC4 AFC5 AFC6 AFC7 ICP2 VDD VSS spi_regs
XBIAS nb pb VDD VSS bias_gen
XVCO VCTRL B0 B1 nb l1p l1n l2p l2n l3p l3n l4p l4n ckr vr VDDV VSS vco_ring4
XRB REFIN refck VDDV VSS refbuf
XPLL refck ckr nb pb ICP2 VCTRL fs fb VDD VSS pll_core
XLNA RFIN pb rfp rfn VDD VSS lna_nc
XMIX rfp rfn l1p l1n l2p l2n l3p l3n l4p l4n nb mip min mqp mqn VDD VSS mixer_iq
XIFI mip min IG1A IG1B IG2A IG2B IG3A IG3B pb aip ain VDD VSS if_chain
XIFQ mqp mqn IG1A IG1B IG2A IG2B IG3A IG3B pb aqp aqn VDD VSS if_chain
XADI aip ain fs I_SIGN I_MAG VDD VSS adc2b
XADQ aqp aqn fs Q_SIGN Q_MAG VDD VSS adc2b
XCKO1 fs fsb VDD VSS inv_lo2
XCKO2 fsb CLKOUT VDD VSS inv_lo2
XAFC AFC0 AFC1 AFC2 AFC3 AFC4 AFC5 AFC6 AFC7 AFCOUT VDD VSS afc_dac
XDEC VDD VSS decap
.ends

* expanding   symbol:  spi_regs.sym # of pins=22
** sym_path: /home/noritsuna/GPS/xschem/spi_regs.sym
** sch_path: /home/noritsuna/GPS/xschem/spi_regs.sch
.subckt spi_regs SCLK SDI CS_N IG1A IG1B IG2A IG2B IG3A IG3B B0 B1 AFC0 AFC1 AFC2 AFC3 AFC4 AFC5 AFC6 AFC7 ICP2 VDD VSS
*.ipin SCLK
*.ipin SDI
*.ipin CS_N
*.opin IG1A
*.opin IG1B
*.opin IG2A
*.opin IG2B
*.opin IG3A
*.opin IG3B
*.opin B0
*.opin B1
*.opin AFC0
*.opin AFC1
*.opin AFC2
*.opin AFC3
*.opin AFC4
*.opin AFC5
*.opin AFC6
*.opin AFC7
*.opin ICP2
*.iopin VDD
*.iopin VSS
XRPU CS_N VDD VSS ppolyf_u_1k r_width=1u r_length=100u
XSCB SCLK sclkb VDD VSS inv_dig
XSCG CS_N sclkb sck VDD VSS nor2
XRPOR pr VDD VSS ppolyf_u_1k r_width=1u r_length=200u
XCPOR pr VSS cap_mim_2f0_m4m5_noshield c_width=70e-6 c_length=70e-6
XP1 pr por1 VDD VSS inv_dig
XP2 por1 por2 VDD VSS inv_dig
XP3 por2 rst VDD VSS inv_dig
XR0 SDI sck rst r0 VDD VSS dffr_s
XR1 r0 sck rst r1 VDD VSS dffr_s
XR2 r1 sck rst r2 VDD VSS dffr_s
XR3 r2 sck rst r3 VDD VSS dffr_s
XR4 r3 sck rst r4 VDD VSS dffr_s
XR5 r4 sck rst r5 VDD VSS dffr_s
XR6 r5 sck rst r6 VDD VSS dffr_s
XR7 r6 sck rst r7 VDD VSS dffr_s
XR8 r7 sck rst r8 VDD VSS dffr_s
XR9 r8 sck rst r9 VDD VSS dffr_s
XR10 r9 sck rst r10 VDD VSS dffr_s
XR11 r10 sck rst r11 VDD VSS dffr_s
XR12 r11 sck rst r12 VDD VSS dffr_s
XR13 r12 sck rst r13 VDD VSS dffr_s
XR14 r13 sck rst r14 VDD VSS dffr_s
XR15 r14 sck rst r15 VDD VSS dffr_s
XR16 r15 sck rst r16 VDD VSS dffr_s
XR17 r16 sck rst r17 VDD VSS dffr_s
XR18 r17 sck rst r18 VDD VSS dffr_s
XR19 r18 sck rst r19 VDD VSS dffr_s
XR20 r19 sck rst r20 VDD VSS dffr_s
XR21 r20 sck rst r21 VDD VSS dffr_s
XR22 r21 sck rst r22 VDD VSS dffr_s
XR23 r22 sck rst r23 VDD VSS dffr_s
XL0 r0 CS_N IG1A VDD VSS latch_s
XL1 r1 CS_N IG1B VDD VSS latch_s
XL2 r2 CS_N IG2A VDD VSS latch_s
XL3 r3 CS_N IG2B VDD VSS latch_s
XL4 r4 CS_N IG3A VDD VSS latch_s
XL5 r5 CS_N IG3B VDD VSS latch_s
XL6 r6 CS_N B0 VDD VSS latch_s
XL7 r7 CS_N B1 VDD VSS latch_s
XL8 r8 CS_N AFC0 VDD VSS latch_s
XL9 r9 CS_N AFC1 VDD VSS latch_s
XL10 r10 CS_N AFC2 VDD VSS latch_s
XL11 r11 CS_N AFC3 VDD VSS latch_s
XL12 r12 CS_N AFC4 VDD VSS latch_s
XL13 r13 CS_N AFC5 VDD VSS latch_s
XL14 r14 CS_N AFC6 VDD VSS latch_s
XL15 r15 CS_N afc7n VDD VSS latch_s
XAFC7 afc7n AFC7 VDD VSS inv_dig
XL16 r16 CS_N ICP2 VDD VSS latch_s
.ends

* expanding   symbol:  bias_gen.sym # of pins=4
** sym_path: /home/noritsuna/GPS/xschem/bias_gen.sym
** sch_path: /home/noritsuna/GPS/xschem/bias_gen.sch
.subckt bias_gen NB PB VDD VSS
*.opin NB
*.opin PB
*.iopin VDD
*.iopin VSS
XMN1 nbc nbc VSS VSS nfet_03v3 L=2u W=4u nf=1 ad='int((nf+1)/2) * W/nf * 0.18u' as='int((nf+2)/2) * W/nf * 0.18u' pd='2*int((nf+1)/2) * (W/nf + 0.18u)'  ps='2*int((nf+2)/2) * (W/nf + 0.18u)' nrd='0.18u / W' nrs='0.18u / W' sa=0 sb=0 sd=0 m=1 par=1
XMN2 pbc nbc nr VSS nfet_03v3 L=2u W=16u nf=2 ad='int((nf+1)/2) * W/nf * 0.18u' as='int((nf+2)/2) * W/nf * 0.18u' pd='2*int((nf+1)/2) * (W/nf + 0.18u)'  ps='2*int((nf+2)/2) * (W/nf + 0.18u)' nrd='0.18u / W' nrs='0.18u / W' sa=0 sb=0 sd=0 m=1 par=1
XRB VSS nr VSS ppolyf_u_1k r_width=1u r_length=4.6u
XMP1 nbc pbc VDD VDD pfet_03v3 L=2u W=8u nf=1 ad='int((nf+1)/2) * W/nf * 0.18u' as='int((nf+2)/2) * W/nf * 0.18u' pd='2*int((nf+1)/2) * (W/nf + 0.18u)'  ps='2*int((nf+2)/2) * (W/nf + 0.18u)' nrd='0.18u / W' nrs='0.18u / W' sa=0 sb=0 sd=0 m=1 par=1
XMP2 pbc pbc VDD VDD pfet_03v3 L=2u W=8u nf=1 ad='int((nf+1)/2) * W/nf * 0.18u' as='int((nf+2)/2) * W/nf * 0.18u' pd='2*int((nf+1)/2) * (W/nf + 0.18u)'  ps='2*int((nf+2)/2) * (W/nf + 0.18u)' nrd='0.18u / W' nrs='0.18u / W' sa=0 sb=0 sd=0 m=1 par=1
XMSP st VSS VDD VDD pfet_03v3 L=20u W=1u nf=1 ad='int((nf+1)/2) * W/nf * 0.18u' as='int((nf+2)/2) * W/nf * 0.18u' pd='2*int((nf+1)/2) * (W/nf + 0.18u)'  ps='2*int((nf+2)/2) * (W/nf + 0.18u)' nrd='0.18u / W' nrs='0.18u / W' sa=0 sb=0 sd=0 m=1 par=1
XMSN st nbc VSS VSS nfet_03v3 L=1u W=2u nf=1 ad='int((nf+1)/2) * W/nf * 0.18u' as='int((nf+2)/2) * W/nf * 0.18u' pd='2*int((nf+1)/2) * (W/nf + 0.18u)'  ps='2*int((nf+2)/2) * (W/nf + 0.18u)' nrd='0.18u / W' nrs='0.18u / W' sa=0 sb=0 sd=0 m=1 par=1
XMSU pbc st VSS VSS nfet_03v3 L=1u W=1u nf=1 ad='int((nf+1)/2) * W/nf * 0.18u' as='int((nf+2)/2) * W/nf * 0.18u' pd='2*int((nf+1)/2) * (W/nf + 0.18u)'  ps='2*int((nf+2)/2) * (W/nf + 0.18u)' nrd='0.18u / W' nrs='0.18u / W' sa=0 sb=0 sd=0 m=1 par=1
XMP3 NB pbc VDD VDD pfet_03v3 L=2u W=8u nf=1 ad='int((nf+1)/2) * W/nf * 0.18u' as='int((nf+2)/2) * W/nf * 0.18u' pd='2*int((nf+1)/2) * (W/nf + 0.18u)'  ps='2*int((nf+2)/2) * (W/nf + 0.18u)' nrd='0.18u / W' nrs='0.18u / W' sa=0 sb=0 sd=0 m=1 par=1
XMN3 NB NB VSS VSS nfet_03v3 L=2u W=16u nf=2 ad='int((nf+1)/2) * W/nf * 0.18u' as='int((nf+2)/2) * W/nf * 0.18u' pd='2*int((nf+1)/2) * (W/nf + 0.18u)'  ps='2*int((nf+2)/2) * (W/nf + 0.18u)' nrd='0.18u / W' nrs='0.18u / W' sa=0 sb=0 sd=0 m=1 par=1
XMN4 PB nbc VSS VSS nfet_03v3 L=2u W=4u nf=1 ad='int((nf+1)/2) * W/nf * 0.18u' as='int((nf+2)/2) * W/nf * 0.18u' pd='2*int((nf+1)/2) * (W/nf + 0.18u)'  ps='2*int((nf+2)/2) * (W/nf + 0.18u)' nrd='0.18u / W' nrs='0.18u / W' sa=0 sb=0 sd=0 m=1 par=1
XMP4 PB PB VDD VDD pfet_03v3 L=2u W=32u nf=4 ad='int((nf+1)/2) * W/nf * 0.18u' as='int((nf+2)/2) * W/nf * 0.18u' pd='2*int((nf+1)/2) * (W/nf + 0.18u)'  ps='2*int((nf+2)/2) * (W/nf + 0.18u)' nrd='0.18u / W' nrs='0.18u / W' sa=0 sb=0 sd=0 m=1 par=1
XCNB NB VSS cap_mim_2f0_m4m5_noshield c_width=20e-6 c_length=20e-6
XCPB VDD PB cap_mim_2f0_m4m5_noshield c_width=20e-6 c_length=20e-6
.ends

* expanding   symbol:  vco_ring4.sym # of pins=16
** sym_path: /home/noritsuna/GPS/xschem/vco_ring4.sym
** sch_path: /home/noritsuna/GPS/xschem/vco_ring4.sch
.subckt vco_ring4 VCTRL B0 B1 NB L1P L1N L2P L2N L3P L3N L4P L4N CK VR VDD VSS
*.ipin VCTRL
*.ipin B0
*.ipin B1
*.ipin NB
*.opin L1P
*.opin L1N
*.opin L2P
*.opin L2N
*.opin L3P
*.opin L3N
*.opin L4P
*.opin L4N
*.opin CK
*.opin VR
*.iopin VDD
*.iopin VSS
XMVI ng VCTRL ns VSS nfet_03v3 L=0.5u W=20u nf=4 ad='int((nf+1)/2) * W/nf * 0.18u' as='int((nf+2)/2) * W/nf * 0.18u' pd='2*int((nf+1)/2) * (W/nf + 0.18u)'  ps='2*int((nf+2)/2) * (W/nf + 0.18u)' nrd='0.18u / W' nrs='0.18u / W' sa=0 sb=0 sd=0 m=1 par=1
XRDEG VSS ns VSS ppolyf_u_1k r_width=2u r_length=4u
XMPD ng ng VDD VDD pfet_03v3 L=0.56u W=80u nf=16 ad='int((nf+1)/2) * W/nf * 0.18u' as='int((nf+2)/2) * W/nf * 0.18u' pd='2*int((nf+1)/2) * (W/nf + 0.18u)'  ps='2*int((nf+2)/2) * (W/nf + 0.18u)' nrd='0.18u / W' nrs='0.18u / W' sa=0 sb=0 sd=0 m=1 par=1
XMPO VR ng VDD VDD pfet_03v3 L=0.56u W=80u nf=16 ad='int((nf+1)/2) * W/nf * 0.18u' as='int((nf+2)/2) * W/nf * 0.18u' pd='2*int((nf+1)/2) * (W/nf + 0.18u)'  ps='2*int((nf+2)/2) * (W/nf + 0.18u)' nrd='0.18u / W' nrs='0.18u / W' sa=0 sb=0 sd=0 m=16 par=16
XMMIN ng NB VSS VSS nfet_03v3 L=2u W=12u nf=2 ad='int((nf+1)/2) * W/nf * 0.18u' as='int((nf+2)/2) * W/nf * 0.18u' pd='2*int((nf+1)/2) * (W/nf + 0.18u)'  ps='2*int((nf+2)/2) * (W/nf + 0.18u)' nrd='0.18u / W' nrs='0.18u / W' sa=0 sb=0 sd=0 m=1 par=1
XB0 B0 b0n VDD VSS inv_dig
XB1 B1 b1n VDD VSS inv_dig
XMPB0 nb0 ng VDD VDD pfet_03v3 L=0.56u W=80u nf=16 ad='int((nf+1)/2) * W/nf * 0.18u' as='int((nf+2)/2) * W/nf * 0.18u' pd='2*int((nf+1)/2) * (W/nf + 0.18u)'  ps='2*int((nf+2)/2) * (W/nf + 0.18u)' nrd='0.18u / W' nrs='0.18u / W' sa=0 sb=0 sd=0 m=12 par=12
XMSB0 VR b0n nb0 VDD pfet_03v3 L=0.28u W=40u nf=8 ad='int((nf+1)/2) * W/nf * 0.18u' as='int((nf+2)/2) * W/nf * 0.18u' pd='2*int((nf+1)/2) * (W/nf + 0.18u)'  ps='2*int((nf+2)/2) * (W/nf + 0.18u)' nrd='0.18u / W' nrs='0.18u / W' sa=0 sb=0 sd=0 m=12 par=12
XMPB1 nb1 ng VDD VDD pfet_03v3 L=0.56u W=80u nf=16 ad='int((nf+1)/2) * W/nf * 0.18u' as='int((nf+2)/2) * W/nf * 0.18u' pd='2*int((nf+1)/2) * (W/nf + 0.18u)'  ps='2*int((nf+2)/2) * (W/nf + 0.18u)' nrd='0.18u / W' nrs='0.18u / W' sa=0 sb=0 sd=0 m=24 par=24
XMSB1 VR b1n nb1 VDD pfet_03v3 L=0.28u W=40u nf=8 ad='int((nf+1)/2) * W/nf * 0.18u' as='int((nf+2)/2) * W/nf * 0.18u' pd='2*int((nf+1)/2) * (W/nf + 0.18u)'  ps='2*int((nf+2)/2) * (W/nf + 0.18u)' nrd='0.18u / W' nrs='0.18u / W' sa=0 sb=0 sd=0 m=24 par=24
XCVR VR VSS cap_mim_2f0_m4m5_noshield c_width=30e-6 c_length=30e-6
XCORE L1P L1N L2P L2N L3P L3N L4P L4N CK ckdn1 ckdp2 ckdn2 ckdp3 ckdn3 ckdp4 ckdn4 kh kl VR VSS vco_core
XSUA ckdp2 ckdn2 sua VR VSS nand2
XSUB ckdp2 ckdn2 sub VR VSS nor2
XSUAD1 CK ckdn1 suad1 VR VSS nand2
XSUBD1 CK ckdn1 subd1 VR VSS nor2
XSUAD3 ckdp3 ckdn3 suad3 VR VSS nand2
XSUBD3 ckdp3 ckdn3 subd3 VR VSS nor2
XSUAD4 ckdp4 ckdn4 suad4 VR VSS nand2
XSUBD4 ckdp4 ckdn4 subd4 VR VSS nor2
XRSUA fsua sua VSS ppolyf_u_1k r_width=1u r_length=100u
XCSUA fsua VSS cap_mim_2f0_m4m5_noshield c_width=5e-6 c_length=5e-6
XRSUB fsub sub VSS ppolyf_u_1k r_width=1u r_length=100u
XCSUB fsub VSS cap_mim_2f0_m4m5_noshield c_width=5e-6 c_length=5e-6
XSUA1 sua fsua kh VR VSS nor2
XSUA2 kh khn VR VSS inv_dig
XSUB1 sub fsub kln VR VSS nand2
XSUB2 kln kl VR VSS inv_dig
.ends

* expanding   symbol:  refbuf.sym # of pins=4
** sym_path: /home/noritsuna/GPS/xschem/refbuf.sym
** sch_path: /home/noritsuna/GPS/xschem/refbuf.sch
.subckt refbuf IN OUT VDD VSS
*.ipin IN
*.opin OUT
*.iopin VDD
*.iopin VSS
XCIN IN a cap_mim_2f0_m4m5_noshield c_width=20e-6 c_length=20e-6
XRF b a VSS ppolyf_u_1k r_width=1u r_length=200u
XMN1 b a VSS VSS nfet_03v3 L=0.28u W=2u nf=1 ad='int((nf+1)/2) * W/nf * 0.18u' as='int((nf+2)/2) * W/nf * 0.18u' pd='2*int((nf+1)/2) * (W/nf + 0.18u)'  ps='2*int((nf+2)/2) * (W/nf + 0.18u)' nrd='0.18u / W' nrs='0.18u / W' sa=0 sb=0 sd=0 m=1 par=1
XMP1 b a VDD VDD pfet_03v3 L=0.28u W=4u nf=1 ad='int((nf+1)/2) * W/nf * 0.18u' as='int((nf+2)/2) * W/nf * 0.18u' pd='2*int((nf+1)/2) * (W/nf + 0.18u)'  ps='2*int((nf+2)/2) * (W/nf + 0.18u)' nrd='0.18u / W' nrs='0.18u / W' sa=0 sb=0 sd=0 m=1 par=1
XMN2 OUT b VSS VSS nfet_03v3 L=0.28u W=2u nf=1 ad='int((nf+1)/2) * W/nf * 0.18u' as='int((nf+2)/2) * W/nf * 0.18u' pd='2*int((nf+1)/2) * (W/nf + 0.18u)'  ps='2*int((nf+2)/2) * (W/nf + 0.18u)' nrd='0.18u / W' nrs='0.18u / W' sa=0 sb=0 sd=0 m=1 par=1
XMP2 OUT b VDD VDD pfet_03v3 L=0.28u W=4u nf=1 ad='int((nf+1)/2) * W/nf * 0.18u' as='int((nf+2)/2) * W/nf * 0.18u' pd='2*int((nf+1)/2) * (W/nf + 0.18u)'  ps='2*int((nf+2)/2) * (W/nf + 0.18u)' nrd='0.18u / W' nrs='0.18u / W' sa=0 sb=0 sd=0 m=1 par=1
.ends

* expanding   symbol:  pll_core.sym # of pins=10
** sym_path: /home/noritsuna/GPS/xschem/pll_core.sym
** sch_path: /home/noritsuna/GPS/xschem/pll_core.sch
.subckt pll_core REFCK LO NB PB ICP2 VCTRL FS FB VDD VSS
*.ipin REFCK
*.ipin LO
*.ipin NB
*.ipin PB
*.ipin ICP2
*.opin VCTRL
*.opin FS
*.opin FB
*.iopin VDD
*.iopin VSS
XDB LO ck VDD VSS divbuf
XDIV ck FS FB VDD VSS div48
XRREF refck_i REFCK VSS ppolyf_u_1k r_width=2u r_length=2u
XMCLN refck_i tlo VSS VSS nfet_03v3 L=0.28u W=2u nf=1 ad='int((nf+1)/2) * W/nf * 0.18u' as='int((nf+2)/2) * W/nf * 0.18u' pd='2*int((nf+1)/2) * (W/nf + 0.18u)'  ps='2*int((nf+2)/2) * (W/nf + 0.18u)' nrd='0.18u / W' nrs='0.18u / W' sa=0 sb=0 sd=0 m=1 par=1
XMCLP refck_i thi VDD VDD pfet_03v3 L=0.28u W=2u nf=1 ad='int((nf+1)/2) * W/nf * 0.18u' as='int((nf+2)/2) * W/nf * 0.18u' pd='2*int((nf+1)/2) * (W/nf + 0.18u)'  ps='2*int((nf+2)/2) * (W/nf + 0.18u)' nrd='0.18u / W' nrs='0.18u / W' sa=0 sb=0 sd=0 m=1 par=1
XMTX tx tx VSS VSS nfet_03v3 L=0.28u W=1u nf=1 ad='int((nf+1)/2) * W/nf * 0.18u' as='int((nf+2)/2) * W/nf * 0.18u' pd='2*int((nf+1)/2) * (W/nf + 0.18u)'  ps='2*int((nf+2)/2) * (W/nf + 0.18u)' nrd='0.18u / W' nrs='0.18u / W' sa=0 sb=0 sd=0 m=1 par=1
XMTHI thi tx VDD VDD pfet_03v3 L=0.28u W=1u nf=1 ad='int((nf+1)/2) * W/nf * 0.18u' as='int((nf+2)/2) * W/nf * 0.18u' pd='2*int((nf+1)/2) * (W/nf + 0.18u)'  ps='2*int((nf+2)/2) * (W/nf + 0.18u)' nrd='0.18u / W' nrs='0.18u / W' sa=0 sb=0 sd=0 m=1 par=1
XMTLO tlo thi VSS VSS nfet_03v3 L=0.28u W=1u nf=1 ad='int((nf+1)/2) * W/nf * 0.18u' as='int((nf+2)/2) * W/nf * 0.18u' pd='2*int((nf+1)/2) * (W/nf + 0.18u)'  ps='2*int((nf+2)/2) * (W/nf + 0.18u)' nrd='0.18u / W' nrs='0.18u / W' sa=0 sb=0 sd=0 m=1 par=1
XPFD refck_i FB up upb dn dnb VDD VSS pfd
XCP upb dn dnb PB NB ICP2 vcp VDD VSS cp
XLF vcp VCTRL VSS loop_filter
.ends

* expanding   symbol:  lna_nc.sym # of pins=6
** sym_path: /home/noritsuna/GPS/xschem/lna_nc.sym
** sch_path: /home/noritsuna/GPS/xschem/lna_nc.sch
.subckt lna_nc RFIN PB OUTP OUTN VDD VSS
*.ipin RFIN
*.ipin PB
*.opin OUTP
*.opin OUTN
*.iopin VDD
*.iopin VSS
XM1 op_i vb1 RFIN VSS nfet_03v3 L=0.28u W=40u nf=8 ad='int((nf+1)/2) * W/nf * 0.18u' as='int((nf+2)/2) * W/nf * 0.18u' pd='2*int((nf+1)/2) * (W/nf + 0.18u)'  ps='2*int((nf+2)/2) * (W/nf + 0.18u)' nrd='0.18u / W' nrs='0.18u / W' sa=0 sb=0 sd=0 m=3 par=3
XRS VSS RFIN VSS ppolyf_u_1k r_width=10u r_length=3u
XR1 op_i VDD VSS ppolyf_u_1k r_width=10u r_length=2u
XCC2 RFIN g2 cap_mim_2f0_m4m5_noshield c_width=45e-6 c_length=45e-6
XRB2 vb2 g2 VSS ppolyf_u_1k r_width=1u r_length=10u
XM2 on_i g2 VSS VSS nfet_03v3 L=0.28u W=40u nf=8 ad='int((nf+1)/2) * W/nf * 0.18u' as='int((nf+2)/2) * W/nf * 0.18u' pd='2*int((nf+1)/2) * (W/nf + 0.18u)'  ps='2*int((nf+2)/2) * (W/nf + 0.18u)' nrd='0.18u / W' nrs='0.18u / W' sa=0 sb=0 sd=0 m=8 par=8
XR2 on_i VDD VSS ppolyf_u_1k r_width=15u r_length=1u
XMP1 vb1 PB VDD VDD pfet_03v3 L=2u W=32u nf=4 ad='int((nf+1)/2) * W/nf * 0.18u' as='int((nf+2)/2) * W/nf * 0.18u' pd='2*int((nf+1)/2) * (W/nf + 0.18u)'  ps='2*int((nf+2)/2) * (W/nf + 0.18u)' nrd='0.18u / W' nrs='0.18u / W' sa=0 sb=0 sd=0 m=6 par=6
XM1R vb1 vb1 s1r VSS nfet_03v3 L=0.28u W=12u nf=2 ad='int((nf+1)/2) * W/nf * 0.18u' as='int((nf+2)/2) * W/nf * 0.18u' pd='2*int((nf+1)/2) * (W/nf + 0.18u)'  ps='2*int((nf+2)/2) * (W/nf + 0.18u)' nrd='0.18u / W' nrs='0.18u / W' sa=0 sb=0 sd=0 m=1 par=1
XRSR VSS s1r VSS ppolyf_u_1k r_width=1u r_length=3u
XMP2 vb2 PB VDD VDD pfet_03v3 L=2u W=32u nf=4 ad='int((nf+1)/2) * W/nf * 0.18u' as='int((nf+2)/2) * W/nf * 0.18u' pd='2*int((nf+1)/2) * (W/nf + 0.18u)'  ps='2*int((nf+2)/2) * (W/nf + 0.18u)' nrd='0.18u / W' nrs='0.18u / W' sa=0 sb=0 sd=0 m=5 par=5
XM2R vb2 vb2 VSS VSS nfet_03v3 L=0.28u W=8u nf=2 ad='int((nf+1)/2) * W/nf * 0.18u' as='int((nf+2)/2) * W/nf * 0.18u' pd='2*int((nf+1)/2) * (W/nf + 0.18u)'  ps='2*int((nf+2)/2) * (W/nf + 0.18u)' nrd='0.18u / W' nrs='0.18u / W' sa=0 sb=0 sd=0 m=1 par=1
XCB1 vb1 VSS cap_mim_2f0_m4m5_noshield c_width=50e-6 c_length=50e-6
XCB2 vb2 VSS cap_mim_2f0_m4m5_noshield c_width=50e-6 c_length=50e-6
XCOP op_i OUTP cap_mim_2f0_m4m5_noshield c_width=45e-6 c_length=45e-6
XCON on_i OUTN cap_mim_2f0_m4m5_noshield c_width=45e-6 c_length=45e-6
.ends

* expanding   symbol:  mixer_iq.sym # of pins=17
** sym_path: /home/noritsuna/GPS/xschem/mixer_iq.sym
** sch_path: /home/noritsuna/GPS/xschem/mixer_iq.sch
.subckt mixer_iq RFP RFN L1P L1N L2P L2N L3P L3N L4P L4N NB IFIP IFIN IFQP IFQN VDD VSS
*.ipin RFP
*.ipin RFN
*.ipin L1P
*.ipin L1N
*.ipin L2P
*.ipin L2N
*.ipin L3P
*.ipin L3N
*.ipin L4P
*.ipin L4N
*.ipin NB
*.opin IFIP
*.opin IFIN
*.opin IFQP
*.opin IFQN
*.iopin VDD
*.iopin VSS
XRT1 vbrf RFP VSS ppolyf_u_1k r_width=1u r_length=5u
XRT2 vbrf RFN VSS ppolyf_u_1k r_width=1u r_length=5u
XRBA vbrf VDD VSS ppolyf_u_1k r_width=1u r_length=20u
XRBB VSS vbrf VSS ppolyf_u_1k r_width=1u r_length=13u
XCBRF vbrf VSS cap_mim_2f0_m4m5_noshield c_width=70e-6 c_length=70e-6
XRLUA vlou VDD VSS ppolyf_u_1k r_width=1u r_length=47u
XRLUB VSS vlou VSS ppolyf_u_1k r_width=1u r_length=56u
XCLOU vlou VSS cap_mim_2f0_m4m5_noshield c_width=50e-6 c_length=50e-6
XRLLA vlol VDD VSS ppolyf_u_1k r_width=1u r_length=65u
XRLLB VSS vlol VSS ppolyf_u_1k r_width=1u r_length=37u
XCLOL vlol VSS cap_mim_2f0_m4m5_noshield c_width=50e-6 c_length=50e-6
XCACL1P L1P gl1p cap_mim_2f0_m4m5_noshield c_width=31.6e-6 c_length=31.6e-6
XRACL1P vlou gl1p VSS ppolyf_u_1k r_width=1u r_length=20u
XCACL1N L1N gl1n cap_mim_2f0_m4m5_noshield c_width=31.6e-6 c_length=31.6e-6
XRACL1N vlou gl1n VSS ppolyf_u_1k r_width=1u r_length=20u
XCACL2P L2P gl2p cap_mim_2f0_m4m5_noshield c_width=31.6e-6 c_length=31.6e-6
XRACL2P vlou gl2p VSS ppolyf_u_1k r_width=1u r_length=20u
XCACL2N L2N gl2n cap_mim_2f0_m4m5_noshield c_width=31.6e-6 c_length=31.6e-6
XRACL2N vlou gl2n VSS ppolyf_u_1k r_width=1u r_length=20u
XCACL3P L3P gl3p cap_mim_2f0_m4m5_noshield c_width=31.6e-6 c_length=31.6e-6
XRACL3P vlol gl3p VSS ppolyf_u_1k r_width=1u r_length=20u
XCACL3N L3N gl3n cap_mim_2f0_m4m5_noshield c_width=31.6e-6 c_length=31.6e-6
XRACL3N vlol gl3n VSS ppolyf_u_1k r_width=1u r_length=20u
XCACL4P L4P gl4p cap_mim_2f0_m4m5_noshield c_width=31.6e-6 c_length=31.6e-6
XRACL4P vlol gl4p VSS ppolyf_u_1k r_width=1u r_length=20u
XCACL4N L4N gl4n cap_mim_2f0_m4m5_noshield c_width=31.6e-6 c_length=31.6e-6
XRACL4N vlol gl4n VSS ppolyf_u_1k r_width=1u r_length=20u
XMCTL1P VSS gl1p VSS VSS nfet_03v3 L=2u W=4.96u nf=1 ad='int((nf+1)/2) * W/nf * 0.18u' as='int((nf+2)/2) * W/nf * 0.18u' pd='2*int((nf+1)/2) * (W/nf + 0.18u)'  ps='2*int((nf+2)/2) * (W/nf + 0.18u)' nrd='0.18u / W' nrs='0.18u / W' sa=0 sb=0 sd=0 m=1 par=1
XMCTL1N VSS gl1n VSS VSS nfet_03v3 L=2u W=6.08u nf=1 ad='int((nf+1)/2) * W/nf * 0.18u' as='int((nf+2)/2) * W/nf * 0.18u' pd='2*int((nf+1)/2) * (W/nf + 0.18u)'  ps='2*int((nf+2)/2) * (W/nf + 0.18u)' nrd='0.18u / W' nrs='0.18u / W' sa=0 sb=0 sd=0 m=1 par=1
XMCTL2P VSS gl2p VSS VSS nfet_03v3 L=2u W=3.97u nf=1 ad='int((nf+1)/2) * W/nf * 0.18u' as='int((nf+2)/2) * W/nf * 0.18u' pd='2*int((nf+1)/2) * (W/nf + 0.18u)'  ps='2*int((nf+2)/2) * (W/nf + 0.18u)' nrd='0.18u / W' nrs='0.18u / W' sa=0 sb=0 sd=0 m=1 par=1
XMCTL2N VSS gl2n VSS VSS nfet_03v3 L=2u W=4.25u nf=1 ad='int((nf+1)/2) * W/nf * 0.18u' as='int((nf+2)/2) * W/nf * 0.18u' pd='2*int((nf+1)/2) * (W/nf + 0.18u)'  ps='2*int((nf+2)/2) * (W/nf + 0.18u)' nrd='0.18u / W' nrs='0.18u / W' sa=0 sb=0 sd=0 m=1 par=1
XMCTL3P VSS gl3p VSS VSS nfet_03v3 L=2u W=0.83u nf=1 ad='int((nf+1)/2) * W/nf * 0.18u' as='int((nf+2)/2) * W/nf * 0.18u' pd='2*int((nf+1)/2) * (W/nf + 0.18u)'  ps='2*int((nf+2)/2) * (W/nf + 0.18u)' nrd='0.18u / W' nrs='0.18u / W' sa=0 sb=0 sd=0 m=1 par=1
XMCTL3N VSS gl3n VSS VSS nfet_03v3 L=2u W=0.8u nf=1 ad='int((nf+1)/2) * W/nf * 0.18u' as='int((nf+2)/2) * W/nf * 0.18u' pd='2*int((nf+1)/2) * (W/nf + 0.18u)'  ps='2*int((nf+2)/2) * (W/nf + 0.18u)' nrd='0.18u / W' nrs='0.18u / W' sa=0 sb=0 sd=0 m=1 par=1
XMCTL4P VSS gl4p VSS VSS nfet_03v3 L=2u W=1.3u nf=1 ad='int((nf+1)/2) * W/nf * 0.18u' as='int((nf+2)/2) * W/nf * 0.18u' pd='2*int((nf+1)/2) * (W/nf + 0.18u)'  ps='2*int((nf+2)/2) * (W/nf + 0.18u)' nrd='0.18u / W' nrs='0.18u / W' sa=0 sb=0 sd=0 m=1 par=1
XMCTL4N VSS gl4n VSS VSS nfet_03v3 L=2u W=1.65u nf=1 ad='int((nf+1)/2) * W/nf * 0.18u' as='int((nf+2)/2) * W/nf * 0.18u' pd='2*int((nf+1)/2) * (W/nf + 0.18u)'  ps='2*int((nf+2)/2) * (W/nf + 0.18u)' nrd='0.18u / W' nrs='0.18u / W' sa=0 sb=0 sd=0 m=1 par=1
XMTI tI NB VSS VSS nfet_03v3 L=2u W=40u nf=4 ad='int((nf+1)/2) * W/nf * 0.18u' as='int((nf+2)/2) * W/nf * 0.18u' pd='2*int((nf+1)/2) * (W/nf + 0.18u)'  ps='2*int((nf+2)/2) * (W/nf + 0.18u)' nrd='0.18u / W' nrs='0.18u / W' sa=0 sb=0 sd=0 m=16 par=16
XMG1I xpI RFP tI VSS nfet_03v3 L=0.28u W=80u nf=16 ad='int((nf+1)/2) * W/nf * 0.18u' as='int((nf+2)/2) * W/nf * 0.18u' pd='2*int((nf+1)/2) * (W/nf + 0.18u)'  ps='2*int((nf+2)/2) * (W/nf + 0.18u)' nrd='0.18u / W' nrs='0.18u / W' sa=0 sb=0 sd=0 m=1 par=1
XMG2I xnI RFN tI VSS nfet_03v3 L=0.28u W=80u nf=16 ad='int((nf+1)/2) * W/nf * 0.18u' as='int((nf+2)/2) * W/nf * 0.18u' pd='2*int((nf+1)/2) * (W/nf + 0.18u)'  ps='2*int((nf+2)/2) * (W/nf + 0.18u)' nrd='0.18u / W' nrs='0.18u / W' sa=0 sb=0 sd=0 m=1 par=1
XMLApI mpaI gl3n xpI VSS nfet_03v3 L=0.28u W=40u nf=8 ad='int((nf+1)/2) * W/nf * 0.18u' as='int((nf+2)/2) * W/nf * 0.18u' pd='2*int((nf+1)/2) * (W/nf + 0.18u)'  ps='2*int((nf+2)/2) * (W/nf + 0.18u)' nrd='0.18u / W' nrs='0.18u / W' sa=0 sb=0 sd=0 m=1 par=1
XMLBpI mpbI gl3p xpI VSS nfet_03v3 L=0.28u W=40u nf=8 ad='int((nf+1)/2) * W/nf * 0.18u' as='int((nf+2)/2) * W/nf * 0.18u' pd='2*int((nf+1)/2) * (W/nf + 0.18u)'  ps='2*int((nf+2)/2) * (W/nf + 0.18u)' nrd='0.18u / W' nrs='0.18u / W' sa=0 sb=0 sd=0 m=1 par=1
XMU1pI IFIP gl1p mpaI VSS nfet_03v3 L=0.28u W=20u nf=4 ad='int((nf+1)/2) * W/nf * 0.18u' as='int((nf+2)/2) * W/nf * 0.18u' pd='2*int((nf+1)/2) * (W/nf + 0.18u)'  ps='2*int((nf+2)/2) * (W/nf + 0.18u)' nrd='0.18u / W' nrs='0.18u / W' sa=0 sb=0 sd=0 m=1 par=1
XMU2pI IFIN gl1n mpaI VSS nfet_03v3 L=0.28u W=20u nf=4 ad='int((nf+1)/2) * W/nf * 0.18u' as='int((nf+2)/2) * W/nf * 0.18u' pd='2*int((nf+1)/2) * (W/nf + 0.18u)'  ps='2*int((nf+2)/2) * (W/nf + 0.18u)' nrd='0.18u / W' nrs='0.18u / W' sa=0 sb=0 sd=0 m=1 par=1
XMU3pI IFIN gl1p mpbI VSS nfet_03v3 L=0.28u W=20u nf=4 ad='int((nf+1)/2) * W/nf * 0.18u' as='int((nf+2)/2) * W/nf * 0.18u' pd='2*int((nf+1)/2) * (W/nf + 0.18u)'  ps='2*int((nf+2)/2) * (W/nf + 0.18u)' nrd='0.18u / W' nrs='0.18u / W' sa=0 sb=0 sd=0 m=1 par=1
XMU4pI IFIP gl1n mpbI VSS nfet_03v3 L=0.28u W=20u nf=4 ad='int((nf+1)/2) * W/nf * 0.18u' as='int((nf+2)/2) * W/nf * 0.18u' pd='2*int((nf+1)/2) * (W/nf + 0.18u)'  ps='2*int((nf+2)/2) * (W/nf + 0.18u)' nrd='0.18u / W' nrs='0.18u / W' sa=0 sb=0 sd=0 m=1 par=1
XMLAnI mnaI gl3n xnI VSS nfet_03v3 L=0.28u W=40u nf=8 ad='int((nf+1)/2) * W/nf * 0.18u' as='int((nf+2)/2) * W/nf * 0.18u' pd='2*int((nf+1)/2) * (W/nf + 0.18u)'  ps='2*int((nf+2)/2) * (W/nf + 0.18u)' nrd='0.18u / W' nrs='0.18u / W' sa=0 sb=0 sd=0 m=1 par=1
XMLBnI mnbI gl3p xnI VSS nfet_03v3 L=0.28u W=40u nf=8 ad='int((nf+1)/2) * W/nf * 0.18u' as='int((nf+2)/2) * W/nf * 0.18u' pd='2*int((nf+1)/2) * (W/nf + 0.18u)'  ps='2*int((nf+2)/2) * (W/nf + 0.18u)' nrd='0.18u / W' nrs='0.18u / W' sa=0 sb=0 sd=0 m=1 par=1
XMU1nI IFIN gl1p mnaI VSS nfet_03v3 L=0.28u W=20u nf=4 ad='int((nf+1)/2) * W/nf * 0.18u' as='int((nf+2)/2) * W/nf * 0.18u' pd='2*int((nf+1)/2) * (W/nf + 0.18u)'  ps='2*int((nf+2)/2) * (W/nf + 0.18u)' nrd='0.18u / W' nrs='0.18u / W' sa=0 sb=0 sd=0 m=1 par=1
XMU2nI IFIP gl1n mnaI VSS nfet_03v3 L=0.28u W=20u nf=4 ad='int((nf+1)/2) * W/nf * 0.18u' as='int((nf+2)/2) * W/nf * 0.18u' pd='2*int((nf+1)/2) * (W/nf + 0.18u)'  ps='2*int((nf+2)/2) * (W/nf + 0.18u)' nrd='0.18u / W' nrs='0.18u / W' sa=0 sb=0 sd=0 m=1 par=1
XMU3nI IFIP gl1p mnbI VSS nfet_03v3 L=0.28u W=20u nf=4 ad='int((nf+1)/2) * W/nf * 0.18u' as='int((nf+2)/2) * W/nf * 0.18u' pd='2*int((nf+1)/2) * (W/nf + 0.18u)'  ps='2*int((nf+2)/2) * (W/nf + 0.18u)' nrd='0.18u / W' nrs='0.18u / W' sa=0 sb=0 sd=0 m=1 par=1
XMU4nI IFIN gl1n mnbI VSS nfet_03v3 L=0.28u W=20u nf=4 ad='int((nf+1)/2) * W/nf * 0.18u' as='int((nf+2)/2) * W/nf * 0.18u' pd='2*int((nf+1)/2) * (W/nf + 0.18u)'  ps='2*int((nf+2)/2) * (W/nf + 0.18u)' nrd='0.18u / W' nrs='0.18u / W' sa=0 sb=0 sd=0 m=1 par=1
XRL1I IFIP VDD VSS ppolyf_u_1k r_width=2u r_length=2.4u
XRL2I IFIN VDD VSS ppolyf_u_1k r_width=2u r_length=2.4u
XCL1I IFIP VSS cap_mim_2f0_m4m5_noshield c_width=45e-6 c_length=45e-6
XCL2I IFIN VSS cap_mim_2f0_m4m5_noshield c_width=45e-6 c_length=45e-6
XMTQ tQ NB VSS VSS nfet_03v3 L=2u W=40u nf=4 ad='int((nf+1)/2) * W/nf * 0.18u' as='int((nf+2)/2) * W/nf * 0.18u' pd='2*int((nf+1)/2) * (W/nf + 0.18u)'  ps='2*int((nf+2)/2) * (W/nf + 0.18u)' nrd='0.18u / W' nrs='0.18u / W' sa=0 sb=0 sd=0 m=16 par=16
XMG1Q xpQ RFP tQ VSS nfet_03v3 L=0.28u W=80u nf=16 ad='int((nf+1)/2) * W/nf * 0.18u' as='int((nf+2)/2) * W/nf * 0.18u' pd='2*int((nf+1)/2) * (W/nf + 0.18u)'  ps='2*int((nf+2)/2) * (W/nf + 0.18u)' nrd='0.18u / W' nrs='0.18u / W' sa=0 sb=0 sd=0 m=1 par=1
XMG2Q xnQ RFN tQ VSS nfet_03v3 L=0.28u W=80u nf=16 ad='int((nf+1)/2) * W/nf * 0.18u' as='int((nf+2)/2) * W/nf * 0.18u' pd='2*int((nf+1)/2) * (W/nf + 0.18u)'  ps='2*int((nf+2)/2) * (W/nf + 0.18u)' nrd='0.18u / W' nrs='0.18u / W' sa=0 sb=0 sd=0 m=1 par=1
XMLApQ mpaQ gl4n xpQ VSS nfet_03v3 L=0.28u W=40u nf=8 ad='int((nf+1)/2) * W/nf * 0.18u' as='int((nf+2)/2) * W/nf * 0.18u' pd='2*int((nf+1)/2) * (W/nf + 0.18u)'  ps='2*int((nf+2)/2) * (W/nf + 0.18u)' nrd='0.18u / W' nrs='0.18u / W' sa=0 sb=0 sd=0 m=1 par=1
XMLBpQ mpbQ gl4p xpQ VSS nfet_03v3 L=0.28u W=40u nf=8 ad='int((nf+1)/2) * W/nf * 0.18u' as='int((nf+2)/2) * W/nf * 0.18u' pd='2*int((nf+1)/2) * (W/nf + 0.18u)'  ps='2*int((nf+2)/2) * (W/nf + 0.18u)' nrd='0.18u / W' nrs='0.18u / W' sa=0 sb=0 sd=0 m=1 par=1
XMU1pQ IFQP gl2p mpaQ VSS nfet_03v3 L=0.28u W=20u nf=4 ad='int((nf+1)/2) * W/nf * 0.18u' as='int((nf+2)/2) * W/nf * 0.18u' pd='2*int((nf+1)/2) * (W/nf + 0.18u)'  ps='2*int((nf+2)/2) * (W/nf + 0.18u)' nrd='0.18u / W' nrs='0.18u / W' sa=0 sb=0 sd=0 m=1 par=1
XMU2pQ IFQN gl2n mpaQ VSS nfet_03v3 L=0.28u W=20u nf=4 ad='int((nf+1)/2) * W/nf * 0.18u' as='int((nf+2)/2) * W/nf * 0.18u' pd='2*int((nf+1)/2) * (W/nf + 0.18u)'  ps='2*int((nf+2)/2) * (W/nf + 0.18u)' nrd='0.18u / W' nrs='0.18u / W' sa=0 sb=0 sd=0 m=1 par=1
XMU3pQ IFQN gl2p mpbQ VSS nfet_03v3 L=0.28u W=20u nf=4 ad='int((nf+1)/2) * W/nf * 0.18u' as='int((nf+2)/2) * W/nf * 0.18u' pd='2*int((nf+1)/2) * (W/nf + 0.18u)'  ps='2*int((nf+2)/2) * (W/nf + 0.18u)' nrd='0.18u / W' nrs='0.18u / W' sa=0 sb=0 sd=0 m=1 par=1
XMU4pQ IFQP gl2n mpbQ VSS nfet_03v3 L=0.28u W=20u nf=4 ad='int((nf+1)/2) * W/nf * 0.18u' as='int((nf+2)/2) * W/nf * 0.18u' pd='2*int((nf+1)/2) * (W/nf + 0.18u)'  ps='2*int((nf+2)/2) * (W/nf + 0.18u)' nrd='0.18u / W' nrs='0.18u / W' sa=0 sb=0 sd=0 m=1 par=1
XMLAnQ mnaQ gl4n xnQ VSS nfet_03v3 L=0.28u W=40u nf=8 ad='int((nf+1)/2) * W/nf * 0.18u' as='int((nf+2)/2) * W/nf * 0.18u' pd='2*int((nf+1)/2) * (W/nf + 0.18u)'  ps='2*int((nf+2)/2) * (W/nf + 0.18u)' nrd='0.18u / W' nrs='0.18u / W' sa=0 sb=0 sd=0 m=1 par=1
XMLBnQ mnbQ gl4p xnQ VSS nfet_03v3 L=0.28u W=40u nf=8 ad='int((nf+1)/2) * W/nf * 0.18u' as='int((nf+2)/2) * W/nf * 0.18u' pd='2*int((nf+1)/2) * (W/nf + 0.18u)'  ps='2*int((nf+2)/2) * (W/nf + 0.18u)' nrd='0.18u / W' nrs='0.18u / W' sa=0 sb=0 sd=0 m=1 par=1
XMU1nQ IFQN gl2p mnaQ VSS nfet_03v3 L=0.28u W=20u nf=4 ad='int((nf+1)/2) * W/nf * 0.18u' as='int((nf+2)/2) * W/nf * 0.18u' pd='2*int((nf+1)/2) * (W/nf + 0.18u)'  ps='2*int((nf+2)/2) * (W/nf + 0.18u)' nrd='0.18u / W' nrs='0.18u / W' sa=0 sb=0 sd=0 m=1 par=1
XMU2nQ IFQP gl2n mnaQ VSS nfet_03v3 L=0.28u W=20u nf=4 ad='int((nf+1)/2) * W/nf * 0.18u' as='int((nf+2)/2) * W/nf * 0.18u' pd='2*int((nf+1)/2) * (W/nf + 0.18u)'  ps='2*int((nf+2)/2) * (W/nf + 0.18u)' nrd='0.18u / W' nrs='0.18u / W' sa=0 sb=0 sd=0 m=1 par=1
XMU3nQ IFQP gl2p mnbQ VSS nfet_03v3 L=0.28u W=20u nf=4 ad='int((nf+1)/2) * W/nf * 0.18u' as='int((nf+2)/2) * W/nf * 0.18u' pd='2*int((nf+1)/2) * (W/nf + 0.18u)'  ps='2*int((nf+2)/2) * (W/nf + 0.18u)' nrd='0.18u / W' nrs='0.18u / W' sa=0 sb=0 sd=0 m=1 par=1
XMU4nQ IFQN gl2n mnbQ VSS nfet_03v3 L=0.28u W=20u nf=4 ad='int((nf+1)/2) * W/nf * 0.18u' as='int((nf+2)/2) * W/nf * 0.18u' pd='2*int((nf+1)/2) * (W/nf + 0.18u)'  ps='2*int((nf+2)/2) * (W/nf + 0.18u)' nrd='0.18u / W' nrs='0.18u / W' sa=0 sb=0 sd=0 m=1 par=1
XRL1Q IFQP VDD VSS ppolyf_u_1k r_width=2u r_length=2.4u
XRL2Q IFQN VDD VSS ppolyf_u_1k r_width=2u r_length=2.4u
XCL1Q IFQP VSS cap_mim_2f0_m4m5_noshield c_width=45e-6 c_length=45e-6
XCL2Q IFQN VSS cap_mim_2f0_m4m5_noshield c_width=45e-6 c_length=45e-6
.ends

* expanding   symbol:  if_chain.sym # of pins=13
** sym_path: /home/noritsuna/GPS/xschem/if_chain.sym
** sch_path: /home/noritsuna/GPS/xschem/if_chain.sch
.subckt if_chain INP INN G1A G1B G2A G2B G3A G3B PB OUTP OUTN VDD VSS
*.ipin INP
*.ipin INN
*.ipin G1A
*.ipin G1B
*.ipin G2A
*.ipin G2B
*.ipin G3A
*.ipin G3B
*.ipin PB
*.opin OUTP
*.opin OUTN
*.iopin VDD
*.iopin VSS
XBIF PB nbif pbif VDD VSS bias_if
XV1 INP INN G1A G1B nbif a1p a1n VDD VSS vga
XF1 a1p a1n pbif f1p f1n VDD VSS sk_lpf1
XV2 f1p f1n G2A G2B nbif a2p a2n VDD VSS vga
XF2 a2p a2n pbif f2p f2n VDD VSS sk_lpf2
XV3 f2p f2n G3A G3B nbif a3p a3n VDD VSS vga
XV4 a3p a3n nbif a4p a4n VDD VSS vga_fix
XV5 a4p a4n nbif OUTP OUTN VDD VSS vga_fix
.ends

* expanding   symbol:  adc2b.sym # of pins=7
** sym_path: /home/noritsuna/GPS/xschem/adc2b.sym
** sch_path: /home/noritsuna/GPS/xschem/adc2b.sch
.subckt adc2b INP INN CLK SIGN MAG VDD VSS
*.ipin INP
*.ipin INN
*.ipin CLK
*.opin SIGN
*.opin MAG
*.iopin VDD
*.iopin VSS
XRL0 thp VDD VSS ppolyf_u_1k r_width=10u r_length=40.1u
XRL1 thm thp VSS ppolyf_u_1k r_width=10u r_length=1.4u
XRL2 thn thm VSS ppolyf_u_1k r_width=10u r_length=1.4u
XRL3 VSS thn VSS ppolyf_u_1k r_width=10u r_length=22.3u
XCT1 thp VSS cap_mim_2f0_m4m5_noshield c_width=50e-6 c_length=50e-6
XCT2 thm VSS cap_mim_2f0_m4m5_noshield c_width=50e-6 c_length=50e-6
XCT3 thn VSS cap_mim_2f0_m4m5_noshield c_width=50e-6 c_length=50e-6
XCS INP INN thm thm CLK SIGN sb VDD VSS sa_comp
XCH INP INN thp thn CLK qh qhb VDD VSS sa_comp
XCL INP INN thn thp CLK ql qlb VDD VSS sa_comp
XM qhb ql MAG VDD VSS nand2
.ends

* expanding   symbol:  inv_lo2.sym # of pins=4
** sym_path: /home/noritsuna/GPS/xschem/inv_lo2.sym
** sch_path: /home/noritsuna/GPS/xschem/inv_lo2.sch
.subckt inv_lo2 A Y VDD VSS
*.ipin A
*.opin Y
*.iopin VDD
*.iopin VSS
XMN Y A VSS VSS nfet_03v3 L=0.28u W=6u nf=2 ad='int((nf+1)/2) * W/nf * 0.18u' as='int((nf+2)/2) * W/nf * 0.18u' pd='2*int((nf+1)/2) * (W/nf + 0.18u)'  ps='2*int((nf+2)/2) * (W/nf + 0.18u)' nrd='0.18u / W' nrs='0.18u / W' sa=0 sb=0 sd=0 m=1 par=1
XMP Y A VDD VDD pfet_03v3 L=0.28u W=12u nf=4 ad='int((nf+1)/2) * W/nf * 0.18u' as='int((nf+2)/2) * W/nf * 0.18u' pd='2*int((nf+1)/2) * (W/nf + 0.18u)'  ps='2*int((nf+2)/2) * (W/nf + 0.18u)' nrd='0.18u / W' nrs='0.18u / W' sa=0 sb=0 sd=0 m=1 par=1
.ends

* expanding   symbol:  afc_dac.sym # of pins=11
** sym_path: /home/noritsuna/GPS/xschem/afc_dac.sym
** sch_path: /home/noritsuna/GPS/xschem/afc_dac.sch
.subckt afc_dac D0 D1 D2 D3 D4 D5 D6 D7 OUT VDD VSS
*.ipin D0
*.ipin D1
*.ipin D2
*.ipin D3
*.ipin D4
*.ipin D5
*.ipin D6
*.ipin D7
*.opin OUT
*.iopin VDD
*.iopin VSS
XRT VSS n0 VSS ppolyf_u_1k r_width=1u r_length=20u
XA0 D0 db0 VDD VSS inv_dig
XB0 db0 dr0 VDD VSS inv_dac
XR2_0 n0 dr0 VSS ppolyf_u_1k r_width=1u r_length=20u
XR1_0 n1 n0 VSS ppolyf_u_1k r_width=1u r_length=10u
XA1 D1 db1 VDD VSS inv_dig
XB1 db1 dr1 VDD VSS inv_dac
XR2_1 n1 dr1 VSS ppolyf_u_1k r_width=1u r_length=20u
XR1_1 n2 n1 VSS ppolyf_u_1k r_width=1u r_length=10u
XA2 D2 db2 VDD VSS inv_dig
XB2 db2 dr2 VDD VSS inv_dac
XR2_2 n2 dr2 VSS ppolyf_u_1k r_width=1u r_length=20u
XR1_2 n3 n2 VSS ppolyf_u_1k r_width=1u r_length=10u
XA3 D3 db3 VDD VSS inv_dig
XB3 db3 dr3 VDD VSS inv_dac
XR2_3 n3 dr3 VSS ppolyf_u_1k r_width=1u r_length=20u
XR1_3 n4 n3 VSS ppolyf_u_1k r_width=1u r_length=10u
XA4 D4 db4 VDD VSS inv_dig
XB4 db4 dr4 VDD VSS inv_dac
XR2_4 n4 dr4 VSS ppolyf_u_1k r_width=1u r_length=20u
XR1_4 n5 n4 VSS ppolyf_u_1k r_width=1u r_length=10u
XA5 D5 db5 VDD VSS inv_dig
XB5 db5 dr5 VDD VSS inv_dac
XR2_5 n5 dr5 VSS ppolyf_u_1k r_width=1u r_length=20u
XR1_5 n6 n5 VSS ppolyf_u_1k r_width=1u r_length=10u
XA6 D6 db6 VDD VSS inv_dig
XB6 db6 dr6 VDD VSS inv_dac
XR2_6 n6 dr6 VSS ppolyf_u_1k r_width=1u r_length=20u
XR1_6 OUT n6 VSS ppolyf_u_1k r_width=1u r_length=10u
XA7 D7 db7 VDD VSS inv_dig
XB7 db7 dr7 VDD VSS inv_dac
XR2_7 OUT dr7 VSS ppolyf_u_1k r_width=1u r_length=20u
.ends

* expanding   symbol:  decap.sym # of pins=2
** sym_path: /home/noritsuna/GPS/xschem/decap.sym
** sch_path: /home/noritsuna/GPS/xschem/decap.sch
.subckt decap VDD VSS
*.iopin VDD
*.iopin VSS
XMD0 VSS VDD VSS VSS nfet_03v3 L=5u W=480u nf=16 ad='int((nf+1)/2) * W/nf * 0.18u' as='int((nf+2)/2) * W/nf * 0.18u' pd='2*int((nf+1)/2) * (W/nf + 0.18u)'  ps='2*int((nf+2)/2) * (W/nf + 0.18u)' nrd='0.18u / W' nrs='0.18u / W' sa=0 sb=0 sd=0 m=1 par=1
XMD1 VSS VDD VSS VSS nfet_03v3 L=5u W=480u nf=16 ad='int((nf+1)/2) * W/nf * 0.18u' as='int((nf+2)/2) * W/nf * 0.18u' pd='2*int((nf+1)/2) * (W/nf + 0.18u)'  ps='2*int((nf+2)/2) * (W/nf + 0.18u)' nrd='0.18u / W' nrs='0.18u / W' sa=0 sb=0 sd=0 m=1 par=1
XMD2 VSS VDD VSS VSS nfet_03v3 L=5u W=480u nf=16 ad='int((nf+1)/2) * W/nf * 0.18u' as='int((nf+2)/2) * W/nf * 0.18u' pd='2*int((nf+1)/2) * (W/nf + 0.18u)'  ps='2*int((nf+2)/2) * (W/nf + 0.18u)' nrd='0.18u / W' nrs='0.18u / W' sa=0 sb=0 sd=0 m=1 par=1
XMD3 VSS VDD VSS VSS nfet_03v3 L=5u W=480u nf=16 ad='int((nf+1)/2) * W/nf * 0.18u' as='int((nf+2)/2) * W/nf * 0.18u' pd='2*int((nf+1)/2) * (W/nf + 0.18u)'  ps='2*int((nf+2)/2) * (W/nf + 0.18u)' nrd='0.18u / W' nrs='0.18u / W' sa=0 sb=0 sd=0 m=1 par=1
XMD4 VSS VDD VSS VSS nfet_03v3 L=5u W=480u nf=16 ad='int((nf+1)/2) * W/nf * 0.18u' as='int((nf+2)/2) * W/nf * 0.18u' pd='2*int((nf+1)/2) * (W/nf + 0.18u)'  ps='2*int((nf+2)/2) * (W/nf + 0.18u)' nrd='0.18u / W' nrs='0.18u / W' sa=0 sb=0 sd=0 m=1 par=1
XMD5 VSS VDD VSS VSS nfet_03v3 L=5u W=480u nf=16 ad='int((nf+1)/2) * W/nf * 0.18u' as='int((nf+2)/2) * W/nf * 0.18u' pd='2*int((nf+1)/2) * (W/nf + 0.18u)'  ps='2*int((nf+2)/2) * (W/nf + 0.18u)' nrd='0.18u / W' nrs='0.18u / W' sa=0 sb=0 sd=0 m=1 par=1
XMD6 VSS VDD VSS VSS nfet_03v3 L=5u W=480u nf=16 ad='int((nf+1)/2) * W/nf * 0.18u' as='int((nf+2)/2) * W/nf * 0.18u' pd='2*int((nf+1)/2) * (W/nf + 0.18u)'  ps='2*int((nf+2)/2) * (W/nf + 0.18u)' nrd='0.18u / W' nrs='0.18u / W' sa=0 sb=0 sd=0 m=1 par=1
XMD7 VSS VDD VSS VSS nfet_03v3 L=5u W=480u nf=16 ad='int((nf+1)/2) * W/nf * 0.18u' as='int((nf+2)/2) * W/nf * 0.18u' pd='2*int((nf+1)/2) * (W/nf + 0.18u)'  ps='2*int((nf+2)/2) * (W/nf + 0.18u)' nrd='0.18u / W' nrs='0.18u / W' sa=0 sb=0 sd=0 m=1 par=1
XMD8 VSS VDD VSS VSS nfet_03v3 L=5u W=480u nf=16 ad='int((nf+1)/2) * W/nf * 0.18u' as='int((nf+2)/2) * W/nf * 0.18u' pd='2*int((nf+1)/2) * (W/nf + 0.18u)'  ps='2*int((nf+2)/2) * (W/nf + 0.18u)' nrd='0.18u / W' nrs='0.18u / W' sa=0 sb=0 sd=0 m=1 par=1
XMD9 VSS VDD VSS VSS nfet_03v3 L=5u W=480u nf=16 ad='int((nf+1)/2) * W/nf * 0.18u' as='int((nf+2)/2) * W/nf * 0.18u' pd='2*int((nf+1)/2) * (W/nf + 0.18u)'  ps='2*int((nf+2)/2) * (W/nf + 0.18u)' nrd='0.18u / W' nrs='0.18u / W' sa=0 sb=0 sd=0 m=1 par=1
XMD10 VSS VDD VSS VSS nfet_03v3 L=5u W=480u nf=16 ad='int((nf+1)/2) * W/nf * 0.18u' as='int((nf+2)/2) * W/nf * 0.18u' pd='2*int((nf+1)/2) * (W/nf + 0.18u)'  ps='2*int((nf+2)/2) * (W/nf + 0.18u)' nrd='0.18u / W' nrs='0.18u / W' sa=0 sb=0 sd=0 m=1 par=1
XMD11 VSS VDD VSS VSS nfet_03v3 L=5u W=480u nf=16 ad='int((nf+1)/2) * W/nf * 0.18u' as='int((nf+2)/2) * W/nf * 0.18u' pd='2*int((nf+1)/2) * (W/nf + 0.18u)'  ps='2*int((nf+2)/2) * (W/nf + 0.18u)' nrd='0.18u / W' nrs='0.18u / W' sa=0 sb=0 sd=0 m=1 par=1
XMD12 VSS VDD VSS VSS nfet_03v3 L=5u W=480u nf=16 ad='int((nf+1)/2) * W/nf * 0.18u' as='int((nf+2)/2) * W/nf * 0.18u' pd='2*int((nf+1)/2) * (W/nf + 0.18u)'  ps='2*int((nf+2)/2) * (W/nf + 0.18u)' nrd='0.18u / W' nrs='0.18u / W' sa=0 sb=0 sd=0 m=1 par=1
.ends

* expanding   symbol:  inv_dig.sym # of pins=4
** sym_path: /home/noritsuna/GPS/xschem/inv_dig.sym
** sch_path: /home/noritsuna/GPS/xschem/inv_dig.sch
.subckt inv_dig A Y VDD VSS
*.ipin A
*.opin Y
*.iopin VDD
*.iopin VSS
XMN Y A VSS VSS nfet_03v3 L=0.28u W=1u nf=1 ad='int((nf+1)/2) * W/nf * 0.18u' as='int((nf+2)/2) * W/nf * 0.18u' pd='2*int((nf+1)/2) * (W/nf + 0.18u)'  ps='2*int((nf+2)/2) * (W/nf + 0.18u)' nrd='0.18u / W' nrs='0.18u / W' sa=0 sb=0 sd=0 m=1 par=1
XMP Y A VDD VDD pfet_03v3 L=0.28u W=2u nf=1 ad='int((nf+1)/2) * W/nf * 0.18u' as='int((nf+2)/2) * W/nf * 0.18u' pd='2*int((nf+1)/2) * (W/nf + 0.18u)'  ps='2*int((nf+2)/2) * (W/nf + 0.18u)' nrd='0.18u / W' nrs='0.18u / W' sa=0 sb=0 sd=0 m=1 par=1
.ends

* expanding   symbol:  nor2.sym # of pins=5
** sym_path: /home/noritsuna/GPS/xschem/nor2.sym
** sch_path: /home/noritsuna/GPS/xschem/nor2.sch
.subckt nor2 A B Y VDD VSS
*.ipin A
*.ipin B
*.opin Y
*.iopin VDD
*.iopin VSS
XMN1 Y A VSS VSS nfet_03v3 L=0.28u W=1u nf=1 ad='int((nf+1)/2) * W/nf * 0.18u' as='int((nf+2)/2) * W/nf * 0.18u' pd='2*int((nf+1)/2) * (W/nf + 0.18u)'  ps='2*int((nf+2)/2) * (W/nf + 0.18u)' nrd='0.18u / W' nrs='0.18u / W' sa=0 sb=0 sd=0 m=1 par=1
XMN2 Y B VSS VSS nfet_03v3 L=0.28u W=1u nf=1 ad='int((nf+1)/2) * W/nf * 0.18u' as='int((nf+2)/2) * W/nf * 0.18u' pd='2*int((nf+1)/2) * (W/nf + 0.18u)'  ps='2*int((nf+2)/2) * (W/nf + 0.18u)' nrd='0.18u / W' nrs='0.18u / W' sa=0 sb=0 sd=0 m=1 par=1
XMP1 n1 A VDD VDD pfet_03v3 L=0.28u W=4u nf=1 ad='int((nf+1)/2) * W/nf * 0.18u' as='int((nf+2)/2) * W/nf * 0.18u' pd='2*int((nf+1)/2) * (W/nf + 0.18u)'  ps='2*int((nf+2)/2) * (W/nf + 0.18u)' nrd='0.18u / W' nrs='0.18u / W' sa=0 sb=0 sd=0 m=1 par=1
XMP2 Y B n1 VDD pfet_03v3 L=0.28u W=4u nf=1 ad='int((nf+1)/2) * W/nf * 0.18u' as='int((nf+2)/2) * W/nf * 0.18u' pd='2*int((nf+1)/2) * (W/nf + 0.18u)'  ps='2*int((nf+2)/2) * (W/nf + 0.18u)' nrd='0.18u / W' nrs='0.18u / W' sa=0 sb=0 sd=0 m=1 par=1
.ends

* expanding   symbol:  dffr_s.sym # of pins=6
** sym_path: /home/noritsuna/GPS/xschem/dffr_s.sym
** sch_path: /home/noritsuna/GPS/xschem/dffr_s.sch
.subckt dffr_s D CK RST Q VDD VSS
*.ipin D
*.ipin CK
*.ipin RST
*.opin Q
*.iopin VDD
*.iopin VSS
XCI CK ckb VDD VSS inv_dig
XT1N D ckb m VSS nfet_03v3 L=0.28u W=1u nf=1 ad='int((nf+1)/2) * W/nf * 0.18u' as='int((nf+2)/2) * W/nf * 0.18u' pd='2*int((nf+1)/2) * (W/nf + 0.18u)'  ps='2*int((nf+2)/2) * (W/nf + 0.18u)' nrd='0.18u / W' nrs='0.18u / W' sa=0 sb=0 sd=0 m=1 par=1
XT1P D CK m VDD pfet_03v3 L=0.28u W=2u nf=1 ad='int((nf+1)/2) * W/nf * 0.18u' as='int((nf+2)/2) * W/nf * 0.18u' pd='2*int((nf+1)/2) * (W/nf + 0.18u)'  ps='2*int((nf+2)/2) * (W/nf + 0.18u)' nrd='0.18u / W' nrs='0.18u / W' sa=0 sb=0 sd=0 m=1 par=1
XM m RST mb VDD VSS nor2
XMF mb mf VDD VSS inv_dig
XT2N mf CK m VSS nfet_03v3 L=0.28u W=1u nf=1 ad='int((nf+1)/2) * W/nf * 0.18u' as='int((nf+2)/2) * W/nf * 0.18u' pd='2*int((nf+1)/2) * (W/nf + 0.18u)'  ps='2*int((nf+2)/2) * (W/nf + 0.18u)' nrd='0.18u / W' nrs='0.18u / W' sa=0 sb=0 sd=0 m=1 par=1
XT2P mf ckb m VDD pfet_03v3 L=0.28u W=2u nf=1 ad='int((nf+1)/2) * W/nf * 0.18u' as='int((nf+2)/2) * W/nf * 0.18u' pd='2*int((nf+1)/2) * (W/nf + 0.18u)'  ps='2*int((nf+2)/2) * (W/nf + 0.18u)' nrd='0.18u / W' nrs='0.18u / W' sa=0 sb=0 sd=0 m=1 par=1
XT3N mb CK sl VSS nfet_03v3 L=0.28u W=1u nf=1 ad='int((nf+1)/2) * W/nf * 0.18u' as='int((nf+2)/2) * W/nf * 0.18u' pd='2*int((nf+1)/2) * (W/nf + 0.18u)'  ps='2*int((nf+2)/2) * (W/nf + 0.18u)' nrd='0.18u / W' nrs='0.18u / W' sa=0 sb=0 sd=0 m=1 par=1
XT3P mb ckb sl VDD pfet_03v3 L=0.28u W=2u nf=1 ad='int((nf+1)/2) * W/nf * 0.18u' as='int((nf+2)/2) * W/nf * 0.18u' pd='2*int((nf+1)/2) * (W/nf + 0.18u)'  ps='2*int((nf+2)/2) * (W/nf + 0.18u)' nrd='0.18u / W' nrs='0.18u / W' sa=0 sb=0 sd=0 m=1 par=1
XS sl RST Q VDD VSS nor2
XSF Q sf VDD VSS inv_dig
XT4N sf ckb sl VSS nfet_03v3 L=0.28u W=1u nf=1 ad='int((nf+1)/2) * W/nf * 0.18u' as='int((nf+2)/2) * W/nf * 0.18u' pd='2*int((nf+1)/2) * (W/nf + 0.18u)'  ps='2*int((nf+2)/2) * (W/nf + 0.18u)' nrd='0.18u / W' nrs='0.18u / W' sa=0 sb=0 sd=0 m=1 par=1
XT4P sf CK sl VDD pfet_03v3 L=0.28u W=2u nf=1 ad='int((nf+1)/2) * W/nf * 0.18u' as='int((nf+2)/2) * W/nf * 0.18u' pd='2*int((nf+1)/2) * (W/nf + 0.18u)'  ps='2*int((nf+2)/2) * (W/nf + 0.18u)' nrd='0.18u / W' nrs='0.18u / W' sa=0 sb=0 sd=0 m=1 par=1
.ends

* expanding   symbol:  latch_s.sym # of pins=5
** sym_path: /home/noritsuna/GPS/xschem/latch_s.sym
** sch_path: /home/noritsuna/GPS/xschem/latch_s.sch
.subckt latch_s D EN Q VDD VSS
*.ipin D
*.ipin EN
*.opin Q
*.iopin VDD
*.iopin VSS
XEI EN enb VDD VSS inv_dig
XTIN D EN l VSS nfet_03v3 L=0.28u W=1u nf=1 ad='int((nf+1)/2) * W/nf * 0.18u' as='int((nf+2)/2) * W/nf * 0.18u' pd='2*int((nf+1)/2) * (W/nf + 0.18u)'  ps='2*int((nf+2)/2) * (W/nf + 0.18u)' nrd='0.18u / W' nrs='0.18u / W' sa=0 sb=0 sd=0 m=1 par=1
XTIP D enb l VDD pfet_03v3 L=0.28u W=2u nf=1 ad='int((nf+1)/2) * W/nf * 0.18u' as='int((nf+2)/2) * W/nf * 0.18u' pd='2*int((nf+1)/2) * (W/nf + 0.18u)'  ps='2*int((nf+2)/2) * (W/nf + 0.18u)' nrd='0.18u / W' nrs='0.18u / W' sa=0 sb=0 sd=0 m=1 par=1
X1 l lb VDD VSS inv_dig
X2 lb Q VDD VSS inv_dig
XTFN Q enb l VSS nfet_03v3 L=0.28u W=1u nf=1 ad='int((nf+1)/2) * W/nf * 0.18u' as='int((nf+2)/2) * W/nf * 0.18u' pd='2*int((nf+1)/2) * (W/nf + 0.18u)'  ps='2*int((nf+2)/2) * (W/nf + 0.18u)' nrd='0.18u / W' nrs='0.18u / W' sa=0 sb=0 sd=0 m=1 par=1
XTFP Q EN l VDD pfet_03v3 L=0.28u W=2u nf=1 ad='int((nf+1)/2) * W/nf * 0.18u' as='int((nf+2)/2) * W/nf * 0.18u' pd='2*int((nf+1)/2) * (W/nf + 0.18u)'  ps='2*int((nf+2)/2) * (W/nf + 0.18u)' nrd='0.18u / W' nrs='0.18u / W' sa=0 sb=0 sd=0 m=1 par=1
.ends

* expanding   symbol:  vco_core.sym # of pins=20
** sym_path: /home/noritsuna/GPS/xschem/vco_core.sym
** sch_path: /home/noritsuna/GPS/xschem/vco_core.sch
.subckt vco_core L1P L1N L2P L2N L3P L3N L4P L4N CK ckdn1 ckdp2 ckdn2 ckdp3 ckdn3 ckdp4 ckdn4 kh kl VR VSS
*.opin L1P
*.opin L1N
*.opin L2P
*.opin L2N
*.opin L3P
*.opin L3N
*.opin L4P
*.opin L4N
*.opin CK
*.opin ckdn1
*.opin ckdp2
*.opin ckdn2
*.opin ckdp3
*.opin ckdn3
*.opin ckdp4
*.opin ckdn4
*.ipin kh
*.ipin kl
*.iopin VR
*.iopin VSS
XMNa1 n1 p4 VSS VSS nfet_03v3 L=0.28u W=16u nf=4 ad='int((nf+1)/2) * W/nf * 0.18u' as='int((nf+2)/2) * W/nf * 0.18u' pd='2*int((nf+1)/2) * (W/nf + 0.18u)'  ps='2*int((nf+2)/2) * (W/nf + 0.18u)' nrd='0.18u / W' nrs='0.18u / W' sa=0 sb=0 sd=0 m=1 par=1
XMNb1 p1 n4 VSS VSS nfet_03v3 L=0.28u W=16u nf=4 ad='int((nf+1)/2) * W/nf * 0.18u' as='int((nf+2)/2) * W/nf * 0.18u' pd='2*int((nf+1)/2) * (W/nf + 0.18u)'  ps='2*int((nf+2)/2) * (W/nf + 0.18u)' nrd='0.18u / W' nrs='0.18u / W' sa=0 sb=0 sd=0 m=1 par=1
XMPa1 n1 p4 VR VR pfet_03v3 L=0.28u W=24u nf=8 ad='int((nf+1)/2) * W/nf * 0.18u' as='int((nf+2)/2) * W/nf * 0.18u' pd='2*int((nf+1)/2) * (W/nf + 0.18u)'  ps='2*int((nf+2)/2) * (W/nf + 0.18u)' nrd='0.18u / W' nrs='0.18u / W' sa=0 sb=0 sd=0 m=1 par=1
XMPb1 p1 n4 VR VR pfet_03v3 L=0.28u W=24u nf=8 ad='int((nf+1)/2) * W/nf * 0.18u' as='int((nf+2)/2) * W/nf * 0.18u' pd='2*int((nf+1)/2) * (W/nf + 0.18u)'  ps='2*int((nf+2)/2) * (W/nf + 0.18u)' nrd='0.18u / W' nrs='0.18u / W' sa=0 sb=0 sd=0 m=1 par=1
XMNc1 n1 p1 VSS VSS nfet_03v3 L=0.28u W=6u nf=2 ad='int((nf+1)/2) * W/nf * 0.18u' as='int((nf+2)/2) * W/nf * 0.18u' pd='2*int((nf+1)/2) * (W/nf + 0.18u)'  ps='2*int((nf+2)/2) * (W/nf + 0.18u)' nrd='0.18u / W' nrs='0.18u / W' sa=0 sb=0 sd=0 m=1 par=1
XMNd1 p1 n1 VSS VSS nfet_03v3 L=0.28u W=6u nf=2 ad='int((nf+1)/2) * W/nf * 0.18u' as='int((nf+2)/2) * W/nf * 0.18u' pd='2*int((nf+1)/2) * (W/nf + 0.18u)'  ps='2*int((nf+2)/2) * (W/nf + 0.18u)' nrd='0.18u / W' nrs='0.18u / W' sa=0 sb=0 sd=0 m=1 par=1
XMPc1 n1 p1 VR VR pfet_03v3 L=0.28u W=12u nf=4 ad='int((nf+1)/2) * W/nf * 0.18u' as='int((nf+2)/2) * W/nf * 0.18u' pd='2*int((nf+1)/2) * (W/nf + 0.18u)'  ps='2*int((nf+2)/2) * (W/nf + 0.18u)' nrd='0.18u / W' nrs='0.18u / W' sa=0 sb=0 sd=0 m=1 par=1
XMPd1 p1 n1 VR VR pfet_03v3 L=0.28u W=12u nf=4 ad='int((nf+1)/2) * W/nf * 0.18u' as='int((nf+2)/2) * W/nf * 0.18u' pd='2*int((nf+1)/2) * (W/nf + 0.18u)'  ps='2*int((nf+2)/2) * (W/nf + 0.18u)' nrd='0.18u / W' nrs='0.18u / W' sa=0 sb=0 sd=0 m=1 par=1
XMNa2 n2 p1 VSS VSS nfet_03v3 L=0.28u W=16u nf=4 ad='int((nf+1)/2) * W/nf * 0.18u' as='int((nf+2)/2) * W/nf * 0.18u' pd='2*int((nf+1)/2) * (W/nf + 0.18u)'  ps='2*int((nf+2)/2) * (W/nf + 0.18u)' nrd='0.18u / W' nrs='0.18u / W' sa=0 sb=0 sd=0 m=1 par=1
XMNb2 p2 n1 VSS VSS nfet_03v3 L=0.28u W=16u nf=4 ad='int((nf+1)/2) * W/nf * 0.18u' as='int((nf+2)/2) * W/nf * 0.18u' pd='2*int((nf+1)/2) * (W/nf + 0.18u)'  ps='2*int((nf+2)/2) * (W/nf + 0.18u)' nrd='0.18u / W' nrs='0.18u / W' sa=0 sb=0 sd=0 m=1 par=1
XMPa2 n2 p1 VR VR pfet_03v3 L=0.28u W=24u nf=8 ad='int((nf+1)/2) * W/nf * 0.18u' as='int((nf+2)/2) * W/nf * 0.18u' pd='2*int((nf+1)/2) * (W/nf + 0.18u)'  ps='2*int((nf+2)/2) * (W/nf + 0.18u)' nrd='0.18u / W' nrs='0.18u / W' sa=0 sb=0 sd=0 m=1 par=1
XMPb2 p2 n1 VR VR pfet_03v3 L=0.28u W=24u nf=8 ad='int((nf+1)/2) * W/nf * 0.18u' as='int((nf+2)/2) * W/nf * 0.18u' pd='2*int((nf+1)/2) * (W/nf + 0.18u)'  ps='2*int((nf+2)/2) * (W/nf + 0.18u)' nrd='0.18u / W' nrs='0.18u / W' sa=0 sb=0 sd=0 m=1 par=1
XMNc2 n2 p2 VSS VSS nfet_03v3 L=0.28u W=6u nf=2 ad='int((nf+1)/2) * W/nf * 0.18u' as='int((nf+2)/2) * W/nf * 0.18u' pd='2*int((nf+1)/2) * (W/nf + 0.18u)'  ps='2*int((nf+2)/2) * (W/nf + 0.18u)' nrd='0.18u / W' nrs='0.18u / W' sa=0 sb=0 sd=0 m=1 par=1
XMNd2 p2 n2 VSS VSS nfet_03v3 L=0.28u W=6u nf=2 ad='int((nf+1)/2) * W/nf * 0.18u' as='int((nf+2)/2) * W/nf * 0.18u' pd='2*int((nf+1)/2) * (W/nf + 0.18u)'  ps='2*int((nf+2)/2) * (W/nf + 0.18u)' nrd='0.18u / W' nrs='0.18u / W' sa=0 sb=0 sd=0 m=1 par=1
XMPc2 n2 p2 VR VR pfet_03v3 L=0.28u W=12u nf=4 ad='int((nf+1)/2) * W/nf * 0.18u' as='int((nf+2)/2) * W/nf * 0.18u' pd='2*int((nf+1)/2) * (W/nf + 0.18u)'  ps='2*int((nf+2)/2) * (W/nf + 0.18u)' nrd='0.18u / W' nrs='0.18u / W' sa=0 sb=0 sd=0 m=1 par=1
XMPd2 p2 n2 VR VR pfet_03v3 L=0.28u W=12u nf=4 ad='int((nf+1)/2) * W/nf * 0.18u' as='int((nf+2)/2) * W/nf * 0.18u' pd='2*int((nf+1)/2) * (W/nf + 0.18u)'  ps='2*int((nf+2)/2) * (W/nf + 0.18u)' nrd='0.18u / W' nrs='0.18u / W' sa=0 sb=0 sd=0 m=1 par=1
XMNa3 n3 p2 VSS VSS nfet_03v3 L=0.28u W=16u nf=4 ad='int((nf+1)/2) * W/nf * 0.18u' as='int((nf+2)/2) * W/nf * 0.18u' pd='2*int((nf+1)/2) * (W/nf + 0.18u)'  ps='2*int((nf+2)/2) * (W/nf + 0.18u)' nrd='0.18u / W' nrs='0.18u / W' sa=0 sb=0 sd=0 m=1 par=1
XMNb3 p3 n2 VSS VSS nfet_03v3 L=0.28u W=16u nf=4 ad='int((nf+1)/2) * W/nf * 0.18u' as='int((nf+2)/2) * W/nf * 0.18u' pd='2*int((nf+1)/2) * (W/nf + 0.18u)'  ps='2*int((nf+2)/2) * (W/nf + 0.18u)' nrd='0.18u / W' nrs='0.18u / W' sa=0 sb=0 sd=0 m=1 par=1
XMPa3 n3 p2 VR VR pfet_03v3 L=0.28u W=24u nf=8 ad='int((nf+1)/2) * W/nf * 0.18u' as='int((nf+2)/2) * W/nf * 0.18u' pd='2*int((nf+1)/2) * (W/nf + 0.18u)'  ps='2*int((nf+2)/2) * (W/nf + 0.18u)' nrd='0.18u / W' nrs='0.18u / W' sa=0 sb=0 sd=0 m=1 par=1
XMPb3 p3 n2 VR VR pfet_03v3 L=0.28u W=24u nf=8 ad='int((nf+1)/2) * W/nf * 0.18u' as='int((nf+2)/2) * W/nf * 0.18u' pd='2*int((nf+1)/2) * (W/nf + 0.18u)'  ps='2*int((nf+2)/2) * (W/nf + 0.18u)' nrd='0.18u / W' nrs='0.18u / W' sa=0 sb=0 sd=0 m=1 par=1
XMNc3 n3 p3 VSS VSS nfet_03v3 L=0.28u W=6u nf=2 ad='int((nf+1)/2) * W/nf * 0.18u' as='int((nf+2)/2) * W/nf * 0.18u' pd='2*int((nf+1)/2) * (W/nf + 0.18u)'  ps='2*int((nf+2)/2) * (W/nf + 0.18u)' nrd='0.18u / W' nrs='0.18u / W' sa=0 sb=0 sd=0 m=1 par=1
XMNd3 p3 n3 VSS VSS nfet_03v3 L=0.28u W=6u nf=2 ad='int((nf+1)/2) * W/nf * 0.18u' as='int((nf+2)/2) * W/nf * 0.18u' pd='2*int((nf+1)/2) * (W/nf + 0.18u)'  ps='2*int((nf+2)/2) * (W/nf + 0.18u)' nrd='0.18u / W' nrs='0.18u / W' sa=0 sb=0 sd=0 m=1 par=1
XMPc3 n3 p3 VR VR pfet_03v3 L=0.28u W=12u nf=4 ad='int((nf+1)/2) * W/nf * 0.18u' as='int((nf+2)/2) * W/nf * 0.18u' pd='2*int((nf+1)/2) * (W/nf + 0.18u)'  ps='2*int((nf+2)/2) * (W/nf + 0.18u)' nrd='0.18u / W' nrs='0.18u / W' sa=0 sb=0 sd=0 m=1 par=1
XMPd3 p3 n3 VR VR pfet_03v3 L=0.28u W=12u nf=4 ad='int((nf+1)/2) * W/nf * 0.18u' as='int((nf+2)/2) * W/nf * 0.18u' pd='2*int((nf+1)/2) * (W/nf + 0.18u)'  ps='2*int((nf+2)/2) * (W/nf + 0.18u)' nrd='0.18u / W' nrs='0.18u / W' sa=0 sb=0 sd=0 m=1 par=1
XMNa4 p4 p3 VSS VSS nfet_03v3 L=0.28u W=16u nf=4 ad='int((nf+1)/2) * W/nf * 0.18u' as='int((nf+2)/2) * W/nf * 0.18u' pd='2*int((nf+1)/2) * (W/nf + 0.18u)'  ps='2*int((nf+2)/2) * (W/nf + 0.18u)' nrd='0.18u / W' nrs='0.18u / W' sa=0 sb=0 sd=0 m=1 par=1
XMNb4 n4 n3 VSS VSS nfet_03v3 L=0.28u W=16u nf=4 ad='int((nf+1)/2) * W/nf * 0.18u' as='int((nf+2)/2) * W/nf * 0.18u' pd='2*int((nf+1)/2) * (W/nf + 0.18u)'  ps='2*int((nf+2)/2) * (W/nf + 0.18u)' nrd='0.18u / W' nrs='0.18u / W' sa=0 sb=0 sd=0 m=1 par=1
XMPa4 p4 p3 VR VR pfet_03v3 L=0.28u W=24u nf=8 ad='int((nf+1)/2) * W/nf * 0.18u' as='int((nf+2)/2) * W/nf * 0.18u' pd='2*int((nf+1)/2) * (W/nf + 0.18u)'  ps='2*int((nf+2)/2) * (W/nf + 0.18u)' nrd='0.18u / W' nrs='0.18u / W' sa=0 sb=0 sd=0 m=1 par=1
XMPb4 n4 n3 VR VR pfet_03v3 L=0.28u W=24u nf=8 ad='int((nf+1)/2) * W/nf * 0.18u' as='int((nf+2)/2) * W/nf * 0.18u' pd='2*int((nf+1)/2) * (W/nf + 0.18u)'  ps='2*int((nf+2)/2) * (W/nf + 0.18u)' nrd='0.18u / W' nrs='0.18u / W' sa=0 sb=0 sd=0 m=1 par=1
XMNc4 p4 n4 VSS VSS nfet_03v3 L=0.28u W=6u nf=2 ad='int((nf+1)/2) * W/nf * 0.18u' as='int((nf+2)/2) * W/nf * 0.18u' pd='2*int((nf+1)/2) * (W/nf + 0.18u)'  ps='2*int((nf+2)/2) * (W/nf + 0.18u)' nrd='0.18u / W' nrs='0.18u / W' sa=0 sb=0 sd=0 m=1 par=1
XMNd4 n4 p4 VSS VSS nfet_03v3 L=0.28u W=6u nf=2 ad='int((nf+1)/2) * W/nf * 0.18u' as='int((nf+2)/2) * W/nf * 0.18u' pd='2*int((nf+1)/2) * (W/nf + 0.18u)'  ps='2*int((nf+2)/2) * (W/nf + 0.18u)' nrd='0.18u / W' nrs='0.18u / W' sa=0 sb=0 sd=0 m=1 par=1
XMPc4 p4 n4 VR VR pfet_03v3 L=0.28u W=12u nf=4 ad='int((nf+1)/2) * W/nf * 0.18u' as='int((nf+2)/2) * W/nf * 0.18u' pd='2*int((nf+1)/2) * (W/nf + 0.18u)'  ps='2*int((nf+2)/2) * (W/nf + 0.18u)' nrd='0.18u / W' nrs='0.18u / W' sa=0 sb=0 sd=0 m=1 par=1
XMPd4 n4 p4 VR VR pfet_03v3 L=0.28u W=12u nf=4 ad='int((nf+1)/2) * W/nf * 0.18u' as='int((nf+2)/2) * W/nf * 0.18u' pd='2*int((nf+1)/2) * (W/nf + 0.18u)'  ps='2*int((nf+2)/2) * (W/nf + 0.18u)' nrd='0.18u / W' nrs='0.18u / W' sa=0 sb=0 sd=0 m=1 par=1
XMBNp1 ap1 p1 VSS VSS nfet_03v3 L=0.28u W=2u nf=1 ad='int((nf+1)/2) * W/nf * 0.18u' as='int((nf+2)/2) * W/nf * 0.18u' pd='2*int((nf+1)/2) * (W/nf + 0.18u)'  ps='2*int((nf+2)/2) * (W/nf + 0.18u)' nrd='0.18u / W' nrs='0.18u / W' sa=0 sb=0 sd=0 m=1 par=1
XMBPp1 ap1 p1 VR VR pfet_03v3 L=0.28u W=4u nf=1 ad='int((nf+1)/2) * W/nf * 0.18u' as='int((nf+2)/2) * W/nf * 0.18u' pd='2*int((nf+1)/2) * (W/nf + 0.18u)'  ps='2*int((nf+2)/2) * (W/nf + 0.18u)' nrd='0.18u / W' nrs='0.18u / W' sa=0 sb=0 sd=0 m=1 par=1
XMDNp1 L1P ap1 VSS VSS nfet_03v3 L=0.28u W=12u nf=4 ad='int((nf+1)/2) * W/nf * 0.18u' as='int((nf+2)/2) * W/nf * 0.18u' pd='2*int((nf+1)/2) * (W/nf + 0.18u)'  ps='2*int((nf+2)/2) * (W/nf + 0.18u)' nrd='0.18u / W' nrs='0.18u / W' sa=0 sb=0 sd=0 m=1 par=1
XMDPp1 L1P ap1 VR VR pfet_03v3 L=0.28u W=24u nf=8 ad='int((nf+1)/2) * W/nf * 0.18u' as='int((nf+2)/2) * W/nf * 0.18u' pd='2*int((nf+1)/2) * (W/nf + 0.18u)'  ps='2*int((nf+2)/2) * (W/nf + 0.18u)' nrd='0.18u / W' nrs='0.18u / W' sa=0 sb=0 sd=0 m=1 par=1
XMCNp1 CK L1P VSS VSS nfet_03v3 L=0.28u W=2u nf=1 ad='int((nf+1)/2) * W/nf * 0.18u' as='int((nf+2)/2) * W/nf * 0.18u' pd='2*int((nf+1)/2) * (W/nf + 0.18u)'  ps='2*int((nf+2)/2) * (W/nf + 0.18u)' nrd='0.18u / W' nrs='0.18u / W' sa=0 sb=0 sd=0 m=1 par=1
XMCPp1 CK L1P VR VR pfet_03v3 L=0.28u W=4u nf=1 ad='int((nf+1)/2) * W/nf * 0.18u' as='int((nf+2)/2) * W/nf * 0.18u' pd='2*int((nf+1)/2) * (W/nf + 0.18u)'  ps='2*int((nf+2)/2) * (W/nf + 0.18u)' nrd='0.18u / W' nrs='0.18u / W' sa=0 sb=0 sd=0 m=1 par=1
XMBNn1 an1 n1 VSS VSS nfet_03v3 L=0.28u W=2u nf=1 ad='int((nf+1)/2) * W/nf * 0.18u' as='int((nf+2)/2) * W/nf * 0.18u' pd='2*int((nf+1)/2) * (W/nf + 0.18u)'  ps='2*int((nf+2)/2) * (W/nf + 0.18u)' nrd='0.18u / W' nrs='0.18u / W' sa=0 sb=0 sd=0 m=1 par=1
XMBPn1 an1 n1 VR VR pfet_03v3 L=0.28u W=4u nf=1 ad='int((nf+1)/2) * W/nf * 0.18u' as='int((nf+2)/2) * W/nf * 0.18u' pd='2*int((nf+1)/2) * (W/nf + 0.18u)'  ps='2*int((nf+2)/2) * (W/nf + 0.18u)' nrd='0.18u / W' nrs='0.18u / W' sa=0 sb=0 sd=0 m=1 par=1
XMDNn1 L1N an1 VSS VSS nfet_03v3 L=0.28u W=12u nf=4 ad='int((nf+1)/2) * W/nf * 0.18u' as='int((nf+2)/2) * W/nf * 0.18u' pd='2*int((nf+1)/2) * (W/nf + 0.18u)'  ps='2*int((nf+2)/2) * (W/nf + 0.18u)' nrd='0.18u / W' nrs='0.18u / W' sa=0 sb=0 sd=0 m=1 par=1
XMDPn1 L1N an1 VR VR pfet_03v3 L=0.28u W=24u nf=8 ad='int((nf+1)/2) * W/nf * 0.18u' as='int((nf+2)/2) * W/nf * 0.18u' pd='2*int((nf+1)/2) * (W/nf + 0.18u)'  ps='2*int((nf+2)/2) * (W/nf + 0.18u)' nrd='0.18u / W' nrs='0.18u / W' sa=0 sb=0 sd=0 m=1 par=1
XMCNn1 ckdn1 L1N VSS VSS nfet_03v3 L=0.28u W=2u nf=1 ad='int((nf+1)/2) * W/nf * 0.18u' as='int((nf+2)/2) * W/nf * 0.18u' pd='2*int((nf+1)/2) * (W/nf + 0.18u)'  ps='2*int((nf+2)/2) * (W/nf + 0.18u)' nrd='0.18u / W' nrs='0.18u / W' sa=0 sb=0 sd=0 m=1 par=1
XMCPn1 ckdn1 L1N VR VR pfet_03v3 L=0.28u W=4u nf=1 ad='int((nf+1)/2) * W/nf * 0.18u' as='int((nf+2)/2) * W/nf * 0.18u' pd='2*int((nf+1)/2) * (W/nf + 0.18u)'  ps='2*int((nf+2)/2) * (W/nf + 0.18u)' nrd='0.18u / W' nrs='0.18u / W' sa=0 sb=0 sd=0 m=1 par=1
XMBNp2 ap2 p2 VSS VSS nfet_03v3 L=0.28u W=2u nf=1 ad='int((nf+1)/2) * W/nf * 0.18u' as='int((nf+2)/2) * W/nf * 0.18u' pd='2*int((nf+1)/2) * (W/nf + 0.18u)'  ps='2*int((nf+2)/2) * (W/nf + 0.18u)' nrd='0.18u / W' nrs='0.18u / W' sa=0 sb=0 sd=0 m=1 par=1
XMBPp2 ap2 p2 VR VR pfet_03v3 L=0.28u W=4u nf=1 ad='int((nf+1)/2) * W/nf * 0.18u' as='int((nf+2)/2) * W/nf * 0.18u' pd='2*int((nf+1)/2) * (W/nf + 0.18u)'  ps='2*int((nf+2)/2) * (W/nf + 0.18u)' nrd='0.18u / W' nrs='0.18u / W' sa=0 sb=0 sd=0 m=1 par=1
XMDNp2 L2P ap2 VSS VSS nfet_03v3 L=0.28u W=12u nf=4 ad='int((nf+1)/2) * W/nf * 0.18u' as='int((nf+2)/2) * W/nf * 0.18u' pd='2*int((nf+1)/2) * (W/nf + 0.18u)'  ps='2*int((nf+2)/2) * (W/nf + 0.18u)' nrd='0.18u / W' nrs='0.18u / W' sa=0 sb=0 sd=0 m=1 par=1
XMDPp2 L2P ap2 VR VR pfet_03v3 L=0.28u W=24u nf=8 ad='int((nf+1)/2) * W/nf * 0.18u' as='int((nf+2)/2) * W/nf * 0.18u' pd='2*int((nf+1)/2) * (W/nf + 0.18u)'  ps='2*int((nf+2)/2) * (W/nf + 0.18u)' nrd='0.18u / W' nrs='0.18u / W' sa=0 sb=0 sd=0 m=1 par=1
XMCNp2 ckdp2 L2P VSS VSS nfet_03v3 L=0.28u W=2u nf=1 ad='int((nf+1)/2) * W/nf * 0.18u' as='int((nf+2)/2) * W/nf * 0.18u' pd='2*int((nf+1)/2) * (W/nf + 0.18u)'  ps='2*int((nf+2)/2) * (W/nf + 0.18u)' nrd='0.18u / W' nrs='0.18u / W' sa=0 sb=0 sd=0 m=1 par=1
XMCPp2 ckdp2 L2P VR VR pfet_03v3 L=0.28u W=4u nf=1 ad='int((nf+1)/2) * W/nf * 0.18u' as='int((nf+2)/2) * W/nf * 0.18u' pd='2*int((nf+1)/2) * (W/nf + 0.18u)'  ps='2*int((nf+2)/2) * (W/nf + 0.18u)' nrd='0.18u / W' nrs='0.18u / W' sa=0 sb=0 sd=0 m=1 par=1
XMBNn2 an2 n2 VSS VSS nfet_03v3 L=0.28u W=2u nf=1 ad='int((nf+1)/2) * W/nf * 0.18u' as='int((nf+2)/2) * W/nf * 0.18u' pd='2*int((nf+1)/2) * (W/nf + 0.18u)'  ps='2*int((nf+2)/2) * (W/nf + 0.18u)' nrd='0.18u / W' nrs='0.18u / W' sa=0 sb=0 sd=0 m=1 par=1
XMBPn2 an2 n2 VR VR pfet_03v3 L=0.28u W=4u nf=1 ad='int((nf+1)/2) * W/nf * 0.18u' as='int((nf+2)/2) * W/nf * 0.18u' pd='2*int((nf+1)/2) * (W/nf + 0.18u)'  ps='2*int((nf+2)/2) * (W/nf + 0.18u)' nrd='0.18u / W' nrs='0.18u / W' sa=0 sb=0 sd=0 m=1 par=1
XMDNn2 L2N an2 VSS VSS nfet_03v3 L=0.28u W=12u nf=4 ad='int((nf+1)/2) * W/nf * 0.18u' as='int((nf+2)/2) * W/nf * 0.18u' pd='2*int((nf+1)/2) * (W/nf + 0.18u)'  ps='2*int((nf+2)/2) * (W/nf + 0.18u)' nrd='0.18u / W' nrs='0.18u / W' sa=0 sb=0 sd=0 m=1 par=1
XMDPn2 L2N an2 VR VR pfet_03v3 L=0.28u W=24u nf=8 ad='int((nf+1)/2) * W/nf * 0.18u' as='int((nf+2)/2) * W/nf * 0.18u' pd='2*int((nf+1)/2) * (W/nf + 0.18u)'  ps='2*int((nf+2)/2) * (W/nf + 0.18u)' nrd='0.18u / W' nrs='0.18u / W' sa=0 sb=0 sd=0 m=1 par=1
XMCNn2 ckdn2 L2N VSS VSS nfet_03v3 L=0.28u W=2u nf=1 ad='int((nf+1)/2) * W/nf * 0.18u' as='int((nf+2)/2) * W/nf * 0.18u' pd='2*int((nf+1)/2) * (W/nf + 0.18u)'  ps='2*int((nf+2)/2) * (W/nf + 0.18u)' nrd='0.18u / W' nrs='0.18u / W' sa=0 sb=0 sd=0 m=1 par=1
XMCPn2 ckdn2 L2N VR VR pfet_03v3 L=0.28u W=4u nf=1 ad='int((nf+1)/2) * W/nf * 0.18u' as='int((nf+2)/2) * W/nf * 0.18u' pd='2*int((nf+1)/2) * (W/nf + 0.18u)'  ps='2*int((nf+2)/2) * (W/nf + 0.18u)' nrd='0.18u / W' nrs='0.18u / W' sa=0 sb=0 sd=0 m=1 par=1
XMBNp3 ap3 p3 VSS VSS nfet_03v3 L=0.28u W=2u nf=1 ad='int((nf+1)/2) * W/nf * 0.18u' as='int((nf+2)/2) * W/nf * 0.18u' pd='2*int((nf+1)/2) * (W/nf + 0.18u)'  ps='2*int((nf+2)/2) * (W/nf + 0.18u)' nrd='0.18u / W' nrs='0.18u / W' sa=0 sb=0 sd=0 m=1 par=1
XMBPp3 ap3 p3 VR VR pfet_03v3 L=0.28u W=4u nf=1 ad='int((nf+1)/2) * W/nf * 0.18u' as='int((nf+2)/2) * W/nf * 0.18u' pd='2*int((nf+1)/2) * (W/nf + 0.18u)'  ps='2*int((nf+2)/2) * (W/nf + 0.18u)' nrd='0.18u / W' nrs='0.18u / W' sa=0 sb=0 sd=0 m=1 par=1
XMDNp3 L3P ap3 VSS VSS nfet_03v3 L=0.28u W=12u nf=4 ad='int((nf+1)/2) * W/nf * 0.18u' as='int((nf+2)/2) * W/nf * 0.18u' pd='2*int((nf+1)/2) * (W/nf + 0.18u)'  ps='2*int((nf+2)/2) * (W/nf + 0.18u)' nrd='0.18u / W' nrs='0.18u / W' sa=0 sb=0 sd=0 m=1 par=1
XMDPp3 L3P ap3 VR VR pfet_03v3 L=0.28u W=24u nf=8 ad='int((nf+1)/2) * W/nf * 0.18u' as='int((nf+2)/2) * W/nf * 0.18u' pd='2*int((nf+1)/2) * (W/nf + 0.18u)'  ps='2*int((nf+2)/2) * (W/nf + 0.18u)' nrd='0.18u / W' nrs='0.18u / W' sa=0 sb=0 sd=0 m=1 par=1
XMCNp3 ckdp3 L3P VSS VSS nfet_03v3 L=0.28u W=2u nf=1 ad='int((nf+1)/2) * W/nf * 0.18u' as='int((nf+2)/2) * W/nf * 0.18u' pd='2*int((nf+1)/2) * (W/nf + 0.18u)'  ps='2*int((nf+2)/2) * (W/nf + 0.18u)' nrd='0.18u / W' nrs='0.18u / W' sa=0 sb=0 sd=0 m=1 par=1
XMCPp3 ckdp3 L3P VR VR pfet_03v3 L=0.28u W=4u nf=1 ad='int((nf+1)/2) * W/nf * 0.18u' as='int((nf+2)/2) * W/nf * 0.18u' pd='2*int((nf+1)/2) * (W/nf + 0.18u)'  ps='2*int((nf+2)/2) * (W/nf + 0.18u)' nrd='0.18u / W' nrs='0.18u / W' sa=0 sb=0 sd=0 m=1 par=1
XMBNn3 an3 n3 VSS VSS nfet_03v3 L=0.28u W=2u nf=1 ad='int((nf+1)/2) * W/nf * 0.18u' as='int((nf+2)/2) * W/nf * 0.18u' pd='2*int((nf+1)/2) * (W/nf + 0.18u)'  ps='2*int((nf+2)/2) * (W/nf + 0.18u)' nrd='0.18u / W' nrs='0.18u / W' sa=0 sb=0 sd=0 m=1 par=1
XMBPn3 an3 n3 VR VR pfet_03v3 L=0.28u W=4u nf=1 ad='int((nf+1)/2) * W/nf * 0.18u' as='int((nf+2)/2) * W/nf * 0.18u' pd='2*int((nf+1)/2) * (W/nf + 0.18u)'  ps='2*int((nf+2)/2) * (W/nf + 0.18u)' nrd='0.18u / W' nrs='0.18u / W' sa=0 sb=0 sd=0 m=1 par=1
XMDNn3 L3N an3 VSS VSS nfet_03v3 L=0.28u W=12u nf=4 ad='int((nf+1)/2) * W/nf * 0.18u' as='int((nf+2)/2) * W/nf * 0.18u' pd='2*int((nf+1)/2) * (W/nf + 0.18u)'  ps='2*int((nf+2)/2) * (W/nf + 0.18u)' nrd='0.18u / W' nrs='0.18u / W' sa=0 sb=0 sd=0 m=1 par=1
XMDPn3 L3N an3 VR VR pfet_03v3 L=0.28u W=24u nf=8 ad='int((nf+1)/2) * W/nf * 0.18u' as='int((nf+2)/2) * W/nf * 0.18u' pd='2*int((nf+1)/2) * (W/nf + 0.18u)'  ps='2*int((nf+2)/2) * (W/nf + 0.18u)' nrd='0.18u / W' nrs='0.18u / W' sa=0 sb=0 sd=0 m=1 par=1
XMCNn3 ckdn3 L3N VSS VSS nfet_03v3 L=0.28u W=2u nf=1 ad='int((nf+1)/2) * W/nf * 0.18u' as='int((nf+2)/2) * W/nf * 0.18u' pd='2*int((nf+1)/2) * (W/nf + 0.18u)'  ps='2*int((nf+2)/2) * (W/nf + 0.18u)' nrd='0.18u / W' nrs='0.18u / W' sa=0 sb=0 sd=0 m=1 par=1
XMCPn3 ckdn3 L3N VR VR pfet_03v3 L=0.28u W=4u nf=1 ad='int((nf+1)/2) * W/nf * 0.18u' as='int((nf+2)/2) * W/nf * 0.18u' pd='2*int((nf+1)/2) * (W/nf + 0.18u)'  ps='2*int((nf+2)/2) * (W/nf + 0.18u)' nrd='0.18u / W' nrs='0.18u / W' sa=0 sb=0 sd=0 m=1 par=1
XMBNp4 ap4 p4 VSS VSS nfet_03v3 L=0.28u W=2u nf=1 ad='int((nf+1)/2) * W/nf * 0.18u' as='int((nf+2)/2) * W/nf * 0.18u' pd='2*int((nf+1)/2) * (W/nf + 0.18u)'  ps='2*int((nf+2)/2) * (W/nf + 0.18u)' nrd='0.18u / W' nrs='0.18u / W' sa=0 sb=0 sd=0 m=1 par=1
XMBPp4 ap4 p4 VR VR pfet_03v3 L=0.28u W=4u nf=1 ad='int((nf+1)/2) * W/nf * 0.18u' as='int((nf+2)/2) * W/nf * 0.18u' pd='2*int((nf+1)/2) * (W/nf + 0.18u)'  ps='2*int((nf+2)/2) * (W/nf + 0.18u)' nrd='0.18u / W' nrs='0.18u / W' sa=0 sb=0 sd=0 m=1 par=1
XMDNp4 L4P ap4 VSS VSS nfet_03v3 L=0.28u W=12u nf=4 ad='int((nf+1)/2) * W/nf * 0.18u' as='int((nf+2)/2) * W/nf * 0.18u' pd='2*int((nf+1)/2) * (W/nf + 0.18u)'  ps='2*int((nf+2)/2) * (W/nf + 0.18u)' nrd='0.18u / W' nrs='0.18u / W' sa=0 sb=0 sd=0 m=1 par=1
XMDPp4 L4P ap4 VR VR pfet_03v3 L=0.28u W=24u nf=8 ad='int((nf+1)/2) * W/nf * 0.18u' as='int((nf+2)/2) * W/nf * 0.18u' pd='2*int((nf+1)/2) * (W/nf + 0.18u)'  ps='2*int((nf+2)/2) * (W/nf + 0.18u)' nrd='0.18u / W' nrs='0.18u / W' sa=0 sb=0 sd=0 m=1 par=1
XMCNp4 ckdp4 L4P VSS VSS nfet_03v3 L=0.28u W=2u nf=1 ad='int((nf+1)/2) * W/nf * 0.18u' as='int((nf+2)/2) * W/nf * 0.18u' pd='2*int((nf+1)/2) * (W/nf + 0.18u)'  ps='2*int((nf+2)/2) * (W/nf + 0.18u)' nrd='0.18u / W' nrs='0.18u / W' sa=0 sb=0 sd=0 m=1 par=1
XMCPp4 ckdp4 L4P VR VR pfet_03v3 L=0.28u W=4u nf=1 ad='int((nf+1)/2) * W/nf * 0.18u' as='int((nf+2)/2) * W/nf * 0.18u' pd='2*int((nf+1)/2) * (W/nf + 0.18u)'  ps='2*int((nf+2)/2) * (W/nf + 0.18u)' nrd='0.18u / W' nrs='0.18u / W' sa=0 sb=0 sd=0 m=1 par=1
XMBNn4 an4 n4 VSS VSS nfet_03v3 L=0.28u W=2u nf=1 ad='int((nf+1)/2) * W/nf * 0.18u' as='int((nf+2)/2) * W/nf * 0.18u' pd='2*int((nf+1)/2) * (W/nf + 0.18u)'  ps='2*int((nf+2)/2) * (W/nf + 0.18u)' nrd='0.18u / W' nrs='0.18u / W' sa=0 sb=0 sd=0 m=1 par=1
XMBPn4 an4 n4 VR VR pfet_03v3 L=0.28u W=4u nf=1 ad='int((nf+1)/2) * W/nf * 0.18u' as='int((nf+2)/2) * W/nf * 0.18u' pd='2*int((nf+1)/2) * (W/nf + 0.18u)'  ps='2*int((nf+2)/2) * (W/nf + 0.18u)' nrd='0.18u / W' nrs='0.18u / W' sa=0 sb=0 sd=0 m=1 par=1
XMDNn4 L4N an4 VSS VSS nfet_03v3 L=0.28u W=12u nf=4 ad='int((nf+1)/2) * W/nf * 0.18u' as='int((nf+2)/2) * W/nf * 0.18u' pd='2*int((nf+1)/2) * (W/nf + 0.18u)'  ps='2*int((nf+2)/2) * (W/nf + 0.18u)' nrd='0.18u / W' nrs='0.18u / W' sa=0 sb=0 sd=0 m=1 par=1
XMDPn4 L4N an4 VR VR pfet_03v3 L=0.28u W=24u nf=8 ad='int((nf+1)/2) * W/nf * 0.18u' as='int((nf+2)/2) * W/nf * 0.18u' pd='2*int((nf+1)/2) * (W/nf + 0.18u)'  ps='2*int((nf+2)/2) * (W/nf + 0.18u)' nrd='0.18u / W' nrs='0.18u / W' sa=0 sb=0 sd=0 m=1 par=1
XMCNn4 ckdn4 L4N VSS VSS nfet_03v3 L=0.28u W=2u nf=1 ad='int((nf+1)/2) * W/nf * 0.18u' as='int((nf+2)/2) * W/nf * 0.18u' pd='2*int((nf+1)/2) * (W/nf + 0.18u)'  ps='2*int((nf+2)/2) * (W/nf + 0.18u)' nrd='0.18u / W' nrs='0.18u / W' sa=0 sb=0 sd=0 m=1 par=1
XMCPn4 ckdn4 L4N VR VR pfet_03v3 L=0.28u W=4u nf=1 ad='int((nf+1)/2) * W/nf * 0.18u' as='int((nf+2)/2) * W/nf * 0.18u' pd='2*int((nf+1)/2) * (W/nf + 0.18u)'  ps='2*int((nf+2)/2) * (W/nf + 0.18u)' nrd='0.18u / W' nrs='0.18u / W' sa=0 sb=0 sd=0 m=1 par=1
XMK1 n1 kh VSS VSS nfet_03v3 L=0.28u W=16u nf=4 ad='int((nf+1)/2) * W/nf * 0.18u' as='int((nf+2)/2) * W/nf * 0.18u' pd='2*int((nf+1)/2) * (W/nf + 0.18u)'  ps='2*int((nf+2)/2) * (W/nf + 0.18u)' nrd='0.18u / W' nrs='0.18u / W' sa=0 sb=0 sd=0 m=1 par=1
XMKD1 p1 VSS VSS VSS nfet_03v3 L=0.28u W=16u nf=4 ad='int((nf+1)/2) * W/nf * 0.18u' as='int((nf+2)/2) * W/nf * 0.18u' pd='2*int((nf+1)/2) * (W/nf + 0.18u)'  ps='2*int((nf+2)/2) * (W/nf + 0.18u)' nrd='0.18u / W' nrs='0.18u / W' sa=0 sb=0 sd=0 m=1 par=1
XMK2 n2 kl VSS VSS nfet_03v3 L=0.28u W=16u nf=4 ad='int((nf+1)/2) * W/nf * 0.18u' as='int((nf+2)/2) * W/nf * 0.18u' pd='2*int((nf+1)/2) * (W/nf + 0.18u)'  ps='2*int((nf+2)/2) * (W/nf + 0.18u)' nrd='0.18u / W' nrs='0.18u / W' sa=0 sb=0 sd=0 m=1 par=1
XMKD2 p2 VSS VSS VSS nfet_03v3 L=0.28u W=16u nf=4 ad='int((nf+1)/2) * W/nf * 0.18u' as='int((nf+2)/2) * W/nf * 0.18u' pd='2*int((nf+1)/2) * (W/nf + 0.18u)'  ps='2*int((nf+2)/2) * (W/nf + 0.18u)' nrd='0.18u / W' nrs='0.18u / W' sa=0 sb=0 sd=0 m=1 par=1
XMK3 n3 VSS VSS VSS nfet_03v3 L=0.28u W=16u nf=4 ad='int((nf+1)/2) * W/nf * 0.18u' as='int((nf+2)/2) * W/nf * 0.18u' pd='2*int((nf+1)/2) * (W/nf + 0.18u)'  ps='2*int((nf+2)/2) * (W/nf + 0.18u)' nrd='0.18u / W' nrs='0.18u / W' sa=0 sb=0 sd=0 m=1 par=1
XMKD3 p3 VSS VSS VSS nfet_03v3 L=0.28u W=16u nf=4 ad='int((nf+1)/2) * W/nf * 0.18u' as='int((nf+2)/2) * W/nf * 0.18u' pd='2*int((nf+1)/2) * (W/nf + 0.18u)'  ps='2*int((nf+2)/2) * (W/nf + 0.18u)' nrd='0.18u / W' nrs='0.18u / W' sa=0 sb=0 sd=0 m=1 par=1
XMK4 p4 VSS VSS VSS nfet_03v3 L=0.28u W=16u nf=4 ad='int((nf+1)/2) * W/nf * 0.18u' as='int((nf+2)/2) * W/nf * 0.18u' pd='2*int((nf+1)/2) * (W/nf + 0.18u)'  ps='2*int((nf+2)/2) * (W/nf + 0.18u)' nrd='0.18u / W' nrs='0.18u / W' sa=0 sb=0 sd=0 m=1 par=1
XMKD4 n4 VSS VSS VSS nfet_03v3 L=0.28u W=16u nf=4 ad='int((nf+1)/2) * W/nf * 0.18u' as='int((nf+2)/2) * W/nf * 0.18u' pd='2*int((nf+1)/2) * (W/nf + 0.18u)'  ps='2*int((nf+2)/2) * (W/nf + 0.18u)' nrd='0.18u / W' nrs='0.18u / W' sa=0 sb=0 sd=0 m=1 par=1
.ends

* expanding   symbol:  nand2.sym # of pins=5
** sym_path: /home/noritsuna/GPS/xschem/nand2.sym
** sch_path: /home/noritsuna/GPS/xschem/nand2.sch
.subckt nand2 A B Y VDD VSS
*.ipin A
*.ipin B
*.opin Y
*.iopin VDD
*.iopin VSS
XMN1 Y A n1 VSS nfet_03v3 L=0.28u W=2u nf=1 ad='int((nf+1)/2) * W/nf * 0.18u' as='int((nf+2)/2) * W/nf * 0.18u' pd='2*int((nf+1)/2) * (W/nf + 0.18u)'  ps='2*int((nf+2)/2) * (W/nf + 0.18u)' nrd='0.18u / W' nrs='0.18u / W' sa=0 sb=0 sd=0 m=1 par=1
XMN2 n1 B VSS VSS nfet_03v3 L=0.28u W=2u nf=1 ad='int((nf+1)/2) * W/nf * 0.18u' as='int((nf+2)/2) * W/nf * 0.18u' pd='2*int((nf+1)/2) * (W/nf + 0.18u)'  ps='2*int((nf+2)/2) * (W/nf + 0.18u)' nrd='0.18u / W' nrs='0.18u / W' sa=0 sb=0 sd=0 m=1 par=1
XMP1 Y A VDD VDD pfet_03v3 L=0.28u W=2u nf=1 ad='int((nf+1)/2) * W/nf * 0.18u' as='int((nf+2)/2) * W/nf * 0.18u' pd='2*int((nf+1)/2) * (W/nf + 0.18u)'  ps='2*int((nf+2)/2) * (W/nf + 0.18u)' nrd='0.18u / W' nrs='0.18u / W' sa=0 sb=0 sd=0 m=1 par=1
XMP2 Y B VDD VDD pfet_03v3 L=0.28u W=2u nf=1 ad='int((nf+1)/2) * W/nf * 0.18u' as='int((nf+2)/2) * W/nf * 0.18u' pd='2*int((nf+1)/2) * (W/nf + 0.18u)'  ps='2*int((nf+2)/2) * (W/nf + 0.18u)' nrd='0.18u / W' nrs='0.18u / W' sa=0 sb=0 sd=0 m=1 par=1
.ends

* expanding   symbol:  divbuf.sym # of pins=4
** sym_path: /home/noritsuna/GPS/xschem/divbuf.sym
** sch_path: /home/noritsuna/GPS/xschem/divbuf.sch
.subckt divbuf IN OUT VDD VSS
*.ipin IN
*.opin OUT
*.iopin VDD
*.iopin VSS
XCIN IN a cap_mim_2f0_m4m5_noshield c_width=12e-6 c_length=12e-6
XRF b a VSS ppolyf_u_1k r_width=1u r_length=20u
XMN1 b a VSS VSS nfet_03v3 L=0.28u W=4u nf=1 ad='int((nf+1)/2) * W/nf * 0.18u' as='int((nf+2)/2) * W/nf * 0.18u' pd='2*int((nf+1)/2) * (W/nf + 0.18u)'  ps='2*int((nf+2)/2) * (W/nf + 0.18u)' nrd='0.18u / W' nrs='0.18u / W' sa=0 sb=0 sd=0 m=1 par=1
XMP1 b a VDD VDD pfet_03v3 L=0.28u W=8u nf=1 ad='int((nf+1)/2) * W/nf * 0.18u' as='int((nf+2)/2) * W/nf * 0.18u' pd='2*int((nf+1)/2) * (W/nf + 0.18u)'  ps='2*int((nf+2)/2) * (W/nf + 0.18u)' nrd='0.18u / W' nrs='0.18u / W' sa=0 sb=0 sd=0 m=1 par=1
XMN2 OUT b VSS VSS nfet_03v3 L=0.28u W=4u nf=1 ad='int((nf+1)/2) * W/nf * 0.18u' as='int((nf+2)/2) * W/nf * 0.18u' pd='2*int((nf+1)/2) * (W/nf + 0.18u)'  ps='2*int((nf+2)/2) * (W/nf + 0.18u)' nrd='0.18u / W' nrs='0.18u / W' sa=0 sb=0 sd=0 m=1 par=1
XMP2 OUT b VDD VDD pfet_03v3 L=0.28u W=8u nf=1 ad='int((nf+1)/2) * W/nf * 0.18u' as='int((nf+2)/2) * W/nf * 0.18u' pd='2*int((nf+1)/2) * (W/nf + 0.18u)'  ps='2*int((nf+2)/2) * (W/nf + 0.18u)' nrd='0.18u / W' nrs='0.18u / W' sa=0 sb=0 sd=0 m=1 par=1
.ends

* expanding   symbol:  div48.sym # of pins=5
** sym_path: /home/noritsuna/GPS/xschem/div48.sym
** sch_path: /home/noritsuna/GPS/xschem/div48.sch
.subckt div48 CK FS FB VDD VSS
*.ipin CK
*.opin FS
*.opin FB
*.iopin VDD
*.iopin VSS
XD1 CK c2 c2b VDD VSS div2
XD2 c2 c4 c4b VDD VSS div2
XD3 c4 c8 c8b VDD VSS div2
XD5 c8 c24 VDD VSS div3
XD6 c24 FB c48b VDD VSS div2
XFB1 FB fbi VDD VSS inv_lo1
XFB2 fbi FS VDD VSS inv_lo2
.ends

* expanding   symbol:  pfd.sym # of pins=8
** sym_path: /home/noritsuna/GPS/xschem/pfd.sym
** sch_path: /home/noritsuna/GPS/xschem/pfd.sch
.subckt pfd REF FB UP UPB DN DNB VDD VSS
*.ipin REF
*.ipin FB
*.opin UP
*.opin UPB
*.opin DN
*.opin DNB
*.iopin VDD
*.iopin VSS
XU REF rb UP VDD VSS dff_r
XD FB rb DN VDD VSS dff_r
XR UP DN r0 VDD VSS nand2
XD1 r0 r1 VDD VSS inv_dig
XD2 r1 r2 VDD VSS inv_dig
XD3 r2 r3 VDD VSS inv_dig
XD4 r3 rb VDD VSS inv_dig
XO1 UP UPB VDD VSS inv_dig
XO2 DN DNB VDD VSS inv_dig
.ends

* expanding   symbol:  cp.sym # of pins=9
** sym_path: /home/noritsuna/GPS/xschem/cp.sym
** sch_path: /home/noritsuna/GPS/xschem/cp.sch
.subckt cp UPB DN DNB PB NB HI OUT VDD VSS
*.ipin UPB
*.ipin DN
*.ipin DNB
*.ipin PB
*.ipin NB
*.ipin HI
*.opin OUT
*.iopin VDD
*.iopin VSS
XUD UPB upd VDD VSS inv_dig
XMPC pc PB VDD VDD pfet_03v3 L=2u W=32u nf=4 ad='int((nf+1)/2) * W/nf * 0.18u' as='int((nf+2)/2) * W/nf * 0.18u' pd='2*int((nf+1)/2) * (W/nf + 0.18u)'  ps='2*int((nf+2)/2) * (W/nf + 0.18u)' nrd='0.18u / W' nrs='0.18u / W' sa=0 sb=0 sd=0 m=2 par=2
XMPS OUT UPB pc VDD pfet_03v3 L=0.28u W=8u nf=2 ad='int((nf+1)/2) * W/nf * 0.18u' as='int((nf+2)/2) * W/nf * 0.18u' pd='2*int((nf+1)/2) * (W/nf + 0.18u)'  ps='2*int((nf+2)/2) * (W/nf + 0.18u)' nrd='0.18u / W' nrs='0.18u / W' sa=0 sb=0 sd=0 m=1 par=1
XMPD vd upd pc VDD pfet_03v3 L=0.28u W=8u nf=2 ad='int((nf+1)/2) * W/nf * 0.18u' as='int((nf+2)/2) * W/nf * 0.18u' pd='2*int((nf+1)/2) * (W/nf + 0.18u)'  ps='2*int((nf+2)/2) * (W/nf + 0.18u)' nrd='0.18u / W' nrs='0.18u / W' sa=0 sb=0 sd=0 m=1 par=1
XMNS OUT DN nc VSS nfet_03v3 L=0.28u W=2u nf=1 ad='int((nf+1)/2) * W/nf * 0.18u' as='int((nf+2)/2) * W/nf * 0.18u' pd='2*int((nf+1)/2) * (W/nf + 0.18u)'  ps='2*int((nf+2)/2) * (W/nf + 0.18u)' nrd='0.18u / W' nrs='0.18u / W' sa=0 sb=0 sd=0 m=1 par=1
XMND vd DNB nc VSS nfet_03v3 L=0.28u W=2u nf=1 ad='int((nf+1)/2) * W/nf * 0.18u' as='int((nf+2)/2) * W/nf * 0.18u' pd='2*int((nf+1)/2) * (W/nf + 0.18u)'  ps='2*int((nf+2)/2) * (W/nf + 0.18u)' nrd='0.18u / W' nrs='0.18u / W' sa=0 sb=0 sd=0 m=1 par=1
XMNC nc NB VSS VSS nfet_03v3 L=2u W=16u nf=2 ad='int((nf+1)/2) * W/nf * 0.18u' as='int((nf+2)/2) * W/nf * 0.18u' pd='2*int((nf+1)/2) * (W/nf + 0.18u)'  ps='2*int((nf+2)/2) * (W/nf + 0.18u)' nrd='0.18u / W' nrs='0.18u / W' sa=0 sb=0 sd=0 m=2 par=2
XHI HI hib VDD VSS inv_dig
XMPC2 pc2 PB VDD VDD pfet_03v3 L=2u W=32u nf=4 ad='int((nf+1)/2) * W/nf * 0.18u' as='int((nf+2)/2) * W/nf * 0.18u' pd='2*int((nf+1)/2) * (W/nf + 0.18u)'  ps='2*int((nf+2)/2) * (W/nf + 0.18u)' nrd='0.18u / W' nrs='0.18u / W' sa=0 sb=0 sd=0 m=2 par=2
XMPE2 pe2 hib pc2 VDD pfet_03v3 L=0.28u W=24u nf=4 ad='int((nf+1)/2) * W/nf * 0.18u' as='int((nf+2)/2) * W/nf * 0.18u' pd='2*int((nf+1)/2) * (W/nf + 0.18u)'  ps='2*int((nf+2)/2) * (W/nf + 0.18u)' nrd='0.18u / W' nrs='0.18u / W' sa=0 sb=0 sd=0 m=1 par=1
XMPS2 OUT UPB pe2 VDD pfet_03v3 L=0.28u W=8u nf=2 ad='int((nf+1)/2) * W/nf * 0.18u' as='int((nf+2)/2) * W/nf * 0.18u' pd='2*int((nf+1)/2) * (W/nf + 0.18u)'  ps='2*int((nf+2)/2) * (W/nf + 0.18u)' nrd='0.18u / W' nrs='0.18u / W' sa=0 sb=0 sd=0 m=1 par=1
XMPD2 vd upd pe2 VDD pfet_03v3 L=0.28u W=8u nf=2 ad='int((nf+1)/2) * W/nf * 0.18u' as='int((nf+2)/2) * W/nf * 0.18u' pd='2*int((nf+1)/2) * (W/nf + 0.18u)'  ps='2*int((nf+2)/2) * (W/nf + 0.18u)' nrd='0.18u / W' nrs='0.18u / W' sa=0 sb=0 sd=0 m=1 par=1
XMNS2 OUT DN ne2 VSS nfet_03v3 L=0.28u W=2u nf=1 ad='int((nf+1)/2) * W/nf * 0.18u' as='int((nf+2)/2) * W/nf * 0.18u' pd='2*int((nf+1)/2) * (W/nf + 0.18u)'  ps='2*int((nf+2)/2) * (W/nf + 0.18u)' nrd='0.18u / W' nrs='0.18u / W' sa=0 sb=0 sd=0 m=1 par=1
XMND2 vd DNB ne2 VSS nfet_03v3 L=0.28u W=2u nf=1 ad='int((nf+1)/2) * W/nf * 0.18u' as='int((nf+2)/2) * W/nf * 0.18u' pd='2*int((nf+1)/2) * (W/nf + 0.18u)'  ps='2*int((nf+2)/2) * (W/nf + 0.18u)' nrd='0.18u / W' nrs='0.18u / W' sa=0 sb=0 sd=0 m=1 par=1
XMNE2 ne2 HI nc2 VSS nfet_03v3 L=0.28u W=4u nf=2 ad='int((nf+1)/2) * W/nf * 0.18u' as='int((nf+2)/2) * W/nf * 0.18u' pd='2*int((nf+1)/2) * (W/nf + 0.18u)'  ps='2*int((nf+2)/2) * (W/nf + 0.18u)' nrd='0.18u / W' nrs='0.18u / W' sa=0 sb=0 sd=0 m=1 par=1
XMNC2 nc2 NB VSS VSS nfet_03v3 L=2u W=16u nf=2 ad='int((nf+1)/2) * W/nf * 0.18u' as='int((nf+2)/2) * W/nf * 0.18u' pd='2*int((nf+1)/2) * (W/nf + 0.18u)'  ps='2*int((nf+2)/2) * (W/nf + 0.18u)' nrd='0.18u / W' nrs='0.18u / W' sa=0 sb=0 sd=0 m=2 par=2
XMBT bt NB VSS VSS nfet_03v3 L=2u W=16u nf=2 ad='int((nf+1)/2) * W/nf * 0.18u' as='int((nf+2)/2) * W/nf * 0.18u' pd='2*int((nf+1)/2) * (W/nf + 0.18u)'  ps='2*int((nf+2)/2) * (W/nf + 0.18u)' nrd='0.18u / W' nrs='0.18u / W' sa=0 sb=0 sd=0 m=1 par=1
XMB1 b1 OUT bt VSS nfet_03v3 L=1u W=8u nf=2 ad='int((nf+1)/2) * W/nf * 0.18u' as='int((nf+2)/2) * W/nf * 0.18u' pd='2*int((nf+1)/2) * (W/nf + 0.18u)'  ps='2*int((nf+2)/2) * (W/nf + 0.18u)' nrd='0.18u / W' nrs='0.18u / W' sa=0 sb=0 sd=0 m=1 par=1
XMB2 vd vd bt VSS nfet_03v3 L=1u W=8u nf=2 ad='int((nf+1)/2) * W/nf * 0.18u' as='int((nf+2)/2) * W/nf * 0.18u' pd='2*int((nf+1)/2) * (W/nf + 0.18u)'  ps='2*int((nf+2)/2) * (W/nf + 0.18u)' nrd='0.18u / W' nrs='0.18u / W' sa=0 sb=0 sd=0 m=1 par=1
XMBL1 b1 b1 VDD VDD pfet_03v3 L=1u W=8u nf=2 ad='int((nf+1)/2) * W/nf * 0.18u' as='int((nf+2)/2) * W/nf * 0.18u' pd='2*int((nf+1)/2) * (W/nf + 0.18u)'  ps='2*int((nf+2)/2) * (W/nf + 0.18u)' nrd='0.18u / W' nrs='0.18u / W' sa=0 sb=0 sd=0 m=1 par=1
XMBL2 vd b1 VDD VDD pfet_03v3 L=1u W=8u nf=2 ad='int((nf+1)/2) * W/nf * 0.18u' as='int((nf+2)/2) * W/nf * 0.18u' pd='2*int((nf+1)/2) * (W/nf + 0.18u)'  ps='2*int((nf+2)/2) * (W/nf + 0.18u)' nrd='0.18u / W' nrs='0.18u / W' sa=0 sb=0 sd=0 m=1 par=1
XCVD vd VSS cap_mim_2f0_m4m5_noshield c_width=32e-6 c_length=32e-6
.ends

* expanding   symbol:  loop_filter.sym # of pins=3
** sym_path: /home/noritsuna/GPS/xschem/loop_filter.sym
** sch_path: /home/noritsuna/GPS/xschem/loop_filter.sch
.subckt loop_filter VC VT VSS
*.iopin VC
*.opin VT
*.iopin VSS
XRZ z VC VSS ppolyf_u_1k r_width=1u r_length=10u
XC1 z VSS cap_mim_2f0_m4m5_noshield c_width=77e-6 c_length=77e-6 m=5
XC2 VC VSS cap_mim_2f0_m4m5_noshield c_width=49.5e-6 c_length=49.5e-6
XRVT VT VC VSS ppolyf_u_1k r_width=2u r_length=4u
XC3 VT VSS cap_mim_2f0_m4m5_noshield c_width=19.45e-6 c_length=19.45e-6
.ends

* expanding   symbol:  bias_if.sym # of pins=5
** sym_path: /home/noritsuna/GPS/xschem/bias_if.sym
** sch_path: /home/noritsuna/GPS/xschem/bias_if.sch
.subckt bias_if PB NBIF PBIF VDD VSS
*.ipin PB
*.opin NBIF
*.opin PBIF
*.iopin VDD
*.iopin VSS
XRDA vdiv VDD VSS ppolyf_u_1k r_width=1u r_length=70u
XRDB VSS vdiv VSS ppolyf_u_1k r_width=1u r_length=28.3u
XMOT ot PB VDD VDD pfet_03v3 L=2u W=32u nf=4 ad='int((nf+1)/2) * W/nf * 0.18u' as='int((nf+2)/2) * W/nf * 0.18u' pd='2*int((nf+1)/2) * (W/nf + 0.18u)'  ps='2*int((nf+2)/2) * (W/nf + 0.18u)' nrd='0.18u / W' nrs='0.18u / W' sa=0 sb=0 sd=0 m=1 par=1
XMI1 o1 vdiv ot VDD pfet_03v3 L=1u W=16u nf=2 ad='int((nf+1)/2) * W/nf * 0.18u' as='int((nf+2)/2) * W/nf * 0.18u' pd='2*int((nf+1)/2) * (W/nf + 0.18u)'  ps='2*int((nf+2)/2) * (W/nf + 0.18u)' nrd='0.18u / W' nrs='0.18u / W' sa=0 sb=0 sd=0 m=1 par=1
XMI2 og x ot VDD pfet_03v3 L=1u W=16u nf=2 ad='int((nf+1)/2) * W/nf * 0.18u' as='int((nf+2)/2) * W/nf * 0.18u' pd='2*int((nf+1)/2) * (W/nf + 0.18u)'  ps='2*int((nf+2)/2) * (W/nf + 0.18u)' nrd='0.18u / W' nrs='0.18u / W' sa=0 sb=0 sd=0 m=1 par=1
XML1 o1 o1 VSS VSS nfet_03v3 L=2u W=4u nf=1 ad='int((nf+1)/2) * W/nf * 0.18u' as='int((nf+2)/2) * W/nf * 0.18u' pd='2*int((nf+1)/2) * (W/nf + 0.18u)'  ps='2*int((nf+2)/2) * (W/nf + 0.18u)' nrd='0.18u / W' nrs='0.18u / W' sa=0 sb=0 sd=0 m=1 par=1
XML2 og o1 VSS VSS nfet_03v3 L=2u W=4u nf=1 ad='int((nf+1)/2) * W/nf * 0.18u' as='int((nf+2)/2) * W/nf * 0.18u' pd='2*int((nf+1)/2) * (W/nf + 0.18u)'  ps='2*int((nf+2)/2) * (W/nf + 0.18u)' nrd='0.18u / W' nrs='0.18u / W' sa=0 sb=0 sd=0 m=1 par=1
XCC og VSS cap_mim_2f0_m4m5_noshield c_width=20e-6 c_length=20e-6
XMV dp og x VSS nfet_03v3 L=1u W=20u nf=2 ad='int((nf+1)/2) * W/nf * 0.18u' as='int((nf+2)/2) * W/nf * 0.18u' pd='2*int((nf+1)/2) * (W/nf + 0.18u)'  ps='2*int((nf+2)/2) * (W/nf + 0.18u)' nrd='0.18u / W' nrs='0.18u / W' sa=0 sb=0 sd=0 m=1 par=1
XRREF0 r1 x VSS ppolyf_u_1k r_width=1u r_length=2u
XRREF1 r2 r1 VSS ppolyf_u_1k r_width=1u r_length=2u
XRREF2 r3 r2 VSS ppolyf_u_1k r_width=1u r_length=2u
XRREF3 r4 r3 VSS ppolyf_u_1k r_width=1u r_length=2u
XRREF4 r5 r4 VSS ppolyf_u_1k r_width=1u r_length=2u
XRREF5 r6 r5 VSS ppolyf_u_1k r_width=1u r_length=2u
XRREF6 r7 r6 VSS ppolyf_u_1k r_width=1u r_length=2u
XRREF7 r8 r7 VSS ppolyf_u_1k r_width=1u r_length=2u
XRREF8 VSS r8 VSS ppolyf_u_1k r_width=1u r_length=2u
XMPD dp dp VDD VDD pfet_03v3 L=2u W=32u nf=4 ad='int((nf+1)/2) * W/nf * 0.18u' as='int((nf+2)/2) * W/nf * 0.18u' pd='2*int((nf+1)/2) * (W/nf + 0.18u)'  ps='2*int((nf+2)/2) * (W/nf + 0.18u)' nrd='0.18u / W' nrs='0.18u / W' sa=0 sb=0 sd=0 m=1 par=1
XMPM NBIF dp VDD VDD pfet_03v3 L=2u W=32u nf=4 ad='int((nf+1)/2) * W/nf * 0.18u' as='int((nf+2)/2) * W/nf * 0.18u' pd='2*int((nf+1)/2) * (W/nf + 0.18u)'  ps='2*int((nf+2)/2) * (W/nf + 0.18u)' nrd='0.18u / W' nrs='0.18u / W' sa=0 sb=0 sd=0 m=1 par=1
XMND NBIF NBIF VSS VSS nfet_03v3 L=2u W=16u nf=2 ad='int((nf+1)/2) * W/nf * 0.18u' as='int((nf+2)/2) * W/nf * 0.18u' pd='2*int((nf+1)/2) * (W/nf + 0.18u)'  ps='2*int((nf+2)/2) * (W/nf + 0.18u)' nrd='0.18u / W' nrs='0.18u / W' sa=0 sb=0 sd=0 m=1 par=1
XCNB NBIF VSS cap_mim_2f0_m4m5_noshield c_width=20e-6 c_length=20e-6
XMNP PBIF NBIF VSS VSS nfet_03v3 L=2u W=16u nf=2 ad='int((nf+1)/2) * W/nf * 0.18u' as='int((nf+2)/2) * W/nf * 0.18u' pd='2*int((nf+1)/2) * (W/nf + 0.18u)'  ps='2*int((nf+2)/2) * (W/nf + 0.18u)' nrd='0.18u / W' nrs='0.18u / W' sa=0 sb=0 sd=0 m=1 par=1
XMPP PBIF PBIF VDD VDD pfet_03v3 L=2u W=32u nf=4 ad='int((nf+1)/2) * W/nf * 0.18u' as='int((nf+2)/2) * W/nf * 0.18u' pd='2*int((nf+1)/2) * (W/nf + 0.18u)'  ps='2*int((nf+2)/2) * (W/nf + 0.18u)' nrd='0.18u / W' nrs='0.18u / W' sa=0 sb=0 sd=0 m=1 par=1
XCPB VDD PBIF cap_mim_2f0_m4m5_noshield c_width=20e-6 c_length=20e-6
.ends

* expanding   symbol:  vga.sym # of pins=9
** sym_path: /home/noritsuna/GPS/xschem/vga.sym
** sch_path: /home/noritsuna/GPS/xschem/vga.sch
.subckt vga INP INN GA GB NB OUTP OUTN VDD VSS
*.ipin INP
*.ipin INN
*.ipin GA
*.ipin GB
*.ipin NB
*.opin OUTP
*.opin OUTN
*.iopin VDD
*.iopin VSS
XCC1 INP gp cap_mim_2f0_m4m5_noshield c_width=50e-6 c_length=50e-6
XCC2 INN gn cap_mim_2f0_m4m5_noshield c_width=50e-6 c_length=50e-6
XRB1 vcm gp VSS ppolyf_u_1k r_width=1u r_length=100u
XRB2 vcm gn VSS ppolyf_u_1k r_width=1u r_length=100u
XRCA vcm VDD VSS ppolyf_u_1k r_width=1u r_length=34u
XRCB VSS vcm VSS ppolyf_u_1k r_width=1u r_length=25u
XCCM vcm VSS cap_mim_2f0_m4m5_noshield c_width=30e-6 c_length=30e-6
XM1 OUTN gp s1 VSS nfet_03v3 L=0.28u W=40u nf=8 ad='int((nf+1)/2) * W/nf * 0.18u' as='int((nf+2)/2) * W/nf * 0.18u' pd='2*int((nf+1)/2) * (W/nf + 0.18u)'  ps='2*int((nf+2)/2) * (W/nf + 0.18u)' nrd='0.18u / W' nrs='0.18u / W' sa=0 sb=0 sd=0 m=2 par=2
XM2 OUTP gn s2 VSS nfet_03v3 L=0.28u W=40u nf=8 ad='int((nf+1)/2) * W/nf * 0.18u' as='int((nf+2)/2) * W/nf * 0.18u' pd='2*int((nf+1)/2) * (W/nf + 0.18u)'  ps='2*int((nf+2)/2) * (W/nf + 0.18u)' nrd='0.18u / W' nrs='0.18u / W' sa=0 sb=0 sd=0 m=2 par=2
XMT1 s1 NB VSS VSS nfet_03v3 L=2u W=40u nf=4 ad='int((nf+1)/2) * W/nf * 0.18u' as='int((nf+2)/2) * W/nf * 0.18u' pd='2*int((nf+1)/2) * (W/nf + 0.18u)'  ps='2*int((nf+2)/2) * (W/nf + 0.18u)' nrd='0.18u / W' nrs='0.18u / W' sa=0 sb=0 sd=0 m=8 par=8
XMT2 s2 NB VSS VSS nfet_03v3 L=2u W=40u nf=4 ad='int((nf+1)/2) * W/nf * 0.18u' as='int((nf+2)/2) * W/nf * 0.18u' pd='2*int((nf+1)/2) * (W/nf + 0.18u)'  ps='2*int((nf+2)/2) * (W/nf + 0.18u)' nrd='0.18u / W' nrs='0.18u / W' sa=0 sb=0 sd=0 m=8 par=8
XRL1 OUTN VDD VSS ppolyf_u_1k r_width=1u r_length=2u
XRL2 OUTP VDD VSS ppolyf_u_1k r_width=1u r_length=2u
XRD0 s2 s1 VSS ppolyf_u_1k r_width=1u r_length=2u
XMSA s1 GA da VSS nfet_03v3 L=0.28u W=20u nf=4 ad='int((nf+1)/2) * W/nf * 0.18u' as='int((nf+2)/2) * W/nf * 0.18u' pd='2*int((nf+1)/2) * (W/nf + 0.18u)'  ps='2*int((nf+2)/2) * (W/nf + 0.18u)' nrd='0.18u / W' nrs='0.18u / W' sa=0 sb=0 sd=0 m=1 par=1
XRDA s2 da VSS ppolyf_u_1k r_width=1u r_length=3u
XMSB s1 GB db VSS nfet_03v3 L=0.28u W=40u nf=8 ad='int((nf+1)/2) * W/nf * 0.18u' as='int((nf+2)/2) * W/nf * 0.18u' pd='2*int((nf+1)/2) * (W/nf + 0.18u)'  ps='2*int((nf+2)/2) * (W/nf + 0.18u)' nrd='0.18u / W' nrs='0.18u / W' sa=0 sb=0 sd=0 m=1 par=1
XRDB s2 db VSS ppolyf_u_1k r_width=2u r_length=1.8u
.ends

* expanding   symbol:  sk_lpf1.sym # of pins=7
** sym_path: /home/noritsuna/GPS/xschem/sk_lpf1.sym
** sch_path: /home/noritsuna/GPS/xschem/sk_lpf1.sch
.subckt sk_lpf1 INP INN PB OUTP OUTN VDD VSS
*.ipin INP
*.ipin INN
*.ipin PB
*.opin OUTP
*.opin OUTN
*.iopin VDD
*.iopin VSS
XR1P xP INP VSS ppolyf_u_1k r_width=1u r_length=1u
XR2P yP xP VSS ppolyf_u_1k r_width=1u r_length=3u
XC1P xP OUTP cap_mim_2f0_m4m5_noshield c_width=42.6e-6 c_length=42.6e-6
XC2P yP VSS cap_mim_2f0_m4m5_noshield c_width=45.8e-6 c_length=45.8e-6
XMFP VSS yP OUTP OUTP pfet_03v3 L=0.28u W=40u nf=8 ad='int((nf+1)/2) * W/nf * 0.18u' as='int((nf+2)/2) * W/nf * 0.18u' pd='2*int((nf+1)/2) * (W/nf + 0.18u)'  ps='2*int((nf+2)/2) * (W/nf + 0.18u)' nrd='0.18u / W' nrs='0.18u / W' sa=0 sb=0 sd=0 m=1 par=1
XMIP OUTP PB VDD VDD pfet_03v3 L=2u W=40u nf=4 ad='int((nf+1)/2) * W/nf * 0.18u' as='int((nf+2)/2) * W/nf * 0.18u' pd='2*int((nf+1)/2) * (W/nf + 0.18u)'  ps='2*int((nf+2)/2) * (W/nf + 0.18u)' nrd='0.18u / W' nrs='0.18u / W' sa=0 sb=0 sd=0 m=16 par=16
XR1N xN INN VSS ppolyf_u_1k r_width=1u r_length=1u
XR2N yN xN VSS ppolyf_u_1k r_width=1u r_length=3u
XC1N xN OUTN cap_mim_2f0_m4m5_noshield c_width=42.6e-6 c_length=42.6e-6
XC2N yN VSS cap_mim_2f0_m4m5_noshield c_width=45.8e-6 c_length=45.8e-6
XMFN VSS yN OUTN OUTN pfet_03v3 L=0.28u W=40u nf=8 ad='int((nf+1)/2) * W/nf * 0.18u' as='int((nf+2)/2) * W/nf * 0.18u' pd='2*int((nf+1)/2) * (W/nf + 0.18u)'  ps='2*int((nf+2)/2) * (W/nf + 0.18u)' nrd='0.18u / W' nrs='0.18u / W' sa=0 sb=0 sd=0 m=1 par=1
XMIN OUTN PB VDD VDD pfet_03v3 L=2u W=40u nf=4 ad='int((nf+1)/2) * W/nf * 0.18u' as='int((nf+2)/2) * W/nf * 0.18u' pd='2*int((nf+1)/2) * (W/nf + 0.18u)'  ps='2*int((nf+2)/2) * (W/nf + 0.18u)' nrd='0.18u / W' nrs='0.18u / W' sa=0 sb=0 sd=0 m=16 par=16
.ends

* expanding   symbol:  sk_lpf2.sym # of pins=7
** sym_path: /home/noritsuna/GPS/xschem/sk_lpf2.sym
** sch_path: /home/noritsuna/GPS/xschem/sk_lpf2.sch
.subckt sk_lpf2 INP INN PB OUTP OUTN VDD VSS
*.ipin INP
*.ipin INN
*.ipin PB
*.opin OUTP
*.opin OUTN
*.iopin VDD
*.iopin VSS
XR1P xP INP VSS ppolyf_u_1k r_width=1u r_length=1u
XR2P yP xP VSS ppolyf_u_1k r_width=1u r_length=3u
XC1P xP OUTP cap_mim_2f0_m4m5_noshield c_width=95.8e-6 c_length=95.8e-6
XC2P yP VSS cap_mim_2f0_m4m5_noshield c_width=23.0e-6 c_length=23.0e-6
XMFP VSS yP OUTP OUTP pfet_03v3 L=0.28u W=40u nf=8 ad='int((nf+1)/2) * W/nf * 0.18u' as='int((nf+2)/2) * W/nf * 0.18u' pd='2*int((nf+1)/2) * (W/nf + 0.18u)'  ps='2*int((nf+2)/2) * (W/nf + 0.18u)' nrd='0.18u / W' nrs='0.18u / W' sa=0 sb=0 sd=0 m=1 par=1
XMIP OUTP PB VDD VDD pfet_03v3 L=2u W=40u nf=4 ad='int((nf+1)/2) * W/nf * 0.18u' as='int((nf+2)/2) * W/nf * 0.18u' pd='2*int((nf+1)/2) * (W/nf + 0.18u)'  ps='2*int((nf+2)/2) * (W/nf + 0.18u)' nrd='0.18u / W' nrs='0.18u / W' sa=0 sb=0 sd=0 m=16 par=16
XR1N xN INN VSS ppolyf_u_1k r_width=1u r_length=1u
XR2N yN xN VSS ppolyf_u_1k r_width=1u r_length=3u
XC1N xN OUTN cap_mim_2f0_m4m5_noshield c_width=95.8e-6 c_length=95.8e-6
XC2N yN VSS cap_mim_2f0_m4m5_noshield c_width=23.0e-6 c_length=23.0e-6
XMFN VSS yN OUTN OUTN pfet_03v3 L=0.28u W=40u nf=8 ad='int((nf+1)/2) * W/nf * 0.18u' as='int((nf+2)/2) * W/nf * 0.18u' pd='2*int((nf+1)/2) * (W/nf + 0.18u)'  ps='2*int((nf+2)/2) * (W/nf + 0.18u)' nrd='0.18u / W' nrs='0.18u / W' sa=0 sb=0 sd=0 m=1 par=1
XMIN OUTN PB VDD VDD pfet_03v3 L=2u W=40u nf=4 ad='int((nf+1)/2) * W/nf * 0.18u' as='int((nf+2)/2) * W/nf * 0.18u' pd='2*int((nf+1)/2) * (W/nf + 0.18u)'  ps='2*int((nf+2)/2) * (W/nf + 0.18u)' nrd='0.18u / W' nrs='0.18u / W' sa=0 sb=0 sd=0 m=16 par=16
.ends

* expanding   symbol:  vga_fix.sym # of pins=7
** sym_path: /home/noritsuna/GPS/xschem/vga_fix.sym
** sch_path: /home/noritsuna/GPS/xschem/vga_fix.sch
.subckt vga_fix INP INN NB OUTP OUTN VDD VSS
*.ipin INP
*.ipin INN
*.ipin NB
*.opin OUTP
*.opin OUTN
*.iopin VDD
*.iopin VSS
XCC1 INP gp cap_mim_2f0_m4m5_noshield c_width=50e-6 c_length=50e-6
XCC2 INN gn cap_mim_2f0_m4m5_noshield c_width=50e-6 c_length=50e-6
XRB1 vcm gp VSS ppolyf_u_1k r_width=1u r_length=100u
XRB2 vcm gn VSS ppolyf_u_1k r_width=1u r_length=100u
XRCA vcm VDD VSS ppolyf_u_1k r_width=1u r_length=34u
XRCB VSS vcm VSS ppolyf_u_1k r_width=1u r_length=25u
XCCM vcm VSS cap_mim_2f0_m4m5_noshield c_width=30e-6 c_length=30e-6
XM1 OUTN gp s1 VSS nfet_03v3 L=0.28u W=40u nf=8 ad='int((nf+1)/2) * W/nf * 0.18u' as='int((nf+2)/2) * W/nf * 0.18u' pd='2*int((nf+1)/2) * (W/nf + 0.18u)'  ps='2*int((nf+2)/2) * (W/nf + 0.18u)' nrd='0.18u / W' nrs='0.18u / W' sa=0 sb=0 sd=0 m=2 par=2
XM2 OUTP gn s2 VSS nfet_03v3 L=0.28u W=40u nf=8 ad='int((nf+1)/2) * W/nf * 0.18u' as='int((nf+2)/2) * W/nf * 0.18u' pd='2*int((nf+1)/2) * (W/nf + 0.18u)'  ps='2*int((nf+2)/2) * (W/nf + 0.18u)' nrd='0.18u / W' nrs='0.18u / W' sa=0 sb=0 sd=0 m=2 par=2
XMT1 s1 NB VSS VSS nfet_03v3 L=2u W=40u nf=4 ad='int((nf+1)/2) * W/nf * 0.18u' as='int((nf+2)/2) * W/nf * 0.18u' pd='2*int((nf+1)/2) * (W/nf + 0.18u)'  ps='2*int((nf+2)/2) * (W/nf + 0.18u)' nrd='0.18u / W' nrs='0.18u / W' sa=0 sb=0 sd=0 m=8 par=8
XMT2 s2 NB VSS VSS nfet_03v3 L=2u W=40u nf=4 ad='int((nf+1)/2) * W/nf * 0.18u' as='int((nf+2)/2) * W/nf * 0.18u' pd='2*int((nf+1)/2) * (W/nf + 0.18u)'  ps='2*int((nf+2)/2) * (W/nf + 0.18u)' nrd='0.18u / W' nrs='0.18u / W' sa=0 sb=0 sd=0 m=8 par=8
XRL1 OUTN VDD VSS ppolyf_u_1k r_width=1u r_length=2u
XRL2 OUTP VDD VSS ppolyf_u_1k r_width=1u r_length=2u
XRDF s2 s1 VSS ppolyf_u_1k r_width=10.6u r_length=1u
.ends

* expanding   symbol:  sa_comp.sym # of pins=9
** sym_path: /home/noritsuna/GPS/xschem/sa_comp.sym
** sch_path: /home/noritsuna/GPS/xschem/sa_comp.sch
.subckt sa_comp INP INN REFP REFN CLK Q QB VDD VSS
*.ipin INP
*.ipin INN
*.ipin REFP
*.ipin REFN
*.ipin CLK
*.opin Q
*.opin QB
*.iopin VDD
*.iopin VSS
XMT t CLK VSS VSS nfet_03v3 L=0.28u W=8u nf=2 ad='int((nf+1)/2) * W/nf * 0.18u' as='int((nf+2)/2) * W/nf * 0.18u' pd='2*int((nf+1)/2) * (W/nf + 0.18u)'  ps='2*int((nf+2)/2) * (W/nf + 0.18u)' nrd='0.18u / W' nrs='0.18u / W' sa=0 sb=0 sd=0 m=1 par=1
XM1 x1 INP t VSS nfet_03v3 L=0.28u W=4u nf=1 ad='int((nf+1)/2) * W/nf * 0.18u' as='int((nf+2)/2) * W/nf * 0.18u' pd='2*int((nf+1)/2) * (W/nf + 0.18u)'  ps='2*int((nf+2)/2) * (W/nf + 0.18u)' nrd='0.18u / W' nrs='0.18u / W' sa=0 sb=0 sd=0 m=1 par=1
XM2 x2 INN t VSS nfet_03v3 L=0.28u W=4u nf=1 ad='int((nf+1)/2) * W/nf * 0.18u' as='int((nf+2)/2) * W/nf * 0.18u' pd='2*int((nf+1)/2) * (W/nf + 0.18u)'  ps='2*int((nf+2)/2) * (W/nf + 0.18u)' nrd='0.18u / W' nrs='0.18u / W' sa=0 sb=0 sd=0 m=1 par=1
XM3 x2 REFP t VSS nfet_03v3 L=0.28u W=4u nf=1 ad='int((nf+1)/2) * W/nf * 0.18u' as='int((nf+2)/2) * W/nf * 0.18u' pd='2*int((nf+1)/2) * (W/nf + 0.18u)'  ps='2*int((nf+2)/2) * (W/nf + 0.18u)' nrd='0.18u / W' nrs='0.18u / W' sa=0 sb=0 sd=0 m=1 par=1
XM4 x1 REFN t VSS nfet_03v3 L=0.28u W=4u nf=1 ad='int((nf+1)/2) * W/nf * 0.18u' as='int((nf+2)/2) * W/nf * 0.18u' pd='2*int((nf+1)/2) * (W/nf + 0.18u)'  ps='2*int((nf+2)/2) * (W/nf + 0.18u)' nrd='0.18u / W' nrs='0.18u / W' sa=0 sb=0 sd=0 m=1 par=1
XM5 on op x1 VSS nfet_03v3 L=0.28u W=2u nf=1 ad='int((nf+1)/2) * W/nf * 0.18u' as='int((nf+2)/2) * W/nf * 0.18u' pd='2*int((nf+1)/2) * (W/nf + 0.18u)'  ps='2*int((nf+2)/2) * (W/nf + 0.18u)' nrd='0.18u / W' nrs='0.18u / W' sa=0 sb=0 sd=0 m=1 par=1
XM6 op on x2 VSS nfet_03v3 L=0.28u W=2u nf=1 ad='int((nf+1)/2) * W/nf * 0.18u' as='int((nf+2)/2) * W/nf * 0.18u' pd='2*int((nf+1)/2) * (W/nf + 0.18u)'  ps='2*int((nf+2)/2) * (W/nf + 0.18u)' nrd='0.18u / W' nrs='0.18u / W' sa=0 sb=0 sd=0 m=1 par=1
XM7 on op VDD VDD pfet_03v3 L=0.28u W=2u nf=1 ad='int((nf+1)/2) * W/nf * 0.18u' as='int((nf+2)/2) * W/nf * 0.18u' pd='2*int((nf+1)/2) * (W/nf + 0.18u)'  ps='2*int((nf+2)/2) * (W/nf + 0.18u)' nrd='0.18u / W' nrs='0.18u / W' sa=0 sb=0 sd=0 m=1 par=1
XM8 op on VDD VDD pfet_03v3 L=0.28u W=2u nf=1 ad='int((nf+1)/2) * W/nf * 0.18u' as='int((nf+2)/2) * W/nf * 0.18u' pd='2*int((nf+1)/2) * (W/nf + 0.18u)'  ps='2*int((nf+2)/2) * (W/nf + 0.18u)' nrd='0.18u / W' nrs='0.18u / W' sa=0 sb=0 sd=0 m=1 par=1
XM9 on CLK VDD VDD pfet_03v3 L=0.28u W=1u nf=1 ad='int((nf+1)/2) * W/nf * 0.18u' as='int((nf+2)/2) * W/nf * 0.18u' pd='2*int((nf+1)/2) * (W/nf + 0.18u)'  ps='2*int((nf+2)/2) * (W/nf + 0.18u)' nrd='0.18u / W' nrs='0.18u / W' sa=0 sb=0 sd=0 m=1 par=1
XM10 op CLK VDD VDD pfet_03v3 L=0.28u W=1u nf=1 ad='int((nf+1)/2) * W/nf * 0.18u' as='int((nf+2)/2) * W/nf * 0.18u' pd='2*int((nf+1)/2) * (W/nf + 0.18u)'  ps='2*int((nf+2)/2) * (W/nf + 0.18u)' nrd='0.18u / W' nrs='0.18u / W' sa=0 sb=0 sd=0 m=1 par=1
XM11 x1 CLK VDD VDD pfet_03v3 L=0.28u W=1u nf=1 ad='int((nf+1)/2) * W/nf * 0.18u' as='int((nf+2)/2) * W/nf * 0.18u' pd='2*int((nf+1)/2) * (W/nf + 0.18u)'  ps='2*int((nf+2)/2) * (W/nf + 0.18u)' nrd='0.18u / W' nrs='0.18u / W' sa=0 sb=0 sd=0 m=1 par=1
XM12 x2 CLK VDD VDD pfet_03v3 L=0.28u W=1u nf=1 ad='int((nf+1)/2) * W/nf * 0.18u' as='int((nf+2)/2) * W/nf * 0.18u' pd='2*int((nf+1)/2) * (W/nf + 0.18u)'  ps='2*int((nf+2)/2) * (W/nf + 0.18u)' nrd='0.18u / W' nrs='0.18u / W' sa=0 sb=0 sd=0 m=1 par=1
XI1 op opb VDD VSS inv_dig
XI2 on onb VDD VSS inv_dig
XS1 opb QB Q VDD VSS nor2
XS2 onb Q QB VDD VSS nor2
.ends

* expanding   symbol:  inv_dac.sym # of pins=4
** sym_path: /home/noritsuna/GPS/xschem/inv_dac.sym
** sch_path: /home/noritsuna/GPS/xschem/inv_dac.sch
.subckt inv_dac A Y VDD VSS
*.ipin A
*.opin Y
*.iopin VDD
*.iopin VSS
XMN Y A VSS VSS nfet_03v3 L=0.28u W=8u nf=2 ad='int((nf+1)/2) * W/nf * 0.18u' as='int((nf+2)/2) * W/nf * 0.18u' pd='2*int((nf+1)/2) * (W/nf + 0.18u)'  ps='2*int((nf+2)/2) * (W/nf + 0.18u)' nrd='0.18u / W' nrs='0.18u / W' sa=0 sb=0 sd=0 m=1 par=1
XMP Y A VDD VDD pfet_03v3 L=0.28u W=24u nf=4 ad='int((nf+1)/2) * W/nf * 0.18u' as='int((nf+2)/2) * W/nf * 0.18u' pd='2*int((nf+1)/2) * (W/nf + 0.18u)'  ps='2*int((nf+2)/2) * (W/nf + 0.18u)' nrd='0.18u / W' nrs='0.18u / W' sa=0 sb=0 sd=0 m=1 par=1
.ends

* expanding   symbol:  div2.sym # of pins=5
** sym_path: /home/noritsuna/GPS/xschem/div2.sym
** sch_path: /home/noritsuna/GPS/xschem/div2.sch
.subckt div2 CK Q QB VDD VSS
*.ipin CK
*.opin Q
*.opin QB
*.iopin VDD
*.iopin VSS
XF QB CK Q QB VDD VSS tspc_dff
.ends

* expanding   symbol:  div3.sym # of pins=4
** sym_path: /home/noritsuna/GPS/xschem/div3.sym
** sch_path: /home/noritsuna/GPS/xschem/div3.sch
.subckt div3 CK Q VDD VSS
*.ipin CK
*.opin Q
*.iopin VDD
*.iopin VSS
XF1 d1 CK Q q1b VDD VSS tspc_dff
XF2 Q CK q2 q2b VDD VSS tspc_dff
XN Q q2 d1 VDD VSS nor2
.ends

* expanding   symbol:  inv_lo1.sym # of pins=4
** sym_path: /home/noritsuna/GPS/xschem/inv_lo1.sym
** sch_path: /home/noritsuna/GPS/xschem/inv_lo1.sch
.subckt inv_lo1 A Y VDD VSS
*.ipin A
*.opin Y
*.iopin VDD
*.iopin VSS
XMN Y A VSS VSS nfet_03v3 L=0.28u W=2u nf=1 ad='int((nf+1)/2) * W/nf * 0.18u' as='int((nf+2)/2) * W/nf * 0.18u' pd='2*int((nf+1)/2) * (W/nf + 0.18u)'  ps='2*int((nf+2)/2) * (W/nf + 0.18u)' nrd='0.18u / W' nrs='0.18u / W' sa=0 sb=0 sd=0 m=1 par=1
XMP Y A VDD VDD pfet_03v3 L=0.28u W=4u nf=1 ad='int((nf+1)/2) * W/nf * 0.18u' as='int((nf+2)/2) * W/nf * 0.18u' pd='2*int((nf+1)/2) * (W/nf + 0.18u)'  ps='2*int((nf+2)/2) * (W/nf + 0.18u)' nrd='0.18u / W' nrs='0.18u / W' sa=0 sb=0 sd=0 m=1 par=1
.ends

* expanding   symbol:  dff_r.sym # of pins=5
** sym_path: /home/noritsuna/GPS/xschem/dff_r.sym
** sch_path: /home/noritsuna/GPS/xschem/dff_r.sch
.subckt dff_r CK RB Q VDD VSS
*.ipin CK
*.ipin RB
*.opin Q
*.iopin VDD
*.iopin VSS
X1 n4 n2 n1 VDD VSS nand2
X2 n1 CK RB n2 VDD VSS nand3
X3 n2 CK n4 n3 VDD VSS nand3
X4 n3 RB n4 VDD VSS nand2
X5 n2 qb Q VDD VSS nand2
X6 Q n3 RB qb VDD VSS nand3
.ends

* expanding   symbol:  tspc_dff.sym # of pins=6
** sym_path: /home/noritsuna/GPS/xschem/tspc_dff.sym
** sch_path: /home/noritsuna/GPS/xschem/tspc_dff.sch
.subckt tspc_dff D CK Q QB VDD VSS
*.ipin D
*.ipin CK
*.opin Q
*.opin QB
*.iopin VDD
*.iopin VSS
XMP1 a1 D VDD VDD pfet_03v3 L=0.28u W=2u nf=1 ad='int((nf+1)/2) * W/nf * 0.18u' as='int((nf+2)/2) * W/nf * 0.18u' pd='2*int((nf+1)/2) * (W/nf + 0.18u)'  ps='2*int((nf+2)/2) * (W/nf + 0.18u)' nrd='0.18u / W' nrs='0.18u / W' sa=0 sb=0 sd=0 m=1 par=1
XMP2 x CK a1 VDD pfet_03v3 L=0.28u W=2u nf=1 ad='int((nf+1)/2) * W/nf * 0.18u' as='int((nf+2)/2) * W/nf * 0.18u' pd='2*int((nf+1)/2) * (W/nf + 0.18u)'  ps='2*int((nf+2)/2) * (W/nf + 0.18u)' nrd='0.18u / W' nrs='0.18u / W' sa=0 sb=0 sd=0 m=1 par=1
XMN1 x D VSS VSS nfet_03v3 L=0.28u W=1u nf=1 ad='int((nf+1)/2) * W/nf * 0.18u' as='int((nf+2)/2) * W/nf * 0.18u' pd='2*int((nf+1)/2) * (W/nf + 0.18u)'  ps='2*int((nf+2)/2) * (W/nf + 0.18u)' nrd='0.18u / W' nrs='0.18u / W' sa=0 sb=0 sd=0 m=1 par=1
XMP3 y CK VDD VDD pfet_03v3 L=0.28u W=2u nf=1 ad='int((nf+1)/2) * W/nf * 0.18u' as='int((nf+2)/2) * W/nf * 0.18u' pd='2*int((nf+1)/2) * (W/nf + 0.18u)'  ps='2*int((nf+2)/2) * (W/nf + 0.18u)' nrd='0.18u / W' nrs='0.18u / W' sa=0 sb=0 sd=0 m=1 par=1
XMN2 y x b2 VSS nfet_03v3 L=0.28u W=1.5u nf=1 ad='int((nf+1)/2) * W/nf * 0.18u' as='int((nf+2)/2) * W/nf * 0.18u' pd='2*int((nf+1)/2) * (W/nf + 0.18u)'  ps='2*int((nf+2)/2) * (W/nf + 0.18u)' nrd='0.18u / W' nrs='0.18u / W' sa=0 sb=0 sd=0 m=1 par=1
XMN3 b2 CK VSS VSS nfet_03v3 L=0.28u W=1.5u nf=1 ad='int((nf+1)/2) * W/nf * 0.18u' as='int((nf+2)/2) * W/nf * 0.18u' pd='2*int((nf+1)/2) * (W/nf + 0.18u)'  ps='2*int((nf+2)/2) * (W/nf + 0.18u)' nrd='0.18u / W' nrs='0.18u / W' sa=0 sb=0 sd=0 m=1 par=1
XMP4 QB y VDD VDD pfet_03v3 L=0.28u W=3u nf=1 ad='int((nf+1)/2) * W/nf * 0.18u' as='int((nf+2)/2) * W/nf * 0.18u' pd='2*int((nf+1)/2) * (W/nf + 0.18u)'  ps='2*int((nf+2)/2) * (W/nf + 0.18u)' nrd='0.18u / W' nrs='0.18u / W' sa=0 sb=0 sd=0 m=1 par=1
XMN4 QB CK c3 VSS nfet_03v3 L=0.28u W=1.5u nf=1 ad='int((nf+1)/2) * W/nf * 0.18u' as='int((nf+2)/2) * W/nf * 0.18u' pd='2*int((nf+1)/2) * (W/nf + 0.18u)'  ps='2*int((nf+2)/2) * (W/nf + 0.18u)' nrd='0.18u / W' nrs='0.18u / W' sa=0 sb=0 sd=0 m=1 par=1
XMN5 c3 y VSS VSS nfet_03v3 L=0.28u W=1.5u nf=1 ad='int((nf+1)/2) * W/nf * 0.18u' as='int((nf+2)/2) * W/nf * 0.18u' pd='2*int((nf+1)/2) * (W/nf + 0.18u)'  ps='2*int((nf+2)/2) * (W/nf + 0.18u)' nrd='0.18u / W' nrs='0.18u / W' sa=0 sb=0 sd=0 m=1 par=1
XMP5 Q QB VDD VDD pfet_03v3 L=0.28u W=2u nf=1 ad='int((nf+1)/2) * W/nf * 0.18u' as='int((nf+2)/2) * W/nf * 0.18u' pd='2*int((nf+1)/2) * (W/nf + 0.18u)'  ps='2*int((nf+2)/2) * (W/nf + 0.18u)' nrd='0.18u / W' nrs='0.18u / W' sa=0 sb=0 sd=0 m=1 par=1
XMN6 Q QB VSS VSS nfet_03v3 L=0.28u W=1u nf=1 ad='int((nf+1)/2) * W/nf * 0.18u' as='int((nf+2)/2) * W/nf * 0.18u' pd='2*int((nf+1)/2) * (W/nf + 0.18u)'  ps='2*int((nf+2)/2) * (W/nf + 0.18u)' nrd='0.18u / W' nrs='0.18u / W' sa=0 sb=0 sd=0 m=1 par=1
.ends

* expanding   symbol:  nand3.sym # of pins=6
** sym_path: /home/noritsuna/GPS/xschem/nand3.sym
** sch_path: /home/noritsuna/GPS/xschem/nand3.sch
.subckt nand3 A B C Y VDD VSS
*.ipin A
*.ipin B
*.ipin C
*.opin Y
*.iopin VDD
*.iopin VSS
XMN1 Y A n1 VSS nfet_03v3 L=0.28u W=3u nf=1 ad='int((nf+1)/2) * W/nf * 0.18u' as='int((nf+2)/2) * W/nf * 0.18u' pd='2*int((nf+1)/2) * (W/nf + 0.18u)'  ps='2*int((nf+2)/2) * (W/nf + 0.18u)' nrd='0.18u / W' nrs='0.18u / W' sa=0 sb=0 sd=0 m=1 par=1
XMN2 n1 B n2 VSS nfet_03v3 L=0.28u W=3u nf=1 ad='int((nf+1)/2) * W/nf * 0.18u' as='int((nf+2)/2) * W/nf * 0.18u' pd='2*int((nf+1)/2) * (W/nf + 0.18u)'  ps='2*int((nf+2)/2) * (W/nf + 0.18u)' nrd='0.18u / W' nrs='0.18u / W' sa=0 sb=0 sd=0 m=1 par=1
XMN3 n2 C VSS VSS nfet_03v3 L=0.28u W=3u nf=1 ad='int((nf+1)/2) * W/nf * 0.18u' as='int((nf+2)/2) * W/nf * 0.18u' pd='2*int((nf+1)/2) * (W/nf + 0.18u)'  ps='2*int((nf+2)/2) * (W/nf + 0.18u)' nrd='0.18u / W' nrs='0.18u / W' sa=0 sb=0 sd=0 m=1 par=1
XMP1 Y A VDD VDD pfet_03v3 L=0.28u W=2u nf=1 ad='int((nf+1)/2) * W/nf * 0.18u' as='int((nf+2)/2) * W/nf * 0.18u' pd='2*int((nf+1)/2) * (W/nf + 0.18u)'  ps='2*int((nf+2)/2) * (W/nf + 0.18u)' nrd='0.18u / W' nrs='0.18u / W' sa=0 sb=0 sd=0 m=1 par=1
XMP2 Y B VDD VDD pfet_03v3 L=0.28u W=2u nf=1 ad='int((nf+1)/2) * W/nf * 0.18u' as='int((nf+2)/2) * W/nf * 0.18u' pd='2*int((nf+1)/2) * (W/nf + 0.18u)'  ps='2*int((nf+2)/2) * (W/nf + 0.18u)' nrd='0.18u / W' nrs='0.18u / W' sa=0 sb=0 sd=0 m=1 par=1
XMP3 Y C VDD VDD pfet_03v3 L=0.28u W=2u nf=1 ad='int((nf+1)/2) * W/nf * 0.18u' as='int((nf+2)/2) * W/nf * 0.18u' pd='2*int((nf+1)/2) * (W/nf + 0.18u)'  ps='2*int((nf+2)/2) * (W/nf + 0.18u)' nrd='0.18u / W' nrs='0.18u / W' sa=0 sb=0 sd=0 m=1 par=1
.ends

.end
