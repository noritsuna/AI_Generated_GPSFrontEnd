** sch_path: /home/noritsuna/GPS/xschem/tb_vco.sch
**.subckt tb_vco
VDD vdd 0 3.3
VC vctrl 0 1.5
VB0 b0 0 0
VB1 b1 0 0
XVCO vctrl b0 b1 loip loin loqp loqn vr vdd 0 vco_ring4
CLloip loip 0 60f
CLloin loin 0 60f
CLloqp loqp 0 60f
CLloqn loqn 0 60f
**** begin user architecture code
 .include /home/noritsuna/pdk/gf180mcuD/libs.tech/ngspice/design.ngspice
.lib /home/noritsuna/pdk/gf180mcuD/libs.tech/ngspice/sm141064.ngspice typical
.lib /home/noritsuna/pdk/gf180mcuD/libs.tech/ngspice/sm141064.ngspice res_typical
.lib /home/noritsuna/pdk/gf180mcuD/libs.tech/ngspice/sm141064.ngspice mimcap_typical

.option method=gear reltol=1e-4
.ic v(xvco.xpex.a_16549_52000#)=0 v(xvco.xpex.a_17193_52000#)=2
.option temp=27
.control
set num_threads=1
alter VC dc = 2.1
tran 1p 40n 20n uic
wrdata /home/noritsuna/GPS/sim/pex_vco/noR.txt v(loip) v(loin) v(loqp) v(loqn) i(VDD)
.endc

**** end user architecture code
**.ends

* expanding   symbol:  vco_ring4.sym # of pins=10
** sym_path: /home/noritsuna/GPS/xschem/vco_ring4.sym
** sch_path: /home/noritsuna/GPS/xschem/vco_ring4.sch

* expanding   symbol:  inv_dig.sym # of pins=4
** sym_path: /home/noritsuna/GPS/xschem/inv_dig.sym
** sch_path: /home/noritsuna/GPS/xschem/inv_dig.sch
.subckt inv_dig A Y VDD VSS
*.ipin A
*.opin Y
*.iopin VDD
*.iopin VSS
XMN Y A VSS VSS nfet_03v3 L=0.28u W=1u nf=1 ad='int((nf+1)/2) * W/nf * 0.18u' as='int((nf+2)/2) * W/nf * 0.18u' pd='2*int((nf+1)/2) * (W/nf + 0.18u)'
+ ps='2*int((nf+2)/2) * (W/nf + 0.18u)' nrd='0.18u / W' nrs='0.18u / W' sa=0 sb=0 sd=0 m=1 par=1
XMP Y A VDD VDD pfet_03v3 L=0.28u W=2u nf=1 ad='int((nf+1)/2) * W/nf * 0.18u' as='int((nf+2)/2) * W/nf * 0.18u' pd='2*int((nf+1)/2) * (W/nf + 0.18u)'
+ ps='2*int((nf+2)/2) * (W/nf + 0.18u)' nrd='0.18u / W' nrs='0.18u / W' sa=0 sb=0 sd=0 m=1 par=1
.ends

* expanding   symbol:  vco_core.sym # of pins=12
** sym_path: /home/noritsuna/GPS/xschem/vco_core.sym
** sch_path: /home/noritsuna/GPS/xschem/vco_core.sch
.subckt vco_core ap1 an1 ap2 an2 ap3 an3 ap4 an4 kh kl VR VSS
*.opin ap1
*.opin an1
*.opin ap2
*.opin an2
*.opin ap3
*.opin an3
*.opin ap4
*.opin an4
*.ipin kh
*.ipin kl
*.iopin VR
*.iopin VSS
XMNa1 n1 p4 VSS VSS nfet_03v3 L=0.4u W=8u nf=2 ad='int((nf+1)/2) * W/nf * 0.18u' as='int((nf+2)/2) * W/nf * 0.18u' pd='2*int((nf+1)/2) * (W/nf + 0.18u)'
+ ps='2*int((nf+2)/2) * (W/nf + 0.18u)' nrd='0.18u / W' nrs='0.18u / W' sa=0 sb=0 sd=0 m=1 par=1
XMNb1 p1 n4 VSS VSS nfet_03v3 L=0.4u W=8u nf=2 ad='int((nf+1)/2) * W/nf * 0.18u' as='int((nf+2)/2) * W/nf * 0.18u' pd='2*int((nf+1)/2) * (W/nf + 0.18u)'
+ ps='2*int((nf+2)/2) * (W/nf + 0.18u)' nrd='0.18u / W' nrs='0.18u / W' sa=0 sb=0 sd=0 m=1 par=1
XMPa1 n1 p4 VR VR pfet_03v3 L=0.4u W=12u nf=4 ad='int((nf+1)/2) * W/nf * 0.18u' as='int((nf+2)/2) * W/nf * 0.18u' pd='2*int((nf+1)/2) * (W/nf + 0.18u)'
+ ps='2*int((nf+2)/2) * (W/nf + 0.18u)' nrd='0.18u / W' nrs='0.18u / W' sa=0 sb=0 sd=0 m=1 par=1
XMPb1 p1 n4 VR VR pfet_03v3 L=0.4u W=12u nf=4 ad='int((nf+1)/2) * W/nf * 0.18u' as='int((nf+2)/2) * W/nf * 0.18u' pd='2*int((nf+1)/2) * (W/nf + 0.18u)'
+ ps='2*int((nf+2)/2) * (W/nf + 0.18u)' nrd='0.18u / W' nrs='0.18u / W' sa=0 sb=0 sd=0 m=1 par=1
XMNc1 n1 p1 VSS VSS nfet_03v3 L=0.4u W=1u nf=1 ad='int((nf+1)/2) * W/nf * 0.18u' as='int((nf+2)/2) * W/nf * 0.18u' pd='2*int((nf+1)/2) * (W/nf + 0.18u)'
+ ps='2*int((nf+2)/2) * (W/nf + 0.18u)' nrd='0.18u / W' nrs='0.18u / W' sa=0 sb=0 sd=0 m=1 par=1
XMNd1 p1 n1 VSS VSS nfet_03v3 L=0.4u W=1u nf=1 ad='int((nf+1)/2) * W/nf * 0.18u' as='int((nf+2)/2) * W/nf * 0.18u' pd='2*int((nf+1)/2) * (W/nf + 0.18u)'
+ ps='2*int((nf+2)/2) * (W/nf + 0.18u)' nrd='0.18u / W' nrs='0.18u / W' sa=0 sb=0 sd=0 m=1 par=1
XMPc1 n1 p1 VR VR pfet_03v3 L=0.4u W=2u nf=1 ad='int((nf+1)/2) * W/nf * 0.18u' as='int((nf+2)/2) * W/nf * 0.18u' pd='2*int((nf+1)/2) * (W/nf + 0.18u)'
+ ps='2*int((nf+2)/2) * (W/nf + 0.18u)' nrd='0.18u / W' nrs='0.18u / W' sa=0 sb=0 sd=0 m=1 par=1
XMPd1 p1 n1 VR VR pfet_03v3 L=0.4u W=2u nf=1 ad='int((nf+1)/2) * W/nf * 0.18u' as='int((nf+2)/2) * W/nf * 0.18u' pd='2*int((nf+1)/2) * (W/nf + 0.18u)'
+ ps='2*int((nf+2)/2) * (W/nf + 0.18u)' nrd='0.18u / W' nrs='0.18u / W' sa=0 sb=0 sd=0 m=1 par=1
XMNa2 n2 p1 VSS VSS nfet_03v3 L=0.4u W=8u nf=2 ad='int((nf+1)/2) * W/nf * 0.18u' as='int((nf+2)/2) * W/nf * 0.18u' pd='2*int((nf+1)/2) * (W/nf + 0.18u)'
+ ps='2*int((nf+2)/2) * (W/nf + 0.18u)' nrd='0.18u / W' nrs='0.18u / W' sa=0 sb=0 sd=0 m=1 par=1
XMNb2 p2 n1 VSS VSS nfet_03v3 L=0.4u W=8u nf=2 ad='int((nf+1)/2) * W/nf * 0.18u' as='int((nf+2)/2) * W/nf * 0.18u' pd='2*int((nf+1)/2) * (W/nf + 0.18u)'
+ ps='2*int((nf+2)/2) * (W/nf + 0.18u)' nrd='0.18u / W' nrs='0.18u / W' sa=0 sb=0 sd=0 m=1 par=1
XMPa2 n2 p1 VR VR pfet_03v3 L=0.4u W=12u nf=4 ad='int((nf+1)/2) * W/nf * 0.18u' as='int((nf+2)/2) * W/nf * 0.18u' pd='2*int((nf+1)/2) * (W/nf + 0.18u)'
+ ps='2*int((nf+2)/2) * (W/nf + 0.18u)' nrd='0.18u / W' nrs='0.18u / W' sa=0 sb=0 sd=0 m=1 par=1
XMPb2 p2 n1 VR VR pfet_03v3 L=0.4u W=12u nf=4 ad='int((nf+1)/2) * W/nf * 0.18u' as='int((nf+2)/2) * W/nf * 0.18u' pd='2*int((nf+1)/2) * (W/nf + 0.18u)'
+ ps='2*int((nf+2)/2) * (W/nf + 0.18u)' nrd='0.18u / W' nrs='0.18u / W' sa=0 sb=0 sd=0 m=1 par=1
XMNc2 n2 p2 VSS VSS nfet_03v3 L=0.4u W=1u nf=1 ad='int((nf+1)/2) * W/nf * 0.18u' as='int((nf+2)/2) * W/nf * 0.18u' pd='2*int((nf+1)/2) * (W/nf + 0.18u)'
+ ps='2*int((nf+2)/2) * (W/nf + 0.18u)' nrd='0.18u / W' nrs='0.18u / W' sa=0 sb=0 sd=0 m=1 par=1
XMNd2 p2 n2 VSS VSS nfet_03v3 L=0.4u W=1u nf=1 ad='int((nf+1)/2) * W/nf * 0.18u' as='int((nf+2)/2) * W/nf * 0.18u' pd='2*int((nf+1)/2) * (W/nf + 0.18u)'
+ ps='2*int((nf+2)/2) * (W/nf + 0.18u)' nrd='0.18u / W' nrs='0.18u / W' sa=0 sb=0 sd=0 m=1 par=1
XMPc2 n2 p2 VR VR pfet_03v3 L=0.4u W=2u nf=1 ad='int((nf+1)/2) * W/nf * 0.18u' as='int((nf+2)/2) * W/nf * 0.18u' pd='2*int((nf+1)/2) * (W/nf + 0.18u)'
+ ps='2*int((nf+2)/2) * (W/nf + 0.18u)' nrd='0.18u / W' nrs='0.18u / W' sa=0 sb=0 sd=0 m=1 par=1
XMPd2 p2 n2 VR VR pfet_03v3 L=0.4u W=2u nf=1 ad='int((nf+1)/2) * W/nf * 0.18u' as='int((nf+2)/2) * W/nf * 0.18u' pd='2*int((nf+1)/2) * (W/nf + 0.18u)'
+ ps='2*int((nf+2)/2) * (W/nf + 0.18u)' nrd='0.18u / W' nrs='0.18u / W' sa=0 sb=0 sd=0 m=1 par=1
XMNa3 n3 p2 VSS VSS nfet_03v3 L=0.4u W=8u nf=2 ad='int((nf+1)/2) * W/nf * 0.18u' as='int((nf+2)/2) * W/nf * 0.18u' pd='2*int((nf+1)/2) * (W/nf + 0.18u)'
+ ps='2*int((nf+2)/2) * (W/nf + 0.18u)' nrd='0.18u / W' nrs='0.18u / W' sa=0 sb=0 sd=0 m=1 par=1
XMNb3 p3 n2 VSS VSS nfet_03v3 L=0.4u W=8u nf=2 ad='int((nf+1)/2) * W/nf * 0.18u' as='int((nf+2)/2) * W/nf * 0.18u' pd='2*int((nf+1)/2) * (W/nf + 0.18u)'
+ ps='2*int((nf+2)/2) * (W/nf + 0.18u)' nrd='0.18u / W' nrs='0.18u / W' sa=0 sb=0 sd=0 m=1 par=1
XMPa3 n3 p2 VR VR pfet_03v3 L=0.4u W=12u nf=4 ad='int((nf+1)/2) * W/nf * 0.18u' as='int((nf+2)/2) * W/nf * 0.18u' pd='2*int((nf+1)/2) * (W/nf + 0.18u)'
+ ps='2*int((nf+2)/2) * (W/nf + 0.18u)' nrd='0.18u / W' nrs='0.18u / W' sa=0 sb=0 sd=0 m=1 par=1
XMPb3 p3 n2 VR VR pfet_03v3 L=0.4u W=12u nf=4 ad='int((nf+1)/2) * W/nf * 0.18u' as='int((nf+2)/2) * W/nf * 0.18u' pd='2*int((nf+1)/2) * (W/nf + 0.18u)'
+ ps='2*int((nf+2)/2) * (W/nf + 0.18u)' nrd='0.18u / W' nrs='0.18u / W' sa=0 sb=0 sd=0 m=1 par=1
XMNc3 n3 p3 VSS VSS nfet_03v3 L=0.4u W=1u nf=1 ad='int((nf+1)/2) * W/nf * 0.18u' as='int((nf+2)/2) * W/nf * 0.18u' pd='2*int((nf+1)/2) * (W/nf + 0.18u)'
+ ps='2*int((nf+2)/2) * (W/nf + 0.18u)' nrd='0.18u / W' nrs='0.18u / W' sa=0 sb=0 sd=0 m=1 par=1
XMNd3 p3 n3 VSS VSS nfet_03v3 L=0.4u W=1u nf=1 ad='int((nf+1)/2) * W/nf * 0.18u' as='int((nf+2)/2) * W/nf * 0.18u' pd='2*int((nf+1)/2) * (W/nf + 0.18u)'
+ ps='2*int((nf+2)/2) * (W/nf + 0.18u)' nrd='0.18u / W' nrs='0.18u / W' sa=0 sb=0 sd=0 m=1 par=1
XMPc3 n3 p3 VR VR pfet_03v3 L=0.4u W=2u nf=1 ad='int((nf+1)/2) * W/nf * 0.18u' as='int((nf+2)/2) * W/nf * 0.18u' pd='2*int((nf+1)/2) * (W/nf + 0.18u)'
+ ps='2*int((nf+2)/2) * (W/nf + 0.18u)' nrd='0.18u / W' nrs='0.18u / W' sa=0 sb=0 sd=0 m=1 par=1
XMPd3 p3 n3 VR VR pfet_03v3 L=0.4u W=2u nf=1 ad='int((nf+1)/2) * W/nf * 0.18u' as='int((nf+2)/2) * W/nf * 0.18u' pd='2*int((nf+1)/2) * (W/nf + 0.18u)'
+ ps='2*int((nf+2)/2) * (W/nf + 0.18u)' nrd='0.18u / W' nrs='0.18u / W' sa=0 sb=0 sd=0 m=1 par=1
XMNa4 p4 p3 VSS VSS nfet_03v3 L=0.4u W=8u nf=2 ad='int((nf+1)/2) * W/nf * 0.18u' as='int((nf+2)/2) * W/nf * 0.18u' pd='2*int((nf+1)/2) * (W/nf + 0.18u)'
+ ps='2*int((nf+2)/2) * (W/nf + 0.18u)' nrd='0.18u / W' nrs='0.18u / W' sa=0 sb=0 sd=0 m=1 par=1
XMNb4 n4 n3 VSS VSS nfet_03v3 L=0.4u W=8u nf=2 ad='int((nf+1)/2) * W/nf * 0.18u' as='int((nf+2)/2) * W/nf * 0.18u' pd='2*int((nf+1)/2) * (W/nf + 0.18u)'
+ ps='2*int((nf+2)/2) * (W/nf + 0.18u)' nrd='0.18u / W' nrs='0.18u / W' sa=0 sb=0 sd=0 m=1 par=1
XMPa4 p4 p3 VR VR pfet_03v3 L=0.4u W=12u nf=4 ad='int((nf+1)/2) * W/nf * 0.18u' as='int((nf+2)/2) * W/nf * 0.18u' pd='2*int((nf+1)/2) * (W/nf + 0.18u)'
+ ps='2*int((nf+2)/2) * (W/nf + 0.18u)' nrd='0.18u / W' nrs='0.18u / W' sa=0 sb=0 sd=0 m=1 par=1
XMPb4 n4 n3 VR VR pfet_03v3 L=0.4u W=12u nf=4 ad='int((nf+1)/2) * W/nf * 0.18u' as='int((nf+2)/2) * W/nf * 0.18u' pd='2*int((nf+1)/2) * (W/nf + 0.18u)'
+ ps='2*int((nf+2)/2) * (W/nf + 0.18u)' nrd='0.18u / W' nrs='0.18u / W' sa=0 sb=0 sd=0 m=1 par=1
XMNc4 p4 n4 VSS VSS nfet_03v3 L=0.4u W=1u nf=1 ad='int((nf+1)/2) * W/nf * 0.18u' as='int((nf+2)/2) * W/nf * 0.18u' pd='2*int((nf+1)/2) * (W/nf + 0.18u)'
+ ps='2*int((nf+2)/2) * (W/nf + 0.18u)' nrd='0.18u / W' nrs='0.18u / W' sa=0 sb=0 sd=0 m=1 par=1
XMNd4 n4 p4 VSS VSS nfet_03v3 L=0.4u W=1u nf=1 ad='int((nf+1)/2) * W/nf * 0.18u' as='int((nf+2)/2) * W/nf * 0.18u' pd='2*int((nf+1)/2) * (W/nf + 0.18u)'
+ ps='2*int((nf+2)/2) * (W/nf + 0.18u)' nrd='0.18u / W' nrs='0.18u / W' sa=0 sb=0 sd=0 m=1 par=1
XMPc4 p4 n4 VR VR pfet_03v3 L=0.4u W=2u nf=1 ad='int((nf+1)/2) * W/nf * 0.18u' as='int((nf+2)/2) * W/nf * 0.18u' pd='2*int((nf+1)/2) * (W/nf + 0.18u)'
+ ps='2*int((nf+2)/2) * (W/nf + 0.18u)' nrd='0.18u / W' nrs='0.18u / W' sa=0 sb=0 sd=0 m=1 par=1
XMPd4 n4 p4 VR VR pfet_03v3 L=0.4u W=2u nf=1 ad='int((nf+1)/2) * W/nf * 0.18u' as='int((nf+2)/2) * W/nf * 0.18u' pd='2*int((nf+1)/2) * (W/nf + 0.18u)'
+ ps='2*int((nf+2)/2) * (W/nf + 0.18u)' nrd='0.18u / W' nrs='0.18u / W' sa=0 sb=0 sd=0 m=1 par=1
XMBNp1 ap1 p1 VSS VSS nfet_03v3 L=0.28u W=2u nf=1 ad='int((nf+1)/2) * W/nf * 0.18u' as='int((nf+2)/2) * W/nf * 0.18u' pd='2*int((nf+1)/2) * (W/nf + 0.18u)'
+ ps='2*int((nf+2)/2) * (W/nf + 0.18u)' nrd='0.18u / W' nrs='0.18u / W' sa=0 sb=0 sd=0 m=1 par=1
XMBPp1 ap1 p1 VR VR pfet_03v3 L=0.28u W=4u nf=1 ad='int((nf+1)/2) * W/nf * 0.18u' as='int((nf+2)/2) * W/nf * 0.18u' pd='2*int((nf+1)/2) * (W/nf + 0.18u)'
+ ps='2*int((nf+2)/2) * (W/nf + 0.18u)' nrd='0.18u / W' nrs='0.18u / W' sa=0 sb=0 sd=0 m=1 par=1
XMBNn1 an1 n1 VSS VSS nfet_03v3 L=0.28u W=2u nf=1 ad='int((nf+1)/2) * W/nf * 0.18u' as='int((nf+2)/2) * W/nf * 0.18u' pd='2*int((nf+1)/2) * (W/nf + 0.18u)'
+ ps='2*int((nf+2)/2) * (W/nf + 0.18u)' nrd='0.18u / W' nrs='0.18u / W' sa=0 sb=0 sd=0 m=1 par=1
XMBPn1 an1 n1 VR VR pfet_03v3 L=0.28u W=4u nf=1 ad='int((nf+1)/2) * W/nf * 0.18u' as='int((nf+2)/2) * W/nf * 0.18u' pd='2*int((nf+1)/2) * (W/nf + 0.18u)'
+ ps='2*int((nf+2)/2) * (W/nf + 0.18u)' nrd='0.18u / W' nrs='0.18u / W' sa=0 sb=0 sd=0 m=1 par=1
XMBNp2 ap2 p2 VSS VSS nfet_03v3 L=0.28u W=2u nf=1 ad='int((nf+1)/2) * W/nf * 0.18u' as='int((nf+2)/2) * W/nf * 0.18u' pd='2*int((nf+1)/2) * (W/nf + 0.18u)'
+ ps='2*int((nf+2)/2) * (W/nf + 0.18u)' nrd='0.18u / W' nrs='0.18u / W' sa=0 sb=0 sd=0 m=1 par=1
XMBPp2 ap2 p2 VR VR pfet_03v3 L=0.28u W=4u nf=1 ad='int((nf+1)/2) * W/nf * 0.18u' as='int((nf+2)/2) * W/nf * 0.18u' pd='2*int((nf+1)/2) * (W/nf + 0.18u)'
+ ps='2*int((nf+2)/2) * (W/nf + 0.18u)' nrd='0.18u / W' nrs='0.18u / W' sa=0 sb=0 sd=0 m=1 par=1
XMBNn2 an2 n2 VSS VSS nfet_03v3 L=0.28u W=2u nf=1 ad='int((nf+1)/2) * W/nf * 0.18u' as='int((nf+2)/2) * W/nf * 0.18u' pd='2*int((nf+1)/2) * (W/nf + 0.18u)'
+ ps='2*int((nf+2)/2) * (W/nf + 0.18u)' nrd='0.18u / W' nrs='0.18u / W' sa=0 sb=0 sd=0 m=1 par=1
XMBPn2 an2 n2 VR VR pfet_03v3 L=0.28u W=4u nf=1 ad='int((nf+1)/2) * W/nf * 0.18u' as='int((nf+2)/2) * W/nf * 0.18u' pd='2*int((nf+1)/2) * (W/nf + 0.18u)'
+ ps='2*int((nf+2)/2) * (W/nf + 0.18u)' nrd='0.18u / W' nrs='0.18u / W' sa=0 sb=0 sd=0 m=1 par=1
XMBNp3 ap3 p3 VSS VSS nfet_03v3 L=0.28u W=2u nf=1 ad='int((nf+1)/2) * W/nf * 0.18u' as='int((nf+2)/2) * W/nf * 0.18u' pd='2*int((nf+1)/2) * (W/nf + 0.18u)'
+ ps='2*int((nf+2)/2) * (W/nf + 0.18u)' nrd='0.18u / W' nrs='0.18u / W' sa=0 sb=0 sd=0 m=1 par=1
XMBPp3 ap3 p3 VR VR pfet_03v3 L=0.28u W=4u nf=1 ad='int((nf+1)/2) * W/nf * 0.18u' as='int((nf+2)/2) * W/nf * 0.18u' pd='2*int((nf+1)/2) * (W/nf + 0.18u)'
+ ps='2*int((nf+2)/2) * (W/nf + 0.18u)' nrd='0.18u / W' nrs='0.18u / W' sa=0 sb=0 sd=0 m=1 par=1
XMBNn3 an3 n3 VSS VSS nfet_03v3 L=0.28u W=2u nf=1 ad='int((nf+1)/2) * W/nf * 0.18u' as='int((nf+2)/2) * W/nf * 0.18u' pd='2*int((nf+1)/2) * (W/nf + 0.18u)'
+ ps='2*int((nf+2)/2) * (W/nf + 0.18u)' nrd='0.18u / W' nrs='0.18u / W' sa=0 sb=0 sd=0 m=1 par=1
XMBPn3 an3 n3 VR VR pfet_03v3 L=0.28u W=4u nf=1 ad='int((nf+1)/2) * W/nf * 0.18u' as='int((nf+2)/2) * W/nf * 0.18u' pd='2*int((nf+1)/2) * (W/nf + 0.18u)'
+ ps='2*int((nf+2)/2) * (W/nf + 0.18u)' nrd='0.18u / W' nrs='0.18u / W' sa=0 sb=0 sd=0 m=1 par=1
XMBNp4 ap4 p4 VSS VSS nfet_03v3 L=0.28u W=2u nf=1 ad='int((nf+1)/2) * W/nf * 0.18u' as='int((nf+2)/2) * W/nf * 0.18u' pd='2*int((nf+1)/2) * (W/nf + 0.18u)'
+ ps='2*int((nf+2)/2) * (W/nf + 0.18u)' nrd='0.18u / W' nrs='0.18u / W' sa=0 sb=0 sd=0 m=1 par=1
XMBPp4 ap4 p4 VR VR pfet_03v3 L=0.28u W=4u nf=1 ad='int((nf+1)/2) * W/nf * 0.18u' as='int((nf+2)/2) * W/nf * 0.18u' pd='2*int((nf+1)/2) * (W/nf + 0.18u)'
+ ps='2*int((nf+2)/2) * (W/nf + 0.18u)' nrd='0.18u / W' nrs='0.18u / W' sa=0 sb=0 sd=0 m=1 par=1
XMBNn4 an4 n4 VSS VSS nfet_03v3 L=0.28u W=2u nf=1 ad='int((nf+1)/2) * W/nf * 0.18u' as='int((nf+2)/2) * W/nf * 0.18u' pd='2*int((nf+1)/2) * (W/nf + 0.18u)'
+ ps='2*int((nf+2)/2) * (W/nf + 0.18u)' nrd='0.18u / W' nrs='0.18u / W' sa=0 sb=0 sd=0 m=1 par=1
XMBPn4 an4 n4 VR VR pfet_03v3 L=0.28u W=4u nf=1 ad='int((nf+1)/2) * W/nf * 0.18u' as='int((nf+2)/2) * W/nf * 0.18u' pd='2*int((nf+1)/2) * (W/nf + 0.18u)'
+ ps='2*int((nf+2)/2) * (W/nf + 0.18u)' nrd='0.18u / W' nrs='0.18u / W' sa=0 sb=0 sd=0 m=1 par=1
XMK1 n1 kh VSS VSS nfet_03v3 L=0.4u W=8u nf=2 ad='int((nf+1)/2) * W/nf * 0.18u' as='int((nf+2)/2) * W/nf * 0.18u' pd='2*int((nf+1)/2) * (W/nf + 0.18u)'
+ ps='2*int((nf+2)/2) * (W/nf + 0.18u)' nrd='0.18u / W' nrs='0.18u / W' sa=0 sb=0 sd=0 m=1 par=1
XMKD1 p1 VSS VSS VSS nfet_03v3 L=0.4u W=8u nf=2 ad='int((nf+1)/2) * W/nf * 0.18u' as='int((nf+2)/2) * W/nf * 0.18u' pd='2*int((nf+1)/2) * (W/nf + 0.18u)'
+ ps='2*int((nf+2)/2) * (W/nf + 0.18u)' nrd='0.18u / W' nrs='0.18u / W' sa=0 sb=0 sd=0 m=1 par=1
XMK2 n2 kl VSS VSS nfet_03v3 L=0.4u W=8u nf=2 ad='int((nf+1)/2) * W/nf * 0.18u' as='int((nf+2)/2) * W/nf * 0.18u' pd='2*int((nf+1)/2) * (W/nf + 0.18u)'
+ ps='2*int((nf+2)/2) * (W/nf + 0.18u)' nrd='0.18u / W' nrs='0.18u / W' sa=0 sb=0 sd=0 m=1 par=1
XMKD2 p2 VSS VSS VSS nfet_03v3 L=0.4u W=8u nf=2 ad='int((nf+1)/2) * W/nf * 0.18u' as='int((nf+2)/2) * W/nf * 0.18u' pd='2*int((nf+1)/2) * (W/nf + 0.18u)'
+ ps='2*int((nf+2)/2) * (W/nf + 0.18u)' nrd='0.18u / W' nrs='0.18u / W' sa=0 sb=0 sd=0 m=1 par=1
XMK3 n3 VSS VSS VSS nfet_03v3 L=0.4u W=8u nf=2 ad='int((nf+1)/2) * W/nf * 0.18u' as='int((nf+2)/2) * W/nf * 0.18u' pd='2*int((nf+1)/2) * (W/nf + 0.18u)'
+ ps='2*int((nf+2)/2) * (W/nf + 0.18u)' nrd='0.18u / W' nrs='0.18u / W' sa=0 sb=0 sd=0 m=1 par=1
XMKD3 p3 VSS VSS VSS nfet_03v3 L=0.4u W=8u nf=2 ad='int((nf+1)/2) * W/nf * 0.18u' as='int((nf+2)/2) * W/nf * 0.18u' pd='2*int((nf+1)/2) * (W/nf + 0.18u)'
+ ps='2*int((nf+2)/2) * (W/nf + 0.18u)' nrd='0.18u / W' nrs='0.18u / W' sa=0 sb=0 sd=0 m=1 par=1
XMK4 p4 VSS VSS VSS nfet_03v3 L=0.4u W=8u nf=2 ad='int((nf+1)/2) * W/nf * 0.18u' as='int((nf+2)/2) * W/nf * 0.18u' pd='2*int((nf+1)/2) * (W/nf + 0.18u)'
+ ps='2*int((nf+2)/2) * (W/nf + 0.18u)' nrd='0.18u / W' nrs='0.18u / W' sa=0 sb=0 sd=0 m=1 par=1
XMKD4 n4 VSS VSS VSS nfet_03v3 L=0.4u W=8u nf=2 ad='int((nf+1)/2) * W/nf * 0.18u' as='int((nf+2)/2) * W/nf * 0.18u' pd='2*int((nf+1)/2) * (W/nf + 0.18u)'
+ ps='2*int((nf+2)/2) * (W/nf + 0.18u)' nrd='0.18u / W' nrs='0.18u / W' sa=0 sb=0 sd=0 m=1 par=1
.ends

* expanding   symbol:  inv_lo2.sym # of pins=4
** sym_path: /home/noritsuna/GPS/xschem/inv_lo2.sym
** sch_path: /home/noritsuna/GPS/xschem/inv_lo2.sch
.subckt inv_lo2 A Y VDD VSS
*.ipin A
*.opin Y
*.iopin VDD
*.iopin VSS
XMN Y A VSS VSS nfet_03v3 L=0.28u W=6u nf=2 ad='int((nf+1)/2) * W/nf * 0.18u' as='int((nf+2)/2) * W/nf * 0.18u' pd='2*int((nf+1)/2) * (W/nf + 0.18u)'
+ ps='2*int((nf+2)/2) * (W/nf + 0.18u)' nrd='0.18u / W' nrs='0.18u / W' sa=0 sb=0 sd=0 m=1 par=1
XMP Y A VDD VDD pfet_03v3 L=0.28u W=12u nf=4 ad='int((nf+1)/2) * W/nf * 0.18u' as='int((nf+2)/2) * W/nf * 0.18u' pd='2*int((nf+1)/2) * (W/nf + 0.18u)'
+ ps='2*int((nf+2)/2) * (W/nf + 0.18u)' nrd='0.18u / W' nrs='0.18u / W' sa=0 sb=0 sd=0 m=1 par=1
.ends

* expanding   symbol:  aoi22.sym # of pins=7
** sym_path: /home/noritsuna/GPS/xschem/aoi22.sym
** sch_path: /home/noritsuna/GPS/xschem/aoi22.sch
.subckt aoi22 A B C D Y VDD VSS
*.ipin A
*.ipin B
*.ipin C
*.ipin D
*.opin Y
*.iopin VDD
*.iopin VSS
XMNA Y A na VSS nfet_03v3 L=0.28u W=4u nf=1 ad='int((nf+1)/2) * W/nf * 0.18u' as='int((nf+2)/2) * W/nf * 0.18u' pd='2*int((nf+1)/2) * (W/nf + 0.18u)'
+ ps='2*int((nf+2)/2) * (W/nf + 0.18u)' nrd='0.18u / W' nrs='0.18u / W' sa=0 sb=0 sd=0 m=1 par=1
XMNB na B VSS VSS nfet_03v3 L=0.28u W=4u nf=1 ad='int((nf+1)/2) * W/nf * 0.18u' as='int((nf+2)/2) * W/nf * 0.18u' pd='2*int((nf+1)/2) * (W/nf + 0.18u)'
+ ps='2*int((nf+2)/2) * (W/nf + 0.18u)' nrd='0.18u / W' nrs='0.18u / W' sa=0 sb=0 sd=0 m=1 par=1
XMNC Y C nc VSS nfet_03v3 L=0.28u W=4u nf=1 ad='int((nf+1)/2) * W/nf * 0.18u' as='int((nf+2)/2) * W/nf * 0.18u' pd='2*int((nf+1)/2) * (W/nf + 0.18u)'
+ ps='2*int((nf+2)/2) * (W/nf + 0.18u)' nrd='0.18u / W' nrs='0.18u / W' sa=0 sb=0 sd=0 m=1 par=1
XMND nc D VSS VSS nfet_03v3 L=0.28u W=4u nf=1 ad='int((nf+1)/2) * W/nf * 0.18u' as='int((nf+2)/2) * W/nf * 0.18u' pd='2*int((nf+1)/2) * (W/nf + 0.18u)'
+ ps='2*int((nf+2)/2) * (W/nf + 0.18u)' nrd='0.18u / W' nrs='0.18u / W' sa=0 sb=0 sd=0 m=1 par=1
XMPA pm A VDD VDD pfet_03v3 L=0.28u W=8u nf=1 ad='int((nf+1)/2) * W/nf * 0.18u' as='int((nf+2)/2) * W/nf * 0.18u' pd='2*int((nf+1)/2) * (W/nf + 0.18u)'
+ ps='2*int((nf+2)/2) * (W/nf + 0.18u)' nrd='0.18u / W' nrs='0.18u / W' sa=0 sb=0 sd=0 m=1 par=1
XMPB pm B VDD VDD pfet_03v3 L=0.28u W=8u nf=1 ad='int((nf+1)/2) * W/nf * 0.18u' as='int((nf+2)/2) * W/nf * 0.18u' pd='2*int((nf+1)/2) * (W/nf + 0.18u)'
+ ps='2*int((nf+2)/2) * (W/nf + 0.18u)' nrd='0.18u / W' nrs='0.18u / W' sa=0 sb=0 sd=0 m=1 par=1
XMPC Y C pm VDD pfet_03v3 L=0.28u W=8u nf=1 ad='int((nf+1)/2) * W/nf * 0.18u' as='int((nf+2)/2) * W/nf * 0.18u' pd='2*int((nf+1)/2) * (W/nf + 0.18u)'
+ ps='2*int((nf+2)/2) * (W/nf + 0.18u)' nrd='0.18u / W' nrs='0.18u / W' sa=0 sb=0 sd=0 m=1 par=1
XMPD Y D pm VDD pfet_03v3 L=0.28u W=8u nf=1 ad='int((nf+1)/2) * W/nf * 0.18u' as='int((nf+2)/2) * W/nf * 0.18u' pd='2*int((nf+1)/2) * (W/nf + 0.18u)'
+ ps='2*int((nf+2)/2) * (W/nf + 0.18u)' nrd='0.18u / W' nrs='0.18u / W' sa=0 sb=0 sd=0 m=1 par=1
.ends

* expanding   symbol:  nand2.sym # of pins=5
** sym_path: /home/noritsuna/GPS/xschem/nand2.sym
** sch_path: /home/noritsuna/GPS/xschem/nand2.sch
.subckt nand2 A B Y VDD VSS
*.ipin A
*.ipin B
*.opin Y
*.iopin VDD
*.iopin VSS
XMN1 Y A n1 VSS nfet_03v3 L=0.28u W=2u nf=1 ad='int((nf+1)/2) * W/nf * 0.18u' as='int((nf+2)/2) * W/nf * 0.18u' pd='2*int((nf+1)/2) * (W/nf + 0.18u)'
+ ps='2*int((nf+2)/2) * (W/nf + 0.18u)' nrd='0.18u / W' nrs='0.18u / W' sa=0 sb=0 sd=0 m=1 par=1
XMN2 n1 B VSS VSS nfet_03v3 L=0.28u W=2u nf=1 ad='int((nf+1)/2) * W/nf * 0.18u' as='int((nf+2)/2) * W/nf * 0.18u' pd='2*int((nf+1)/2) * (W/nf + 0.18u)'
+ ps='2*int((nf+2)/2) * (W/nf + 0.18u)' nrd='0.18u / W' nrs='0.18u / W' sa=0 sb=0 sd=0 m=1 par=1
XMP1 Y A VDD VDD pfet_03v3 L=0.28u W=2u nf=1 ad='int((nf+1)/2) * W/nf * 0.18u' as='int((nf+2)/2) * W/nf * 0.18u' pd='2*int((nf+1)/2) * (W/nf + 0.18u)'
+ ps='2*int((nf+2)/2) * (W/nf + 0.18u)' nrd='0.18u / W' nrs='0.18u / W' sa=0 sb=0 sd=0 m=1 par=1
XMP2 Y B VDD VDD pfet_03v3 L=0.28u W=2u nf=1 ad='int((nf+1)/2) * W/nf * 0.18u' as='int((nf+2)/2) * W/nf * 0.18u' pd='2*int((nf+1)/2) * (W/nf + 0.18u)'
+ ps='2*int((nf+2)/2) * (W/nf + 0.18u)' nrd='0.18u / W' nrs='0.18u / W' sa=0 sb=0 sd=0 m=1 par=1
.ends

* expanding   symbol:  nor2.sym # of pins=5
** sym_path: /home/noritsuna/GPS/xschem/nor2.sym
** sch_path: /home/noritsuna/GPS/xschem/nor2.sch
.subckt nor2 A B Y VDD VSS
*.ipin A
*.ipin B
*.opin Y
*.iopin VDD
*.iopin VSS
XMN1 Y A VSS VSS nfet_03v3 L=0.28u W=1u nf=1 ad='int((nf+1)/2) * W/nf * 0.18u' as='int((nf+2)/2) * W/nf * 0.18u' pd='2*int((nf+1)/2) * (W/nf + 0.18u)'
+ ps='2*int((nf+2)/2) * (W/nf + 0.18u)' nrd='0.18u / W' nrs='0.18u / W' sa=0 sb=0 sd=0 m=1 par=1
XMN2 Y B VSS VSS nfet_03v3 L=0.28u W=1u nf=1 ad='int((nf+1)/2) * W/nf * 0.18u' as='int((nf+2)/2) * W/nf * 0.18u' pd='2*int((nf+1)/2) * (W/nf + 0.18u)'
+ ps='2*int((nf+2)/2) * (W/nf + 0.18u)' nrd='0.18u / W' nrs='0.18u / W' sa=0 sb=0 sd=0 m=1 par=1
XMP1 n1 A VDD VDD pfet_03v3 L=0.28u W=4u nf=1 ad='int((nf+1)/2) * W/nf * 0.18u' as='int((nf+2)/2) * W/nf * 0.18u' pd='2*int((nf+1)/2) * (W/nf + 0.18u)'
+ ps='2*int((nf+2)/2) * (W/nf + 0.18u)' nrd='0.18u / W' nrs='0.18u / W' sa=0 sb=0 sd=0 m=1 par=1
XMP2 Y B n1 VDD pfet_03v3 L=0.28u W=4u nf=1 ad='int((nf+1)/2) * W/nf * 0.18u' as='int((nf+2)/2) * W/nf * 0.18u' pd='2*int((nf+1)/2) * (W/nf + 0.18u)'
+ ps='2*int((nf+2)/2) * (W/nf + 0.18u)' nrd='0.18u / W' nrs='0.18u / W' sa=0 sb=0 sd=0 m=1 par=1
.ends
* NGSPICE file created from vco_ring4_flat.ext - technology: gf180mcuD

.subckt vco_ring4_flat VSS VDD VCTRL B0 B1 LOIP LOIN LOQP LOQN VR
X0 VSS a_10387_27249.t6 a_26067_78349.t2 VSS nfet_03v3 ad=1.335p pd=6.89u as=0.795p ps=3.53u w=3u l=0.28u
X1 a_22707_78349.t2 a_8707_27249.t6 VSS VSS nfet_03v3 ad=0.795p pd=3.53u as=1.335p ps=6.89u w=3u l=0.28u
X2 VR.t41 a_24365_56340.t6 a_7027_78349.t0 VR.t40 pfet_03v3 ad=0.795p pd=3.53u as=0.795p ps=3.53u w=3u l=0.28u
X3 a_24365_56340.t1 a_16549_52000# VSS VSS nfet_03v3 ad=0.89p pd=4.89u as=0.89p ps=4.89u w=2u l=0.28u
X4 a_3667_78349.t0 a_22825_56340.t6 VR.t154 VR.t153 pfet_03v3 ad=0.795p pd=3.53u as=1.335p ps=6.89u w=3u l=0.28u
X5 VR.t329 VSS cap_mim_2f0_m4m5_noshield c_width=5u c_length=5u
X6 a_38505_26660# a_40067_27249# VR.t92 VR.t91 pfet_03v3 ad=0.89p pd=4.89u as=0.89p ps=4.89u w=2u l=0.28u
X7 VSS VSS a_26845_57069# VSS nfet_03v3 ad=1.78p pd=8.89u as=1.06p ps=4.53u w=4u l=0.4u
X8 VSS a_43427_78069# a_5347_78349.t2 VSS nfet_03v3 ad=1.335p pd=6.89u as=0.795p ps=3.53u w=3u l=0.28u
X9 a_3667_82689.t2 a_38569_65609# VSS VSS nfet_03v3 ad=0.795p pd=3.53u as=1.335p ps=6.89u w=3u l=0.28u
X10 VSS VSS a_17193_52000# VSS nfet_03v3 ad=1.78p pd=8.89u as=1.06p ps=4.53u w=4u l=0.4u
X11 a_31849_65609.t0 a_17093_52869# VR.t311 VR.t310 pfet_03v3 ad=1.78p pd=8.89u as=1.78p ps=8.89u w=4u l=0.28u
X12 VR.t125 a_16449_52869# a_16549_52000# VR.t124 pfet_03v3 ad=0.795p pd=3.53u as=0.795p ps=3.53u w=3u l=0.4u
X13 VR.t45 a_24365_56340.t6 a_7027_78349.t1 VR.t44 pfet_03v3 ad=1.335p pd=6.89u as=0.795p ps=3.53u w=3u l=0.28u
X14 VR.t17 a_25829_57069# a_16449_52869# VR.t16 pfet_03v3 ad=1.335p pd=6.89u as=0.795p ps=3.53u w=3u l=0.4u
X15 a_31569_13109# B0 VSS VSS nfet_03v3 ad=0.445p pd=2.89u as=0.445p ps=2.89u w=1u l=0.28u
X16 a_16549_52000# a_17193_52000# VR.t220 VR.t219 pfet_03v3 ad=0.89p pd=4.89u as=0.89p ps=4.89u w=2u l=0.4u
X17 a_3640_77480# a_5347_78349.t3 VSS VSS nfet_03v3 ad=1.78p pd=8.89u as=1.78p ps=8.89u w=4u l=0.28u
X18 a_16549_52000# a_16449_52869# VSS VSS nfet_03v3 ad=1.06p pd=4.53u as=1.78p ps=8.89u w=4u l=0.4u
X19 VR.t226 a_17193_52000# a_35309_56340# VR.t225 pfet_03v3 ad=1.335p pd=6.89u as=0.795p ps=3.53u w=3u l=0.4u
X20 a_32345_77480# a_26067_78349.t5 a_32200_91340# VR.t121 pfet_03v3 ad=3.56p pd=16.89u as=3.56p ps=16.89u w=8u l=0.28u
X21 a_36325_56340# a_16549_52000# VR.t178 VR.t177 pfet_03v3 ad=0.795p pd=3.53u as=1.335p ps=6.89u w=3u l=0.4u
X22 a_13160_91340# a_3667_78349.t5 VR.t145 VR.t144 pfet_03v3 ad=3.56p pd=16.89u as=3.56p ps=16.89u w=8u l=0.28u
X23 a_22680_91340# a_24387_78349# VR.t105 VR.t104 pfet_03v3 ad=3.56p pd=16.89u as=3.56p ps=16.89u w=8u l=0.28u
X24 a_18109_11960.t1 a_35769_13109.t12 VR.t95 VDD pfet_03v3 ad=1.325p pd=5.53u as=1.325p ps=5.53u w=5u l=0.28u
X25 VDD a_17709_13109.t83 VR.t191 VDD pfet_03v3 ad=1.325p pd=5.53u as=1.325p ps=5.53u w=5u l=0.28u
X26 a_40220_3486# a_40067_27249# VSS ppolyf_u_1k r_width=1u r_length=10u
X27 VR.t328 VSS cap_mim_2f0_m4m5_noshield c_width=5u c_length=5u
X28 a_41900_3486# a_42740_1364# VSS ppolyf_u_1k r_width=1u r_length=10u
X29 a_41865_77480# a_43427_78069# VR.t246 VR.t245 pfet_03v3 ad=0.89p pd=4.89u as=0.89p ps=4.89u w=2u l=0.28u
X30 a_52505_26660# a_22825_56340.t3 a_52360_26660# VSS nfet_03v3 ad=0.89p pd=4.89u as=0.89p ps=4.89u w=2u l=0.28u
X31 LOQP a_32345_77480# VSS VSS nfet_03v3 ad=0.795p pd=3.53u as=1.335p ps=6.89u w=3u l=0.28u
X32 a_18109_11960.t3 a_17709_13109.t16 VDD VDD pfet_03v3 ad=1.325p pd=5.53u as=1.325p ps=5.53u w=5u l=0.28u
X33 VR.t184 a_16549_52000# a_36325_56340# VR.t183 pfet_03v3 ad=1.335p pd=6.89u as=0.795p ps=3.53u w=3u l=0.4u
X34 VSS a_17193_52000# a_35309_56340# VSS nfet_03v3 ad=1.78p pd=8.89u as=1.06p ps=4.53u w=4u l=0.4u
X35 VR.t329 VSS cap_mim_2f0_m4m5_noshield c_width=5u c_length=5u
X36 VR.t197 a_17709_13109.t72 VDD VDD pfet_03v3 ad=1.325p pd=5.53u as=1.325p ps=5.53u w=5u l=0.28u
X37 VR.t329 VSS cap_mim_2f0_m4m5_noshield c_width=5u c_length=5u
X38 a_18109_11960.t2 a_35769_13109.t44 VR.t109 VDD pfet_03v3 ad=1.325p pd=5.53u as=1.325p ps=5.53u w=5u l=0.28u
X39 VDD a_17709_13109.t75 VR.t185 VDD pfet_03v3 ad=1.325p pd=5.53u as=1.325p ps=5.53u w=5u l=0.28u
X40 a_13160_77480# a_3667_82689.t3 VSS VSS nfet_03v3 ad=1.78p pd=8.89u as=1.78p ps=8.89u w=4u l=0.28u
X41 VDD a_17709_13109.t155 VR.t172 VDD pfet_03v3 ad=1.325p pd=5.53u as=1.325p ps=5.53u w=5u l=0.28u
X42 a_35309_56340# a_36325_56340# VSS VSS nfet_03v3 ad=0.445p pd=2.89u as=0.445p ps=2.89u w=1u l=0.4u
X43 a_22825_56340.t1 a_17193_52000# VSS VSS nfet_03v3 ad=0.89p pd=4.89u as=0.89p ps=4.89u w=2u l=0.28u
X44 a_18109_11960.t19 a_17709_13109.t88 VDD VDD pfet_03v3 ad=1.325p pd=5.53u as=1.325p ps=5.53u w=5u l=0.28u
X45 a_3640_91340# a_3667_78349.t6 VR.t169 VR.t168 pfet_03v3 ad=3.56p pd=16.89u as=3.56p ps=16.89u w=8u l=0.28u
X46 a_52505_26660# a_24365_56340.t5 VR.t297 VR.t296 pfet_03v3 ad=0.89p pd=4.89u as=0.89p ps=4.89u w=2u l=0.28u
X47 VR.t139 a_17709_13109.t144 VDD VDD pfet_03v3 ad=1.325p pd=5.53u as=1.325p ps=5.53u w=5u l=0.28u
X48 a_35769_13109.t0 B1.t0 VSS VSS nfet_03v3 ad=0.445p pd=2.89u as=0.445p ps=2.89u w=1u l=0.28u
X49 a_25829_57069# VSS VSS VSS nfet_03v3 ad=1.06p pd=4.53u as=1.78p ps=8.89u w=4u l=0.4u
X50 a_18109_11960.t26 a_17709_13109.t70 VDD VDD pfet_03v3 ad=1.325p pd=5.53u as=1.325p ps=5.53u w=5u l=0.28u
X51 a_16449_52869# a_25829_57069# VR.t11 VR.t10 pfet_03v3 ad=0.795p pd=3.53u as=1.335p ps=6.89u w=3u l=0.4u
X52 a_16665_27002# a_10387_27249.t4 a_16665_30860# VR.t29 pfet_03v3 ad=1.78p pd=8.89u as=1.78p ps=8.89u w=4u l=0.28u
X53 VSS a_22825_56340.t6 a_3667_78349.t2 VSS nfet_03v3 ad=1.335p pd=6.89u as=0.795p ps=3.53u w=3u l=0.28u
X54 VR.t328 VSS cap_mim_2f0_m4m5_noshield c_width=5u c_length=5u
X55 a_18109_11960.t23 a_17709_13109.t82 VDD VDD pfet_03v3 ad=1.325p pd=5.53u as=1.325p ps=5.53u w=5u l=0.28u
X56 VDD a_17709_13109.t147 VR.t89 VDD pfet_03v3 ad=1.325p pd=5.53u as=1.325p ps=5.53u w=5u l=0.28u
X57 VR.t143 a_35769_13109.t17 a_18109_11960.t1 VDD pfet_03v3 ad=1.325p pd=5.53u as=1.325p ps=5.53u w=5u l=0.28u
X58 VR.t329 VSS cap_mim_2f0_m4m5_noshield c_width=5u c_length=5u
X59 a_43427_78069# a_26845_57069# VSS VSS nfet_03v3 ad=0.89p pd=4.89u as=0.89p ps=4.89u w=2u l=0.28u
X60 a_17709_13109.t11 VCTRL a_35000_1180# VSS nfet_03v3 ad=1.325p pd=5.53u as=2.225p ps=10.89u w=5u l=0.5u
X61 a_60345_27002# a_24365_56340.t4 a_60345_30860# VR.t295 pfet_03v3 ad=1.78p pd=8.89u as=1.78p ps=8.89u w=4u l=0.28u
X62 a_65385_77822# a_31849_65609.t5 a_65385_81680# VR.t7 pfet_03v3 ad=1.78p pd=8.89u as=1.78p ps=8.89u w=4u l=0.28u
X63 VSS a_25129_65609.t2 a_22707_82689# VSS nfet_03v3 ad=1.335p pd=6.89u as=0.795p ps=3.53u w=3u l=0.28u
X64 VDD a_17709_13109.t21 VR.t5 VDD pfet_03v3 ad=1.325p pd=5.53u as=1.325p ps=5.53u w=5u l=0.28u
X65 VDD a_17709_13109.t77 a_18109_11960.t29 VDD pfet_03v3 ad=1.325p pd=5.53u as=1.325p ps=5.53u w=5u l=0.28u
X66 a_7027_78349.t0 a_24365_56340.t6 VR.t39 VR.t38 pfet_03v3 ad=0.795p pd=3.53u as=1.335p ps=6.89u w=3u l=0.28u
X67 a_18109_11960.t16 a_17709_13109.t142 VDD VDD pfet_03v3 ad=1.325p pd=5.53u as=1.325p ps=5.53u w=5u l=0.28u
X68 a_43427_78069# a_26845_57069# VR.t267 VR.t266 pfet_03v3 ad=1.78p pd=8.89u as=1.78p ps=8.89u w=4u l=0.28u
X69 VR.t329 VSS cap_mim_2f0_m4m5_noshield c_width=5u c_length=5u
X70 a_18109_11960.t9 a_17709_13109.t24 VDD VDD pfet_03v3 ad=1.325p pd=5.53u as=1.325p ps=5.53u w=5u l=0.28u
X71 a_18109_11960.t10 a_17709_13109.t154 VDD VDD pfet_03v3 ad=1.325p pd=5.53u as=1.325p ps=5.53u w=5u l=0.28u
X72 a_36325_56340# a_35309_56340# VR.t74 VR.t73 pfet_03v3 ad=0.89p pd=4.89u as=0.89p ps=4.89u w=2u l=0.4u
X73 a_40067_27249# VSS cap_mim_2f0_m4m5_noshield c_width=5u c_length=5u
X74 VR.t107 a_35769_13109.t49 a_18109_11960.t2 VDD pfet_03v3 ad=1.325p pd=5.53u as=1.325p ps=5.53u w=5u l=0.28u
X75 VR.t294 a_17709_13109.t80 VDD VDD pfet_03v3 ad=1.325p pd=5.53u as=1.325p ps=5.53u w=5u l=0.28u
X76 a_57545_77480# a_25129_65609.t6 VR.t199 VR.t198 pfet_03v3 ad=0.89p pd=4.89u as=0.89p ps=4.89u w=2u l=0.28u
X77 a_49705_81680# a_38569_65609# VR.t318 VR.t317 pfet_03v3 ad=1.78p pd=8.89u as=1.78p ps=8.89u w=4u l=0.28u
X78 a_18109_11960.t18 a_17709_13109.t42 VDD VDD pfet_03v3 ad=1.325p pd=5.53u as=1.325p ps=5.53u w=5u l=0.28u
X79 VSS a_24365_56340.t6 a_7027_78349.t2 VSS nfet_03v3 ad=1.335p pd=6.89u as=0.795p ps=3.53u w=3u l=0.28u
X80 a_3667_78349.t2 a_22825_56340.t6 VSS VSS nfet_03v3 ad=0.795p pd=3.53u as=1.335p ps=6.89u w=3u l=0.28u
X81 a_26067_78349.t0 a_10387_27249.t11 VR.t193 VR.t192 pfet_03v3 ad=0.795p pd=3.53u as=1.335p ps=6.89u w=3u l=0.28u
X82 a_36325_56340# a_16549_52000# VSS VSS nfet_03v3 ad=1.06p pd=4.53u as=1.78p ps=8.89u w=4u l=0.4u
X83 a_17193_52000# a_16549_52000# VSS VSS nfet_03v3 ad=0.445p pd=2.89u as=0.445p ps=2.89u w=1u l=0.4u
X84 VDD a_17709_13109.t93 VR.t59 VDD pfet_03v3 ad=1.325p pd=5.53u as=1.325p ps=5.53u w=5u l=0.28u
X85 VR.t328 VSS cap_mim_2f0_m4m5_noshield c_width=5u c_length=5u
X86 a_3785_77480# a_7027_78349.t6 a_3640_91340# VR.t48 pfet_03v3 ad=3.56p pd=16.89u as=3.56p ps=16.89u w=8u l=0.28u
X87 a_35000_1180# VSS VSS ppolyf_u_1k r_width=2u r_length=4u
X88 VDD a_17709_13109.t149 a_18109_11960.t22 VDD pfet_03v3 ad=1.325p pd=5.53u as=1.325p ps=5.53u w=5u l=0.28u
X89 a_32345_27002# a_17737_52869# VSS VSS nfet_03v3 ad=0.445p pd=2.89u as=0.445p ps=2.89u w=1u l=0.28u
X90 VR.t324 a_38569_65609# a_3667_82689.t1 VR.t323 pfet_03v3 ad=1.335p pd=6.89u as=0.795p ps=3.53u w=3u l=0.28u
X91 a_43580_3486# a_44420_1364# VSS ppolyf_u_1k r_width=1u r_length=10u
X92 VR.t329 VSS cap_mim_2f0_m4m5_noshield c_width=5u c_length=5u
X93 a_18109_11960.t4 a_17709_13109.t96 VDD VDD pfet_03v3 ad=1.325p pd=5.53u as=1.325p ps=5.53u w=5u l=0.28u
X94 a_46940_3486# a_46100_1364# VSS ppolyf_u_1k r_width=1u r_length=10u
X95 a_24505_30860# a_8825_26660# VR.t138 VR.t137 pfet_03v3 ad=1.78p pd=8.89u as=1.78p ps=8.89u w=4u l=0.28u
X96 a_22707_82689# a_25129_65609.t2 VSS VSS nfet_03v3 ad=0.795p pd=3.53u as=1.335p ps=6.89u w=3u l=0.28u
X97 VSS a_31849_65609.t2 a_24387_78349# VSS nfet_03v3 ad=1.335p pd=6.89u as=0.795p ps=3.53u w=3u l=0.28u
X98 VDD a_17709_13109.t37 VR.t214 VDD pfet_03v3 ad=1.325p pd=5.53u as=1.325p ps=5.53u w=5u l=0.28u
X99 VDD a_17709_13109.t17 VR.t200 VDD pfet_03v3 ad=1.325p pd=5.53u as=1.325p ps=5.53u w=5u l=0.28u
X100 VR.t96 a_17709_13109.t152 VDD VDD pfet_03v3 ad=1.325p pd=5.53u as=1.325p ps=5.53u w=5u l=0.28u
X101 a_18109_11960.t1 a_35769_13109.t22 VR.t1 VDD pfet_03v3 ad=1.325p pd=5.53u as=1.325p ps=5.53u w=5u l=0.28u
X102 a_18109_11960.t34 a_17709_13109.t114 VDD VDD pfet_03v3 ad=1.325p pd=5.53u as=1.325p ps=5.53u w=5u l=0.28u
X103 VDD a_17709_13109.t73 a_18109_11960.t20 VDD pfet_03v3 ad=1.325p pd=5.53u as=1.325p ps=5.53u w=5u l=0.28u
X104 VR.t329 VSS cap_mim_2f0_m4m5_noshield c_width=5u c_length=5u
X105 LOIN.t1 a_13305_77480# VR.t207 VR.t206 pfet_03v3 ad=0.795p pd=3.53u as=1.335p ps=6.89u w=3u l=0.28u
X106 a_17193_52000# a_17093_52869# VR.t307 VR.t306 pfet_03v3 ad=0.795p pd=3.53u as=0.795p ps=3.53u w=3u l=0.4u
X107 VSS VSS a_16449_52869# VSS nfet_03v3 ad=1.78p pd=8.89u as=1.06p ps=4.53u w=4u l=0.4u
X108 VR.t94 a_35769_13109.t25 a_18109_11960.t1 VDD pfet_03v3 ad=1.325p pd=5.53u as=1.325p ps=5.53u w=5u l=0.28u
X109 VR.t196 a_17709_13109.t26 VDD VDD pfet_03v3 ad=1.325p pd=5.53u as=1.325p ps=5.53u w=5u l=0.28u
X110 a_17093_52869# VSS VSS VSS nfet_03v3 ad=1.06p pd=4.53u as=1.78p ps=8.89u w=4u l=0.4u
X111 VR.t185 a_17709_13109.t76 VDD VDD pfet_03v3 ad=1.325p pd=5.53u as=1.325p ps=5.53u w=5u l=0.28u
X112 a_17193_52000# a_16549_52000# VR.t176 VR.t175 pfet_03v3 ad=0.89p pd=4.89u as=0.89p ps=4.89u w=2u l=0.4u
X113 VR.t93 a_35769_13109.t11 a_18109_11960.t1 VDD pfet_03v3 ad=1.325p pd=5.53u as=1.325p ps=5.53u w=5u l=0.28u
X114 VDD a_17709_13109.t29 VR.t90 VDD pfet_03v3 ad=1.325p pd=5.53u as=1.325p ps=5.53u w=5u l=0.28u
X115 VDD a_17709_13109.t109 VR.t171 VDD pfet_03v3 ad=1.325p pd=5.53u as=1.325p ps=5.53u w=5u l=0.28u
X116 a_40220_3486# a_41060_1364# VSS ppolyf_u_1k r_width=1u r_length=10u
X117 VDD a_17709_13109.t89 VR.t201 VDD pfet_03v3 ad=1.325p pd=5.53u as=1.325p ps=5.53u w=5u l=0.28u
X118 a_43580_3486# a_42740_1364# VSS ppolyf_u_1k r_width=1u r_length=10u
X119 a_18109_11960.t2 a_35769_13109.t54 VR.t101 VDD pfet_03v3 ad=1.325p pd=5.53u as=1.325p ps=5.53u w=5u l=0.28u
X120 VDD a_17709_13109.t15 a_18109_11960.t3 VDD pfet_03v3 ad=1.325p pd=5.53u as=1.325p ps=5.53u w=5u l=0.28u
X121 a_18109_11960.t0 a_35769_13109.t20 VR.t0 VDD pfet_03v3 ad=1.325p pd=5.53u as=1.325p ps=5.53u w=5u l=0.28u
X122 VDD a_17709_13109.t45 a_21997_11960# VDD pfet_03v3 ad=1.325p pd=5.53u as=1.325p ps=5.53u w=5u l=0.28u
X123 a_32345_77480# a_26067_78349.t3 a_32345_81820# VSS nfet_03v3 ad=1.78p pd=8.89u as=1.78p ps=8.89u w=4u l=0.28u
X124 VDD a_17709_13109.t145 a_18109_11960.t7 VDD pfet_03v3 ad=1.325p pd=5.53u as=1.325p ps=5.53u w=5u l=0.28u
X125 a_13305_81820# a_5347_78349.t4 VSS VSS nfet_03v3 ad=1.78p pd=8.89u as=1.78p ps=8.89u w=4u l=0.28u
X126 a_13305_77480# a_3667_78349.t3 a_13160_77480# VSS nfet_03v3 ad=1.78p pd=8.89u as=1.78p ps=8.89u w=4u l=0.28u
X127 a_22680_77480# a_24387_78349# VSS VSS nfet_03v3 ad=1.78p pd=8.89u as=1.78p ps=8.89u w=4u l=0.28u
X128 VR.t13 a_25829_57069# a_16449_52869# VR.t12 pfet_03v3 ad=0.795p pd=3.53u as=0.795p ps=3.53u w=3u l=0.4u
X129 VDD a_17709_13109.t71 VR.t197 VDD pfet_03v3 ad=1.325p pd=5.53u as=1.325p ps=5.53u w=5u l=0.28u
X130 LOQN a_22825_77480# VSS VSS nfet_03v3 ad=0.795p pd=3.53u as=1.335p ps=6.89u w=3u l=0.28u
X131 VR.t320 a_38569_65609# a_3667_82689.t0 VR.t319 pfet_03v3 ad=0.795p pd=3.53u as=0.795p ps=3.53u w=3u l=0.28u
X132 VR.t328 VSS cap_mim_2f0_m4m5_noshield c_width=5u c_length=5u
X133 VR.t189 a_35769_13109.t57 a_18109_11960.t2 VDD pfet_03v3 ad=1.325p pd=5.53u as=1.325p ps=5.53u w=5u l=0.28u
X134 a_16449_52869# a_17093_52869# VR.t301 VR.t300 pfet_03v3 ad=0.89p pd=4.89u as=0.89p ps=4.89u w=2u l=0.4u
X135 VR.t200 a_17709_13109.t18 VDD VDD pfet_03v3 ad=1.325p pd=5.53u as=1.325p ps=5.53u w=5u l=0.28u
X136 VR.t108 a_17709_13109.t98 VDD VDD pfet_03v3 ad=1.325p pd=5.53u as=1.325p ps=5.53u w=5u l=0.28u
X137 VR.t288 a_36325_56340# a_26845_57069# VR.t287 pfet_03v3 ad=1.335p pd=6.89u as=0.795p ps=3.53u w=3u l=0.4u
X138 VR.t329 VSS cap_mim_2f0_m4m5_noshield c_width=5u c_length=5u
X139 VR.t89 a_17709_13109.t148 VDD VDD pfet_03v3 ad=1.325p pd=5.53u as=1.325p ps=5.53u w=5u l=0.28u
X140 VR.t88 a_35769_13109.t43 a_18109_11960.t2 VDD pfet_03v3 ad=1.325p pd=5.53u as=1.325p ps=5.53u w=5u l=0.28u
X141 a_18109_11960.t20 a_17709_13109.t74 VDD VDD pfet_03v3 ad=1.325p pd=5.53u as=1.325p ps=5.53u w=5u l=0.28u
X142 a_16665_27002# a_8707_27249.t2 VSS VSS nfet_03v3 ad=0.445p pd=2.89u as=0.445p ps=2.89u w=1u l=0.28u
X143 VR.t2 a_35769_13109.t9 a_18109_11960.t1 VDD pfet_03v3 ad=1.325p pd=5.53u as=1.325p ps=5.53u w=5u l=0.28u
X144 VR.t329 VSS cap_mim_2f0_m4m5_noshield c_width=5u c_length=5u
X145 a_18109_11960.t14 a_17709_13109.t36 VDD VDD pfet_03v3 ad=1.325p pd=5.53u as=1.325p ps=5.53u w=5u l=0.28u
X146 VSS VSS a_25829_57069# VSS nfet_03v3 ad=1.78p pd=8.89u as=1.06p ps=4.53u w=4u l=0.4u
X147 a_16549_52000# a_16449_52869# VR.t127 VR.t126 pfet_03v3 ad=0.795p pd=3.53u as=0.795p ps=3.53u w=3u l=0.4u
X148 VDD a_17709_13109.t101 VR.t165 VDD pfet_03v3 ad=1.325p pd=5.53u as=1.325p ps=5.53u w=5u l=0.28u
X149 a_8680_26660# a_10387_27249.t3 VSS VSS nfet_03v3 ad=0.89p pd=4.89u as=0.89p ps=4.89u w=2u l=0.28u
X150 VR.t5 a_17709_13109.t22 VDD VDD pfet_03v3 ad=1.325p pd=5.53u as=1.325p ps=5.53u w=5u l=0.28u
X151 VDD a_17709_13109.t87 a_18109_11960.t19 VDD pfet_03v3 ad=1.325p pd=5.53u as=1.325p ps=5.53u w=5u l=0.28u
X152 VSS a_16449_52869# a_16549_52000# VSS nfet_03v3 ad=1.78p pd=8.89u as=1.06p ps=4.53u w=4u l=0.4u
X153 a_17193_52000# a_17093_52869# VSS VSS nfet_03v3 ad=1.06p pd=4.53u as=1.78p ps=8.89u w=4u l=0.4u
X154 VR.t84 a_35769_13109.t27 a_18109_11960.t1 VDD pfet_03v3 ad=1.325p pd=5.53u as=1.325p ps=5.53u w=5u l=0.28u
X155 a_18109_11960.t2 a_35769_13109.t52 VR.t100 VDD pfet_03v3 ad=1.325p pd=5.53u as=1.325p ps=5.53u w=5u l=0.28u
X156 VR.t180 a_16549_52000# a_36325_56340# VR.t179 pfet_03v3 ad=0.795p pd=3.53u as=0.795p ps=3.53u w=3u l=0.4u
X157 VDD a_17709_13109.t13 VR.t166 VDD pfet_03v3 ad=2.225p pd=10.89u as=1.325p ps=5.53u w=5u l=0.28u
X158 VDD a_17709_13109.t117 a_21997_11960# VDD pfet_03v3 ad=1.325p pd=5.53u as=1.325p ps=5.53u w=5u l=0.28u
X159 a_26067_27389# VSS cap_mim_2f0_m4m5_noshield c_width=5u c_length=5u
X160 VDD a_17709_13109.t43 VR.t23 VDD pfet_03v3 ad=1.325p pd=5.53u as=1.325p ps=5.53u w=5u l=0.28u
X161 a_18109_11960.t29 a_17709_13109.t78 VDD VDD pfet_03v3 ad=1.325p pd=5.53u as=1.325p ps=5.53u w=5u l=0.28u
X162 VDD a_17709_13109.t143 VR.t139 VDD pfet_03v3 ad=1.325p pd=5.53u as=1.325p ps=5.53u w=5u l=0.28u
X163 VR.t329 VSS cap_mim_2f0_m4m5_noshield c_width=5u c_length=5u
X164 a_26845_57069# a_36325_56340# VSS VSS nfet_03v3 ad=1.06p pd=4.53u as=1.78p ps=8.89u w=4u l=0.4u
X165 VR.t201 a_17709_13109.t90 VDD VDD pfet_03v3 ad=1.325p pd=5.53u as=1.325p ps=5.53u w=5u l=0.28u
X166 a_37337_52869# a_38505_26660# VSS VSS nfet_03v3 ad=0.445p pd=2.89u as=0.445p ps=2.89u w=1u l=0.28u
X167 a_18109_11960.t1 a_35769_13109.t30 VR.t190 VDD pfet_03v3 ad=1.325p pd=5.53u as=1.325p ps=5.53u w=5u l=0.28u
X168 VDD a_17709_13109.t31 a_18109_11960.t8 VDD pfet_03v3 ad=1.325p pd=5.53u as=1.325p ps=5.53u w=5u l=0.28u
X169 a_22707_82689# a_25129_65609.t2 VR.t240 VR.t239 pfet_03v3 ad=0.795p pd=3.53u as=0.795p ps=3.53u w=3u l=0.28u
X170 a_49705_77822# a_43427_78069# a_49705_81680# VR.t247 pfet_03v3 ad=1.78p pd=8.89u as=1.78p ps=8.89u w=4u l=0.28u
X171 VDD a_17709_13109.t81 a_18109_11960.t23 VDD pfet_03v3 ad=1.325p pd=5.53u as=1.325p ps=5.53u w=5u l=0.28u
X172 a_18109_11960.t7 a_17709_13109.t146 VDD VDD pfet_03v3 ad=1.325p pd=5.53u as=1.325p ps=5.53u w=5u l=0.28u
X173 a_60345_30860# a_22825_56340.t4 VR.t188 VR.t187 pfet_03v3 ad=1.78p pd=8.89u as=1.78p ps=8.89u w=4u l=0.28u
X174 a_3785_81820# a_3667_82689.t4 VSS VSS nfet_03v3 ad=1.78p pd=8.89u as=1.78p ps=8.89u w=4u l=0.28u
X175 a_18109_11960.t1 a_35769_13109.t16 VR.t143 VDD pfet_03v3 ad=1.325p pd=5.53u as=1.325p ps=5.53u w=5u l=0.28u
X176 a_3785_77480# a_3667_78349.t4 a_3640_77480# VSS nfet_03v3 ad=1.78p pd=8.89u as=1.78p ps=8.89u w=4u l=0.28u
X177 VR.t253 a_43427_78069# a_5347_78349.t0 VR.t252 pfet_03v3 ad=0.795p pd=3.53u as=0.795p ps=3.53u w=3u l=0.28u
X178 VR.t87 a_35769_13109.t41 a_18109_11960.t2 VDD pfet_03v3 ad=1.325p pd=5.53u as=1.325p ps=5.53u w=5u l=0.28u
X179 a_3667_82689.t0 a_38569_65609# VR.t316 VR.t315 pfet_03v3 ad=0.795p pd=3.53u as=1.335p ps=6.89u w=3u l=0.28u
X180 a_18109_11960.t15 a_17709_13109.t108 VDD VDD pfet_03v3 ad=1.325p pd=5.53u as=1.325p ps=5.53u w=5u l=0.28u
X181 LOQP a_32345_77480# VR.t114 VR.t113 pfet_03v3 ad=0.795p pd=3.53u as=1.335p ps=6.89u w=3u l=0.28u
X182 a_22680_91340# a_22707_78349.t6 VR.t69 VR.t68 pfet_03v3 ad=3.56p pd=16.89u as=3.56p ps=16.89u w=8u l=0.28u
X183 a_32200_91340# a_22707_82689# VR.t327 VR.t326 pfet_03v3 ad=3.56p pd=16.89u as=3.56p ps=16.89u w=8u l=0.28u
X184 VR.t136 a_17709_13109.t34 VDD VDD pfet_03v3 ad=1.325p pd=5.53u as=1.325p ps=5.53u w=5u l=0.28u
X185 a_18109_11960.t30 a_17709_13109.t62 VDD VDD pfet_03v3 ad=1.325p pd=5.53u as=1.325p ps=5.53u w=5u l=0.28u
X186 VR.t59 a_17709_13109.t94 VDD VDD pfet_03v3 ad=1.325p pd=5.53u as=1.325p ps=5.53u w=5u l=0.28u
X187 VR.t204 a_35769_13109.t19 a_18109_11960.t0 VDD pfet_03v3 ad=1.325p pd=5.53u as=1.325p ps=5.53u w=5u l=0.28u
X188 VR.t27 a_35769_13109.t59 a_18109_11960.t2 VDD pfet_03v3 ad=1.325p pd=5.53u as=1.325p ps=5.53u w=5u l=0.28u
X189 a_18109_11960.t12 a_17709_13109.t20 VDD VDD pfet_03v3 ad=1.325p pd=5.53u as=1.325p ps=5.53u w=5u l=0.28u
X190 VDD a_17709_13109.t85 VR.t167 VDD pfet_03v3 ad=2.225p pd=10.89u as=1.325p ps=5.53u w=5u l=0.28u
X191 a_25829_57069# a_26845_57069# VSS VSS nfet_03v3 ad=0.445p pd=2.89u as=0.445p ps=2.89u w=1u l=0.4u
X192 a_18109_11960.t27 a_17709_13109.t50 VDD VDD pfet_03v3 ad=1.325p pd=5.53u as=1.325p ps=5.53u w=5u l=0.28u
X193 a_18109_11960.t22 a_17709_13109.t150 VDD VDD pfet_03v3 ad=1.325p pd=5.53u as=1.325p ps=5.53u w=5u l=0.28u
X194 VSS a_32345_77480# LOQP VSS nfet_03v3 ad=1.335p pd=6.89u as=0.795p ps=3.53u w=3u l=0.28u
X195 a_41865_77480# a_38569_65609# a_41720_77480# VSS nfet_03v3 ad=0.89p pd=4.89u as=0.89p ps=4.89u w=2u l=0.28u
X196 a_45260_3486# a_46100_1364# VSS ppolyf_u_1k r_width=1u r_length=10u
X197 VDD a_17709_13109.t115 VR.t110 VDD pfet_03v3 ad=1.325p pd=5.53u as=1.325p ps=5.53u w=5u l=0.28u
X198 a_35000_1180# VCTRL a_17709_13109.t12 VSS nfet_03v3 ad=2.225p pd=10.89u as=1.325p ps=5.53u w=5u l=0.5u
X199 a_18109_11960.t2 a_35769_13109.t62 VR.t299 VDD pfet_03v3 ad=1.325p pd=5.53u as=1.325p ps=5.53u w=5u l=0.28u
X200 VDD a_17709_13109.t23 a_18109_11960.t9 VDD pfet_03v3 ad=1.325p pd=5.53u as=1.325p ps=5.53u w=5u l=0.28u
X201 a_7027_78349.t2 a_24365_56340.t6 VSS VSS nfet_03v3 ad=0.795p pd=3.53u as=1.335p ps=6.89u w=3u l=0.28u
X202 VSS a_16549_52000# a_36325_56340# VSS nfet_03v3 ad=1.78p pd=8.89u as=1.06p ps=4.53u w=4u l=0.4u
X203 a_35309_56340# a_17193_52000# VR.t216 VR.t215 pfet_03v3 ad=0.795p pd=3.53u as=1.335p ps=6.89u w=3u l=0.4u
X204 VR.t328 VSS cap_mim_2f0_m4m5_noshield c_width=5u c_length=5u
X205 VDD a_17709_13109.t103 a_18109_11960.t5 VDD pfet_03v3 ad=1.325p pd=5.53u as=1.325p ps=5.53u w=5u l=0.28u
X206 a_35309_56340# a_37337_52869# VSS VSS nfet_03v3 ad=1.06p pd=4.53u as=1.78p ps=8.89u w=4u l=0.4u
X207 a_18109_11960.t1 a_35769_13109.t28 VR.t85 VDD pfet_03v3 ad=1.325p pd=5.53u as=1.325p ps=5.53u w=5u l=0.28u
X208 VR.t329 VSS cap_mim_2f0_m4m5_noshield c_width=5u c_length=5u
X209 VDD a_17709_13109.t53 VR.t146 VDD pfet_03v3 ad=1.325p pd=5.53u as=1.325p ps=5.53u w=5u l=0.28u
X210 VDD a_17709_13109.t153 a_18109_11960.t10 VDD pfet_03v3 ad=1.325p pd=5.53u as=1.325p ps=5.53u w=5u l=0.28u
X211 a_18109_11960.t2 a_35769_13109.t48 VR.t107 VDD pfet_03v3 ad=1.325p pd=5.53u as=1.325p ps=5.53u w=5u l=0.28u
X212 VDD a_17709_13109.t79 VR.t294 VDD pfet_03v3 ad=1.325p pd=5.53u as=1.325p ps=5.53u w=5u l=0.28u
X213 a_38569_65609# a_25829_57069# VSS VSS nfet_03v3 ad=0.89p pd=4.89u as=0.89p ps=4.89u w=2u l=0.28u
X214 a_18109_11960.t1 a_35769_13109.t14 VR.t142 VDD pfet_03v3 ad=1.325p pd=5.53u as=1.325p ps=5.53u w=5u l=0.28u
X215 VR.t255 a_43427_78069# a_5347_78349.t1 VR.t254 pfet_03v3 ad=1.335p pd=6.89u as=0.795p ps=3.53u w=3u l=0.28u
X216 a_17709_13109.t12 VCTRL a_35000_1180# VSS nfet_03v3 ad=1.325p pd=5.53u as=1.325p ps=5.53u w=5u l=0.5u
X217 VDD a_17709_13109.t41 a_18109_11960.t18 VDD pfet_03v3 ad=1.325p pd=5.53u as=1.325p ps=5.53u w=5u l=0.28u
X218 VR.t83 a_17709_13109.t106 VDD VDD pfet_03v3 ad=1.325p pd=5.53u as=1.325p ps=5.53u w=5u l=0.28u
X219 VR.t309 a_17093_52869# a_17193_52000# VR.t308 pfet_03v3 ad=1.335p pd=6.89u as=0.795p ps=3.53u w=3u l=0.4u
X220 a_25129_65609.t1 a_16449_52869# VSS VSS nfet_03v3 ad=0.89p pd=4.89u as=0.89p ps=4.89u w=2u l=0.28u
X221 a_8707_27249.t0 a_36325_56340# VR.t278 VR.t277 pfet_03v3 ad=1.78p pd=8.89u as=1.78p ps=8.89u w=4u l=0.28u
X222 a_18109_11960.t6 a_17709_13109.t134 VDD VDD pfet_03v3 ad=1.325p pd=5.53u as=1.325p ps=5.53u w=5u l=0.28u
X223 a_24387_78349# a_31849_65609.t2 VR.t273 VR.t272 pfet_03v3 ad=0.795p pd=3.53u as=0.795p ps=3.53u w=3u l=0.28u
X224 a_24387_78349# a_31849_65609.t2 VSS VSS nfet_03v3 ad=0.795p pd=3.53u as=1.335p ps=6.89u w=3u l=0.28u
X225 VR.t205 a_35769_13109.t51 a_18109_11960.t2 VDD pfet_03v3 ad=1.325p pd=5.53u as=1.325p ps=5.53u w=5u l=0.28u
X226 VDD a_17709_13109.t27 a_18109_11960.t25 VDD pfet_03v3 ad=1.325p pd=5.53u as=1.325p ps=5.53u w=5u l=0.28u
X227 a_18109_11960.t17 a_17709_13109.t92 VDD VDD pfet_03v3 ad=1.325p pd=5.53u as=1.325p ps=5.53u w=5u l=0.28u
X228 a_8825_26660# a_8707_27249.t3 a_8680_26660# VSS nfet_03v3 ad=0.89p pd=4.89u as=0.89p ps=4.89u w=2u l=0.28u
X229 a_18109_11960.t1 a_35769_13109.t32 VR.t293 VDD pfet_03v3 ad=1.325p pd=5.53u as=1.325p ps=5.53u w=5u l=0.28u
X230 a_26067_78349.t2 a_10387_27249.t7 VSS VSS nfet_03v3 ad=0.795p pd=3.53u as=1.335p ps=6.89u w=3u l=0.28u
X231 a_35000_1180# VCTRL a_17709_13109.t11 VSS nfet_03v3 ad=1.325p pd=5.53u as=1.325p ps=5.53u w=5u l=0.5u
X232 a_18109_11960.t13 a_17709_13109.t122 VDD VDD pfet_03v3 ad=1.325p pd=5.53u as=1.325p ps=5.53u w=5u l=0.28u
X233 a_18109_11960.t33 a_17709_13109.t48 VDD VDD pfet_03v3 ad=1.325p pd=5.53u as=1.325p ps=5.53u w=5u l=0.28u
X234 a_25829_57069# a_35309_56340# VR.t72 VR.t71 pfet_03v3 ad=0.795p pd=3.53u as=1.335p ps=6.89u w=3u l=0.4u
X235 VR.t120 a_32345_77480# LOQP VR.t119 pfet_03v3 ad=1.335p pd=6.89u as=0.795p ps=3.53u w=3u l=0.28u
X236 VR.t90 a_17709_13109.t30 VDD VDD pfet_03v3 ad=1.325p pd=5.53u as=1.325p ps=5.53u w=5u l=0.28u
X237 a_39800_3486# a_26067_27389# VSS ppolyf_u_1k r_width=1u r_length=10u
X238 VDD a_17709_13109.t95 a_18109_11960.t4 VDD pfet_03v3 ad=1.325p pd=5.53u as=1.325p ps=5.53u w=5u l=0.28u
X239 a_52505_26660# a_22825_56340.t5 VR.t4 VR.t3 pfet_03v3 ad=0.89p pd=4.89u as=0.89p ps=4.89u w=2u l=0.28u
X240 a_13305_77480# a_5347_78349.t6 a_13160_91340# VR.t70 pfet_03v3 ad=3.56p pd=16.89u as=3.56p ps=16.89u w=8u l=0.28u
X241 a_45260_3486# a_44420_1364# VSS ppolyf_u_1k r_width=1u r_length=10u
X242 a_18109_11960.t2 a_35769_13109.t60 VR.t28 VDD pfet_03v3 ad=1.325p pd=5.53u as=1.325p ps=5.53u w=5u l=0.28u
X243 VDD a_17709_13109.t125 VR.t24 VDD pfet_03v3 ad=1.325p pd=5.53u as=1.325p ps=5.53u w=5u l=0.28u
X244 VSS VSS a_17093_52869# VSS nfet_03v3 ad=1.78p pd=8.89u as=1.06p ps=4.53u w=4u l=0.4u
X245 a_5347_78349.t2 a_43427_78069# VSS VSS nfet_03v3 ad=0.795p pd=3.53u as=1.335p ps=6.89u w=3u l=0.28u
X246 a_46940_3486# a_16665_27002# VSS ppolyf_u_1k r_width=1u r_length=10u
X247 VDD a_17709_13109.t51 a_21997_11960# VDD pfet_03v3 ad=1.325p pd=5.53u as=1.325p ps=5.53u w=5u l=0.28u
X248 VDD a_17709_13109.t151 VR.t96 VDD pfet_03v3 ad=1.325p pd=5.53u as=1.325p ps=5.53u w=5u l=0.28u
X249 a_25829_57069# a_26845_57069# VR.t257 VR.t256 pfet_03v3 ad=0.89p pd=4.89u as=0.89p ps=4.89u w=2u l=0.4u
X250 VR.t0 a_35769_13109.t21 a_18109_11960.t1 VDD pfet_03v3 ad=1.325p pd=5.53u as=1.325p ps=5.53u w=5u l=0.28u
X251 a_18109_11960.t2 a_35769_13109.t46 VR.t106 VDD pfet_03v3 ad=1.325p pd=5.53u as=1.325p ps=5.53u w=5u l=0.28u
X252 VDD a_17709_13109.t113 a_18109_11960.t34 VDD pfet_03v3 ad=1.325p pd=5.53u as=1.325p ps=5.53u w=5u l=0.28u
X253 a_3785_77480# a_7027_78349.t4 a_3785_81820# VSS nfet_03v3 ad=1.78p pd=8.89u as=1.78p ps=8.89u w=4u l=0.28u
X254 VDD a_17709_13109.t39 a_21997_11960# VDD pfet_03v3 ad=1.325p pd=5.53u as=1.325p ps=5.53u w=5u l=0.28u
X255 VR.t329 VSS cap_mim_2f0_m4m5_noshield c_width=5u c_length=5u
X256 VR.t328 VSS cap_mim_2f0_m4m5_noshield c_width=5u c_length=5u
X257 VDD a_17709_13109.t67 VR.t298 VDD pfet_03v3 ad=1.325p pd=5.53u as=1.325p ps=5.53u w=5u l=0.28u
X258 VDD a_17709_13109.t99 a_18109_11960.t11 VDD pfet_03v3 ad=1.325p pd=5.53u as=1.325p ps=5.53u w=5u l=0.28u
X259 a_18109_11960.t1 a_35769_13109.t24 VR.t94 VDD pfet_03v3 ad=1.325p pd=5.53u as=1.325p ps=5.53u w=5u l=0.28u
X260 a_18109_11960.t2 a_35769_13109.t64 VR.t102 VDD pfet_03v3 ad=1.325p pd=5.53u as=1.325p ps=5.53u w=5u l=0.28u
X261 VDD a_17709_13109.t25 VR.t196 VDD pfet_03v3 ad=1.325p pd=5.53u as=1.325p ps=5.53u w=5u l=0.28u
X262 a_16449_52869# a_25829_57069# VSS VSS nfet_03v3 ad=1.06p pd=4.53u as=1.78p ps=8.89u w=4u l=0.4u
X263 VDD a_17709_13109.t7 a_17709_13109.t6 VDD pfet_03v3 ad=1.325p pd=5.53u as=1.325p ps=5.53u w=5u l=0.28u
X264 a_18109_11960.t21 a_17709_13109.t120 VDD VDD pfet_03v3 ad=1.325p pd=5.53u as=1.325p ps=5.53u w=5u l=0.28u
X265 a_18109_11960.t1 a_35769_13109.t10 VR.t93 VDD pfet_03v3 ad=1.325p pd=5.53u as=1.325p ps=5.53u w=5u l=0.28u
X266 a_65385_81680# a_25129_65609.t5 VR.t244 VR.t243 pfet_03v3 ad=1.78p pd=8.89u as=1.78p ps=8.89u w=4u l=0.28u
X267 VR.t329 VSS cap_mim_2f0_m4m5_noshield c_width=5u c_length=5u
X268 VR.t165 a_17709_13109.t102 VDD VDD pfet_03v3 ad=1.325p pd=5.53u as=1.325p ps=5.53u w=5u l=0.28u
X269 a_18109_11960.t25 a_17709_13109.t28 VDD VDD pfet_03v3 ad=1.325p pd=5.53u as=1.325p ps=5.53u w=5u l=0.28u
X270 VSS a_22825_77480# LOQN VSS nfet_03v3 ad=1.335p pd=6.89u as=0.795p ps=3.53u w=3u l=0.28u
X271 VR.t293 a_35769_13109.t33 a_18109_11960.t1 VDD pfet_03v3 ad=1.325p pd=5.53u as=2.225p ps=10.89u w=5u l=0.28u
X272 a_18109_11960.t24 a_17709_13109.t56 VDD VDD pfet_03v3 ad=1.325p pd=5.53u as=1.325p ps=5.53u w=5u l=0.28u
X273 VDD a_17709_13109.t123 a_21997_11960# VDD pfet_03v3 ad=1.325p pd=5.53u as=1.325p ps=5.53u w=5u l=0.28u
X274 VR.t95 a_35769_13109.t13 a_18109_11960.t1 VDD pfet_03v3 ad=1.325p pd=5.53u as=1.325p ps=5.53u w=5u l=0.28u
X275 LOQP a_32345_77480# VR.t118 VR.t117 pfet_03v3 ad=0.795p pd=3.53u as=0.795p ps=3.53u w=3u l=0.28u
X276 VR.t100 a_35769_13109.t53 a_18109_11960.t2 VDD pfet_03v3 ad=1.325p pd=5.53u as=1.325p ps=5.53u w=5u l=0.28u
X277 VR.t166 a_17709_13109.t14 VDD VDD pfet_03v3 ad=1.325p pd=5.53u as=1.325p ps=5.53u w=5u l=0.28u
X278 VR.t191 a_17709_13109.t84 VDD VDD pfet_03v3 ad=1.325p pd=5.53u as=2.225p ps=10.89u w=5u l=0.28u
X279 VR.t23 a_17709_13109.t44 VDD VDD pfet_03v3 ad=1.325p pd=5.53u as=1.325p ps=5.53u w=5u l=0.28u
X280 VDD a_17709_13109.t111 a_21997_11960# VDD pfet_03v3 ad=1.325p pd=5.53u as=1.325p ps=5.53u w=5u l=0.28u
X281 a_17737_52869# a_26067_27389# VSS VSS nfet_03v3 ad=0.445p pd=2.89u as=0.445p ps=2.89u w=1u l=0.28u
X282 VSS a_36325_56340# a_26845_57069# VSS nfet_03v3 ad=1.78p pd=8.89u as=1.06p ps=4.53u w=4u l=0.4u
X283 a_3785_77480# a_3667_82689.t6 a_3640_91340# VR.t22 pfet_03v3 ad=3.56p pd=16.89u as=3.56p ps=16.89u w=8u l=0.28u
X284 a_3667_82689.t1 a_38569_65609# VR.t322 VR.t321 pfet_03v3 ad=0.795p pd=3.53u as=0.795p ps=3.53u w=3u l=0.28u
X285 a_17193_52000# a_17093_52869# VR.t303 VR.t302 pfet_03v3 ad=0.795p pd=3.53u as=1.335p ps=6.89u w=3u l=0.4u
X286 VDD a_17709_13109.t139 VR.t186 VDD pfet_03v3 ad=1.325p pd=5.53u as=1.325p ps=5.53u w=5u l=0.28u
X287 a_17093_52869# a_26845_57069# VR.t263 VR.t262 pfet_03v3 ad=0.795p pd=3.53u as=0.795p ps=3.53u w=3u l=0.4u
X288 VR.t190 a_35769_13109.t31 a_18109_11960.t1 VDD pfet_03v3 ad=1.325p pd=5.53u as=1.325p ps=5.53u w=5u l=0.28u
X289 a_18109_11960.t2 a_35769_13109.t56 VR.t189 VDD pfet_03v3 ad=1.325p pd=5.53u as=1.325p ps=5.53u w=5u l=0.28u
X290 a_18109_11960.t8 a_17709_13109.t32 VDD VDD pfet_03v3 ad=1.325p pd=5.53u as=1.325p ps=5.53u w=5u l=0.28u
X291 VDD a_17709_13109.t97 VR.t108 VDD pfet_03v3 ad=1.325p pd=5.53u as=1.325p ps=5.53u w=5u l=0.28u
X292 VR.t238 a_25129_65609.t2 a_22707_82689# VR.t237 pfet_03v3 ad=0.795p pd=3.53u as=0.795p ps=3.53u w=3u l=0.28u
X293 VDD a_17709_13109.t47 a_18109_11960.t33 VDD pfet_03v3 ad=1.325p pd=5.53u as=1.325p ps=5.53u w=5u l=0.28u
X294 VDD a_17709_13109.t2 a_17709_13109.t1 VDD pfet_03v3 ad=1.325p pd=5.53u as=1.325p ps=5.53u w=5u l=0.28u
X295 VSS a_17093_52869# a_17193_52000# VSS nfet_03v3 ad=1.78p pd=8.89u as=1.06p ps=4.53u w=4u l=0.4u
X296 a_18109_11960.t2 a_35769_13109.t42 VR.t88 VDD pfet_03v3 ad=1.325p pd=5.53u as=1.325p ps=5.53u w=5u l=0.28u
X297 a_18109_11960.t1 a_35769_13109.t8 VR.t2 VDD pfet_03v3 ad=1.325p pd=5.53u as=1.325p ps=5.53u w=5u l=0.28u
X298 a_26845_57069# a_25829_57069# VSS VSS nfet_03v3 ad=0.445p pd=2.89u as=0.445p ps=2.89u w=1u l=0.4u
X299 VDD a_17709_13109.t35 a_18109_11960.t14 VDD pfet_03v3 ad=1.325p pd=5.53u as=1.325p ps=5.53u w=5u l=0.28u
X300 a_18109_11960.t11 a_17709_13109.t100 VDD VDD pfet_03v3 ad=1.325p pd=5.53u as=1.325p ps=5.53u w=5u l=0.28u
X301 LOIP.t2 a_3785_77480# VSS VSS nfet_03v3 ad=0.795p pd=3.53u as=1.335p ps=6.89u w=3u l=0.28u
X302 a_39800_3486# a_40640_1364# VSS ppolyf_u_1k r_width=1u r_length=10u
X303 VR.t328 VSS cap_mim_2f0_m4m5_noshield c_width=5u c_length=5u
X304 VR.t102 a_35769_13109.t65 a_18109_11960.t2 VDD pfet_03v3 ad=1.325p pd=5.53u as=2.225p ps=10.89u w=5u l=0.28u
X305 VDD a_17709_13109.t63 VR.t292 VDD pfet_03v3 ad=1.325p pd=5.53u as=1.325p ps=5.53u w=5u l=0.28u
X306 a_18109_11960.t31 a_17709_13109.t128 VDD VDD pfet_03v3 ad=1.325p pd=5.53u as=1.325p ps=5.53u w=5u l=0.28u
X307 VR.t109 a_35769_13109.t45 a_18109_11960.t2 VDD pfet_03v3 ad=1.325p pd=5.53u as=1.325p ps=5.53u w=5u l=0.28u
X308 a_21997_11960# a_31569_13109# VR.t54 VDD pfet_03v3 ad=1.325p pd=5.53u as=1.325p ps=5.53u w=5u l=0.28u
X309 a_17709_13109.t6 a_17709_13109.t5 VDD VDD pfet_03v3 ad=1.325p pd=5.53u as=1.325p ps=5.53u w=5u l=0.28u
X310 VR.t167 a_17709_13109.t86 VDD VDD pfet_03v3 ad=1.325p pd=5.53u as=1.325p ps=5.53u w=5u l=0.28u
X311 VR.t172 a_17709_13109.t156 VDD VDD pfet_03v3 ad=1.325p pd=5.53u as=2.225p ps=10.89u w=5u l=0.28u
X312 a_18109_11960.t1 a_35769_13109.t26 VR.t84 VDD pfet_03v3 ad=1.325p pd=5.53u as=1.325p ps=5.53u w=5u l=0.28u
X313 VR.t110 a_17709_13109.t116 VDD VDD pfet_03v3 ad=1.325p pd=5.53u as=1.325p ps=5.53u w=5u l=0.28u
X314 a_17709_13109.t9 a_17709_13109.t8 VDD VDD pfet_03v3 ad=1.325p pd=5.53u as=1.325p ps=5.53u w=5u l=0.28u
X315 VR.t329 VSS cap_mim_2f0_m4m5_noshield c_width=5u c_length=5u
X316 VR.t299 a_35769_13109.t63 a_18109_11960.t2 VDD pfet_03v3 ad=1.325p pd=5.53u as=1.325p ps=5.53u w=5u l=0.28u
X317 a_32200_91340# a_22707_78349.t5 VR.t135 VR.t134 pfet_03v3 ad=3.56p pd=16.89u as=3.56p ps=16.89u w=8u l=0.28u
X318 a_18109_11960.t5 a_17709_13109.t104 VDD VDD pfet_03v3 ad=1.325p pd=5.53u as=1.325p ps=5.53u w=5u l=0.28u
X319 VR.t85 a_35769_13109.t29 a_18109_11960.t1 VDD pfet_03v3 ad=1.325p pd=5.53u as=1.325p ps=5.53u w=5u l=0.28u
X320 VR.t329 VSS cap_mim_2f0_m4m5_noshield c_width=5u c_length=5u
X321 VDD a_17709_13109.t119 a_18109_11960.t21 VDD pfet_03v3 ad=1.325p pd=5.53u as=1.325p ps=5.53u w=5u l=0.28u
X322 VR.t242 a_25129_65609.t2 a_22707_82689# VR.t241 pfet_03v3 ad=1.335p pd=6.89u as=0.795p ps=3.53u w=3u l=0.28u
X323 a_21997_11960# a_17709_13109.t58 VDD VDD pfet_03v3 ad=1.325p pd=5.53u as=1.325p ps=5.53u w=5u l=0.28u
X324 VR.t142 a_35769_13109.t15 a_18109_11960.t1 VDD pfet_03v3 ad=1.325p pd=5.53u as=1.325p ps=5.53u w=5u l=0.28u
X325 a_5347_78349.t1 a_43427_78069# VR.t251 VR.t250 pfet_03v3 ad=0.795p pd=3.53u as=0.795p ps=3.53u w=3u l=0.28u
X326 a_18109_11960.t2 a_35769_13109.t40 VR.t87 VDD pfet_03v3 ad=1.325p pd=5.53u as=1.325p ps=5.53u w=5u l=0.28u
X327 VDD a_17709_13109.t107 a_18109_11960.t15 VDD pfet_03v3 ad=1.325p pd=5.53u as=1.325p ps=5.53u w=5u l=0.28u
X328 a_38505_26660# a_16665_27002# a_38360_26660# VSS nfet_03v3 ad=0.89p pd=4.89u as=0.89p ps=4.89u w=2u l=0.28u
X329 a_16449_52869# a_25829_57069# VR.t15 VR.t14 pfet_03v3 ad=0.795p pd=3.53u as=0.795p ps=3.53u w=3u l=0.4u
X330 VDD a_17709_13109.t33 VR.t136 VDD pfet_03v3 ad=1.325p pd=5.53u as=1.325p ps=5.53u w=5u l=0.28u
X331 VDD a_17709_13109.t135 VR.t86 VDD pfet_03v3 ad=1.325p pd=5.53u as=1.325p ps=5.53u w=5u l=0.28u
X332 VR.t271 a_31849_65609.t2 a_24387_78349# VR.t270 pfet_03v3 ad=0.795p pd=3.53u as=0.795p ps=3.53u w=3u l=0.28u
X333 a_22707_82689# a_25129_65609.t2 VR.t236 VR.t235 pfet_03v3 ad=0.795p pd=3.53u as=1.335p ps=6.89u w=3u l=0.28u
X334 VDD a_17709_13109.t61 a_18109_11960.t30 VDD pfet_03v3 ad=1.325p pd=5.53u as=1.325p ps=5.53u w=5u l=0.28u
X335 a_17709_13109.t1 a_17709_13109.t0 VDD VDD pfet_03v3 ad=1.325p pd=5.53u as=1.325p ps=5.53u w=5u l=0.28u
X336 a_18109_11960.t1 a_35769_13109.t18 VR.t204 VDD pfet_03v3 ad=1.325p pd=5.53u as=1.325p ps=5.53u w=5u l=0.28u
X337 a_18109_11960.t2 a_35769_13109.t58 VR.t27 VDD pfet_03v3 ad=1.325p pd=5.53u as=1.325p ps=5.53u w=5u l=0.28u
X338 a_21997_11960# a_31569_13109# VR.t55 VDD pfet_03v3 ad=1.325p pd=5.53u as=1.325p ps=5.53u w=5u l=0.28u
X339 VDD a_17709_13109.t19 a_18109_11960.t12 VDD pfet_03v3 ad=1.325p pd=5.53u as=1.325p ps=5.53u w=5u l=0.28u
X340 VDD a_17709_13109.t49 a_18109_11960.t27 VDD pfet_03v3 ad=1.325p pd=5.53u as=1.325p ps=5.53u w=5u l=0.28u
X341 LOQN a_22825_77480# VR.t158 VR.t157 pfet_03v3 ad=0.795p pd=3.53u as=1.335p ps=6.89u w=3u l=0.28u
X342 a_17709_13109.t1 a_17709_13109.t3 VDD VDD pfet_03v3 ad=1.325p pd=5.53u as=1.325p ps=5.53u w=5u l=0.28u
X343 LOQN a_22825_77480# VR.t162 VR.t161 pfet_03v3 ad=0.795p pd=3.53u as=0.795p ps=3.53u w=3u l=0.28u
X344 VR.t28 a_35769_13109.t61 a_18109_11960.t2 VDD pfet_03v3 ad=1.325p pd=5.53u as=1.325p ps=5.53u w=5u l=0.28u
X345 a_22825_81820# a_22707_82689# VSS VSS nfet_03v3 ad=1.78p pd=8.89u as=1.78p ps=8.89u w=4u l=0.28u
X346 a_22825_77480# a_22707_78349.t4 a_22680_77480# VSS nfet_03v3 ad=1.78p pd=8.89u as=1.78p ps=8.89u w=4u l=0.28u
X347 a_32200_77480# a_22707_82689# VSS VSS nfet_03v3 ad=1.78p pd=8.89u as=1.78p ps=8.89u w=4u l=0.28u
X348 a_57400_77480# a_31849_65609.t4 VSS VSS nfet_03v3 ad=0.89p pd=4.89u as=0.89p ps=4.89u w=2u l=0.28u
X349 a_21997_11960# a_17709_13109.t52 VDD VDD pfet_03v3 ad=1.325p pd=5.53u as=1.325p ps=5.53u w=5u l=0.28u
X350 a_21997_11960# a_17709_13109.t130 VDD VDD pfet_03v3 ad=1.325p pd=5.53u as=1.325p ps=5.53u w=5u l=0.28u
X351 VR.t106 a_35769_13109.t47 a_18109_11960.t2 VDD pfet_03v3 ad=1.325p pd=5.53u as=1.325p ps=5.53u w=5u l=0.28u
X352 VR.t328 VSS cap_mim_2f0_m4m5_noshield c_width=5u c_length=5u
X353 VSS a_13305_77480# LOIN.t2 VSS nfet_03v3 ad=1.335p pd=6.89u as=0.795p ps=3.53u w=3u l=0.28u
X354 a_21997_11960# a_17709_13109.t40 VDD VDD pfet_03v3 ad=1.325p pd=5.53u as=1.325p ps=5.53u w=5u l=0.28u
X355 VDD a_17709_13109.t105 VR.t83 VDD pfet_03v3 ad=1.325p pd=5.53u as=1.325p ps=5.53u w=5u l=0.28u
X356 VR.t329 VSS cap_mim_2f0_m4m5_noshield c_width=5u c_length=5u
X357 VR.t298 a_17709_13109.t68 VDD VDD pfet_03v3 ad=1.325p pd=5.53u as=1.325p ps=5.53u w=5u l=0.28u
X358 VR.t329 VSS cap_mim_2f0_m4m5_noshield c_width=5u c_length=5u
X359 VDD a_17709_13109.t133 a_18109_11960.t6 VDD pfet_03v3 ad=1.325p pd=5.53u as=1.325p ps=5.53u w=5u l=0.28u
X360 VR.t275 a_31849_65609.t2 a_24387_78349# VR.t274 pfet_03v3 ad=1.335p pd=6.89u as=0.795p ps=3.53u w=3u l=0.28u
X361 a_24365_56340.t0 a_16549_52000# VR.t174 VR.t173 pfet_03v3 ad=1.78p pd=8.89u as=1.78p ps=8.89u w=4u l=0.28u
X362 a_25829_57069# a_35309_56340# VSS VSS nfet_03v3 ad=1.06p pd=4.53u as=1.78p ps=8.89u w=4u l=0.4u
X363 a_18109_11960.t2 a_35769_13109.t50 VR.t205 VDD pfet_03v3 ad=1.325p pd=5.53u as=1.325p ps=5.53u w=5u l=0.28u
X364 VR.t52 a_31569_13109# a_21997_11960# VDD pfet_03v3 ad=1.325p pd=5.53u as=1.325p ps=5.53u w=5u l=0.28u
X365 VDD a_17709_13109.t59 VR.t312 VDD pfet_03v3 ad=1.325p pd=5.53u as=1.325p ps=5.53u w=5u l=0.28u
X366 VDD a_17709_13109.t91 a_18109_11960.t17 VDD pfet_03v3 ad=1.325p pd=5.53u as=1.325p ps=5.53u w=5u l=0.28u
X367 a_17093_52869# a_16449_52869# VSS VSS nfet_03v3 ad=0.445p pd=2.89u as=0.445p ps=2.89u w=1u l=0.4u
X368 VDD a_17709_13109.t10 a_17709_13109.t9 VDD pfet_03v3 ad=1.325p pd=5.53u as=1.325p ps=5.53u w=5u l=0.28u
X369 VDD a_17709_13109.t121 a_18109_11960.t13 VDD pfet_03v3 ad=1.325p pd=5.53u as=1.325p ps=5.53u w=5u l=0.28u
X370 a_25129_65609.t0 a_16449_52869# VR.t133 VR.t132 pfet_03v3 ad=1.78p pd=8.89u as=1.78p ps=8.89u w=4u l=0.28u
X371 a_18109_11960.t1 a_35769_13109.t6 VR.t112 VDD pfet_03v3 ad=1.325p pd=5.53u as=1.325p ps=5.53u w=5u l=0.28u
X372 a_21997_11960# a_31569_13109# VR.t50 VDD pfet_03v3 ad=1.325p pd=5.53u as=1.325p ps=5.53u w=5u l=0.28u
X373 a_13305_77480# a_7027_78349.t5 a_13160_91340# VR.t276 pfet_03v3 ad=3.56p pd=16.89u as=3.56p ps=16.89u w=8u l=0.28u
X374 a_16549_52000# a_17737_52869# VSS VSS nfet_03v3 ad=1.06p pd=4.53u as=1.78p ps=8.89u w=4u l=0.4u
X375 a_17093_52869# a_16449_52869# VR.t131 VR.t130 pfet_03v3 ad=0.89p pd=4.89u as=0.89p ps=4.89u w=2u l=0.4u
X376 VDD a_17709_13109.t57 a_21997_11960# VDD pfet_03v3 ad=1.325p pd=5.53u as=1.325p ps=5.53u w=5u l=0.28u
X377 a_21997_11960# a_17709_13109.t124 VDD VDD pfet_03v3 ad=1.325p pd=5.53u as=1.325p ps=5.53u w=5u l=0.28u
X378 a_31849_65609.t1 a_17093_52869# VSS VSS nfet_03v3 ad=0.89p pd=4.89u as=0.89p ps=4.89u w=2u l=0.28u
X379 a_21997_11960# a_17709_13109.t112 VDD VDD pfet_03v3 ad=1.325p pd=5.53u as=1.325p ps=5.53u w=5u l=0.28u
X380 VR.t213 a_13305_77480# LOIN.t0 VR.t212 pfet_03v3 ad=1.335p pd=6.89u as=0.795p ps=3.53u w=3u l=0.28u
X381 VR.t214 a_17709_13109.t38 VDD VDD pfet_03v3 ad=1.325p pd=5.53u as=1.325p ps=5.53u w=5u l=0.28u
X382 VR.t186 a_17709_13109.t140 VDD VDD pfet_03v3 ad=1.325p pd=5.53u as=1.325p ps=5.53u w=5u l=0.28u
X383 a_18109_11960.t32 a_17709_13109.t66 VDD VDD pfet_03v3 ad=1.325p pd=5.53u as=1.325p ps=5.53u w=5u l=0.28u
X384 VDD a_17709_13109.t131 VR.t141 VDD pfet_03v3 ad=1.325p pd=5.53u as=1.325p ps=5.53u w=5u l=0.28u
X385 VR.t116 a_32345_77480# LOQP VR.t115 pfet_03v3 ad=0.795p pd=3.53u as=0.795p ps=3.53u w=3u l=0.28u
X386 VR.t222 a_17193_52000# a_35309_56340# VR.t221 pfet_03v3 ad=0.795p pd=3.53u as=0.795p ps=3.53u w=3u l=0.4u
X387 VR.t1 a_35769_13109.t23 a_18109_11960.t1 VDD pfet_03v3 ad=1.325p pd=5.53u as=1.325p ps=5.53u w=5u l=0.28u
X388 VR.t53 a_31569_13109# a_21997_11960# VDD pfet_03v3 ad=1.325p pd=5.53u as=1.325p ps=5.53u w=5u l=0.28u
X389 VSS a_37337_52869# a_35309_56340# VSS nfet_03v3 ad=1.78p pd=8.89u as=1.06p ps=4.53u w=4u l=0.4u
X390 VDD a_17709_13109.t4 a_17709_13109.t1 VDD pfet_03v3 ad=1.325p pd=5.53u as=1.325p ps=5.53u w=5u l=0.28u
X391 a_36325_56340# VSS VSS VSS nfet_03v3 ad=1.06p pd=4.53u as=1.78p ps=8.89u w=4u l=0.4u
X392 a_35309_56340# a_36325_56340# VR.t280 VR.t279 pfet_03v3 ad=0.89p pd=4.89u as=0.89p ps=4.89u w=2u l=0.4u
X393 VR.t146 a_17709_13109.t54 VDD VDD pfet_03v3 ad=1.325p pd=5.53u as=1.325p ps=5.53u w=5u l=0.28u
X394 VR.t284 a_36325_56340# a_26845_57069# VR.t283 pfet_03v3 ad=0.795p pd=3.53u as=0.795p ps=3.53u w=3u l=0.4u
X395 a_18109_11960.t2 a_35769_13109.t38 VR.t99 VDD pfet_03v3 ad=1.325p pd=5.53u as=1.325p ps=5.53u w=5u l=0.28u
X396 a_41480_3486# a_42320_1364# VSS ppolyf_u_1k r_width=1u r_length=10u
X397 VDD a_17709_13109.t69 a_18109_11960.t26 VDD pfet_03v3 ad=1.325p pd=5.53u as=1.325p ps=5.53u w=5u l=0.28u
X398 a_18109_11960.t1 a_35769_13109.t4 VR.t140 VDD pfet_03v3 ad=1.325p pd=5.53u as=1.325p ps=5.53u w=5u l=0.28u
X399 a_21997_11960# a_31569_13109# VR.t51 VDD pfet_03v3 ad=1.325p pd=5.53u as=1.325p ps=5.53u w=5u l=0.28u
X400 a_8825_26660# a_10387_27249.t5 VR.t31 VR.t30 pfet_03v3 ad=0.89p pd=4.89u as=0.89p ps=4.89u w=2u l=0.28u
X401 a_65385_77822# a_31849_65609.t3 VSS VSS nfet_03v3 ad=0.445p pd=2.89u as=0.445p ps=2.89u w=1u l=0.28u
X402 a_44840_3486# a_44000_1364# VSS ppolyf_u_1k r_width=1u r_length=10u
X403 VDD a_17709_13109.t129 a_21997_11960# VDD pfet_03v3 ad=1.325p pd=5.53u as=1.325p ps=5.53u w=5u l=0.28u
X404 a_16549_52000# a_17193_52000# VSS VSS nfet_03v3 ad=0.445p pd=2.89u as=0.445p ps=2.89u w=1u l=0.4u
X405 VDD a_17709_13109.t55 a_18109_11960.t24 VDD pfet_03v3 ad=1.325p pd=5.53u as=1.325p ps=5.53u w=5u l=0.28u
X406 VR.t171 a_17709_13109.t110 VDD VDD pfet_03v3 ad=1.325p pd=5.53u as=1.325p ps=5.53u w=5u l=0.28u
X407 VR.t78 a_35309_56340# a_25829_57069# VR.t77 pfet_03v3 ad=0.795p pd=3.53u as=0.795p ps=3.53u w=3u l=0.4u
X408 VR.t329 VSS cap_mim_2f0_m4m5_noshield c_width=5u c_length=5u
X409 VR.t329 VSS cap_mim_2f0_m4m5_noshield c_width=5u c_length=5u
X410 a_18109_11960.t28 a_17709_13109.t138 VDD VDD pfet_03v3 ad=1.325p pd=5.53u as=1.325p ps=5.53u w=5u l=0.28u
X411 VSS a_3785_77480# LOIP.t2 VSS nfet_03v3 ad=1.335p pd=6.89u as=0.795p ps=3.53u w=3u l=0.28u
X412 VR.t101 a_35769_13109.t55 a_18109_11960.t2 VDD pfet_03v3 ad=1.325p pd=5.53u as=1.325p ps=5.53u w=5u l=0.28u
X413 a_21997_11960# a_31569_13109# VR.t49 VDD pfet_03v3 ad=1.325p pd=5.53u as=1.325p ps=5.53u w=5u l=0.28u
X414 VR.t292 a_17709_13109.t64 VDD VDD pfet_03v3 ad=1.325p pd=5.53u as=1.325p ps=5.53u w=5u l=0.28u
X415 a_16665_27002# a_10387_27249.t2 VSS VSS nfet_03v3 ad=0.445p pd=2.89u as=0.445p ps=2.89u w=1u l=0.28u
X416 a_21997_11960# a_17709_13109.t46 VDD VDD pfet_03v3 ad=1.325p pd=5.53u as=1.325p ps=5.53u w=5u l=0.28u
X417 a_38360_26660# a_40067_27249# VSS VSS nfet_03v3 ad=0.89p pd=4.89u as=0.89p ps=4.89u w=2u l=0.28u
X418 VR.t67 a_8707_27249.t6 a_22707_78349.t1 VR.t66 pfet_03v3 ad=1.335p pd=6.89u as=0.795p ps=3.53u w=3u l=0.28u
X419 VR.t24 a_17709_13109.t126 VDD VDD pfet_03v3 ad=1.325p pd=5.53u as=1.325p ps=5.53u w=5u l=0.28u
X420 a_49705_77822# a_38569_65609# VSS VSS nfet_03v3 ad=0.445p pd=2.89u as=0.445p ps=2.89u w=1u l=0.28u
X421 VDD a_17709_13109.t141 a_18109_11960.t16 VDD pfet_03v3 ad=1.325p pd=5.53u as=1.325p ps=5.53u w=5u l=0.28u
X422 a_32345_27002# a_17737_52869# VR.t58 VR.t57 pfet_03v3 ad=0.89p pd=4.89u as=0.89p ps=4.89u w=2u l=0.28u
X423 a_18109_11960.t2 a_35769_13109.t36 VR.t203 VDD pfet_03v3 ad=1.325p pd=5.53u as=1.325p ps=5.53u w=5u l=0.28u
X424 VDD a_17709_13109.t127 a_18109_11960.t31 VDD pfet_03v3 ad=1.325p pd=5.53u as=1.325p ps=5.53u w=5u l=0.28u
X425 a_41480_3486# a_40640_1364# VSS ppolyf_u_1k r_width=1u r_length=10u
X426 VR.t55 a_31569_13109# a_21997_11960# VDD pfet_03v3 ad=1.325p pd=5.53u as=1.325p ps=5.53u w=5u l=0.28u
X427 a_60345_27002# a_24365_56340.t2 VSS VSS nfet_03v3 ad=0.445p pd=2.89u as=0.445p ps=2.89u w=1u l=0.28u
X428 VSS a_25829_57069# a_16449_52869# VSS nfet_03v3 ad=1.78p pd=8.89u as=1.06p ps=4.53u w=4u l=0.4u
X429 a_22825_77480# a_22707_82689# a_22680_91340# VR.t325 pfet_03v3 ad=3.56p pd=16.89u as=3.56p ps=16.89u w=8u l=0.28u
X430 a_41865_77480# a_38569_65609# VR.t314 VR.t313 pfet_03v3 ad=0.89p pd=4.89u as=0.89p ps=4.89u w=2u l=0.28u
X431 VR.t129 a_16449_52869# a_16549_52000# VR.t128 pfet_03v3 ad=1.335p pd=6.89u as=0.795p ps=3.53u w=3u l=0.4u
X432 a_21997_11960# a_31569_13109# VR.t53 VDD pfet_03v3 ad=1.325p pd=5.53u as=1.325p ps=5.53u w=5u l=0.28u
X433 VR.t86 a_17709_13109.t136 VDD VDD pfet_03v3 ad=1.325p pd=5.53u as=1.325p ps=5.53u w=5u l=0.28u
X434 a_24387_78349# a_31849_65609.t2 VR.t269 VR.t268 pfet_03v3 ad=0.795p pd=3.53u as=1.335p ps=6.89u w=3u l=0.28u
X435 VR.t328 VSS cap_mim_2f0_m4m5_noshield c_width=5u c_length=5u
X436 VR.t234 a_3785_77480# LOIP.t1 VR.t233 pfet_03v3 ad=1.335p pd=6.89u as=0.795p ps=3.53u w=3u l=0.28u
X437 a_21997_11960# a_17709_13109.t118 VDD VDD pfet_03v3 ad=1.325p pd=5.53u as=1.325p ps=5.53u w=5u l=0.28u
X438 a_26845_57069# a_36325_56340# VR.t282 VR.t281 pfet_03v3 ad=0.795p pd=3.53u as=1.335p ps=6.89u w=3u l=0.4u
X439 a_16449_52869# a_17093_52869# VSS VSS nfet_03v3 ad=0.445p pd=2.89u as=0.445p ps=2.89u w=1u l=0.4u
X440 VR.t160 a_22825_77480# LOQN VR.t159 pfet_03v3 ad=0.795p pd=3.53u as=0.795p ps=3.53u w=3u l=0.28u
X441 VR.t49 a_31569_13109# a_21997_11960# VDD pfet_03v3 ad=1.325p pd=5.53u as=2.225p ps=10.89u w=5u l=0.28u
X442 VR.t305 a_17093_52869# a_17193_52000# VR.t304 pfet_03v3 ad=0.795p pd=3.53u as=0.795p ps=3.53u w=3u l=0.4u
X443 VR.t312 a_17709_13109.t60 VDD VDD pfet_03v3 ad=1.325p pd=5.53u as=1.325p ps=5.53u w=5u l=0.28u
X444 VR.t265 a_26845_57069# a_17093_52869# VR.t264 pfet_03v3 ad=1.335p pd=6.89u as=0.795p ps=3.53u w=3u l=0.4u
X445 a_8825_26660# a_8707_27249.t5 VR.t37 VR.t36 pfet_03v3 ad=0.89p pd=4.89u as=0.89p ps=4.89u w=2u l=0.28u
X446 a_32345_81820# a_24387_78349# VSS VSS nfet_03v3 ad=1.78p pd=8.89u as=1.78p ps=8.89u w=4u l=0.28u
X447 a_32345_77480# a_22707_78349.t3 a_32200_77480# VSS nfet_03v3 ad=1.78p pd=8.89u as=1.78p ps=8.89u w=4u l=0.28u
X448 a_41720_77480# a_43427_78069# VSS VSS nfet_03v3 ad=0.89p pd=4.89u as=0.89p ps=4.89u w=2u l=0.28u
X449 a_5347_78349.t0 a_43427_78069# VR.t249 VR.t248 pfet_03v3 ad=0.795p pd=3.53u as=1.335p ps=6.89u w=3u l=0.28u
X450 a_38569_65609# a_25829_57069# VR.t21 VR.t20 pfet_03v3 ad=1.78p pd=8.89u as=1.78p ps=8.89u w=4u l=0.28u
X451 VR.t56 a_31569_13109# a_21997_11960# VDD pfet_03v3 ad=1.325p pd=5.53u as=1.325p ps=5.53u w=5u l=0.28u
X452 VR.t63 a_8707_27249.t6 a_22707_78349.t0 VR.t62 pfet_03v3 ad=0.795p pd=3.53u as=0.795p ps=3.53u w=3u l=0.28u
X453 VR.t112 a_35769_13109.t7 a_18109_11960.t1 VDD pfet_03v3 ad=1.325p pd=5.53u as=1.325p ps=5.53u w=5u l=0.28u
X454 VR.t329 VSS cap_mim_2f0_m4m5_noshield c_width=5u c_length=5u
X455 a_17737_52869# a_8825_26660# VSS VSS nfet_03v3 ad=0.445p pd=2.89u as=0.445p ps=2.89u w=1u l=0.28u
X456 VSS a_35309_56340# a_25829_57069# VSS nfet_03v3 ad=1.78p pd=8.89u as=1.06p ps=4.53u w=4u l=0.4u
X457 a_26845_57069# VSS VSS VSS nfet_03v3 ad=1.06p pd=4.53u as=1.78p ps=8.89u w=4u l=0.4u
X458 a_16665_30860# a_8707_27249.t4 VR.t33 VR.t32 pfet_03v3 ad=1.78p pd=8.89u as=1.78p ps=8.89u w=4u l=0.28u
X459 LOIP.t0 a_3785_77480# VR.t228 VR.t227 pfet_03v3 ad=0.795p pd=3.53u as=1.335p ps=6.89u w=3u l=0.28u
X460 a_22825_77480# a_26067_78349.t6 a_22680_91340# VR.t170 pfet_03v3 ad=3.56p pd=16.89u as=3.56p ps=16.89u w=8u l=0.28u
X461 VR.t141 a_17709_13109.t132 VDD VDD pfet_03v3 ad=1.325p pd=5.53u as=1.325p ps=5.53u w=5u l=0.28u
X462 a_10387_27249.t1 a_35309_56340# VSS VSS nfet_03v3 ad=0.89p pd=4.89u as=0.89p ps=4.89u w=2u l=0.28u
X463 a_18109_11960.t1 a_35769_13109.t2 VR.t111 VDD pfet_03v3 ad=2.225p pd=10.89u as=1.325p ps=5.53u w=5u l=0.28u
X464 VR.t328 VSS cap_mim_2f0_m4m5_noshield c_width=5u c_length=5u
X465 a_21997_11960# a_31569_13109# VR.t52 VDD pfet_03v3 ad=1.325p pd=5.53u as=1.325p ps=5.53u w=5u l=0.28u
X466 LOIN.t0 a_13305_77480# VR.t211 VR.t210 pfet_03v3 ad=0.795p pd=3.53u as=0.795p ps=3.53u w=3u l=0.28u
X467 a_16549_52000# a_16449_52869# VR.t123 VR.t122 pfet_03v3 ad=0.795p pd=3.53u as=1.335p ps=6.89u w=3u l=0.4u
X468 a_43160_3486# a_44000_1364# VSS ppolyf_u_1k r_width=1u r_length=10u
X469 VR.t99 a_35769_13109.t39 a_18109_11960.t2 VDD pfet_03v3 ad=1.325p pd=5.53u as=1.325p ps=5.53u w=5u l=0.28u
X470 a_31569_13109# B0 VDD VDD pfet_03v3 ad=0.89p pd=4.89u as=0.89p ps=4.89u w=2u l=0.28u
X471 a_52360_26660# a_24365_56340.t3 VSS VSS nfet_03v3 ad=0.89p pd=4.89u as=0.89p ps=4.89u w=2u l=0.28u
X472 VR.t140 a_35769_13109.t5 a_18109_11960.t1 VDD pfet_03v3 ad=1.325p pd=5.53u as=1.325p ps=5.53u w=5u l=0.28u
X473 a_46520_3486# a_45680_1364# VSS ppolyf_u_1k r_width=1u r_length=10u
X474 VR.t51 a_31569_13109# a_21997_11960# VDD pfet_03v3 ad=1.325p pd=5.53u as=1.325p ps=5.53u w=5u l=0.28u
X475 a_37337_52869# a_38505_26660# VR.t26 VR.t25 pfet_03v3 ad=0.89p pd=4.89u as=0.89p ps=4.89u w=2u l=0.28u
X476 a_3667_78349.t1 a_22825_56340.t6 VR.t150 VR.t149 pfet_03v3 ad=0.795p pd=3.53u as=0.795p ps=3.53u w=3u l=0.28u
X477 VR.t35 a_10387_27249.t10 a_26067_78349.t0 VR.t34 pfet_03v3 ad=0.795p pd=3.53u as=0.795p ps=3.53u w=3u l=0.28u
X478 a_22707_78349.t0 a_8707_27249.t6 VR.t61 VR.t60 pfet_03v3 ad=0.795p pd=3.53u as=1.335p ps=6.89u w=3u l=0.28u
X479 VSS VSS a_36325_56340# VSS nfet_03v3 ad=1.78p pd=8.89u as=1.06p ps=4.53u w=4u l=0.4u
X480 a_22825_56340.t0 a_17193_52000# VR.t218 VR.t217 pfet_03v3 ad=1.78p pd=8.89u as=1.78p ps=8.89u w=4u l=0.28u
X481 a_17093_52869# a_26845_57069# VSS VSS nfet_03v3 ad=1.06p pd=4.53u as=1.78p ps=8.89u w=4u l=0.4u
X482 VR.t329 VSS cap_mim_2f0_m4m5_noshield c_width=5u c_length=5u
X483 a_18109_11960.t2 a_35769_13109.t34 VR.t202 VDD pfet_03v3 ad=2.225p pd=10.89u as=1.325p ps=5.53u w=5u l=0.28u
X484 a_21997_11960# a_31569_13109# VR.t56 VDD pfet_03v3 ad=2.225p pd=10.89u as=1.325p ps=5.53u w=5u l=0.28u
X485 VDD a_17709_13109.t65 a_18109_11960.t32 VDD pfet_03v3 ad=1.325p pd=5.53u as=1.325p ps=5.53u w=5u l=0.28u
X486 a_13305_77480# a_7027_78349.t3 a_13305_81820# VSS nfet_03v3 ad=1.78p pd=8.89u as=1.78p ps=8.89u w=4u l=0.28u
X487 a_49705_77822# a_43427_78069# VSS VSS nfet_03v3 ad=0.445p pd=2.89u as=0.445p ps=2.89u w=1u l=0.28u
X488 a_17093_52869# a_26845_57069# VR.t259 VR.t258 pfet_03v3 ad=0.795p pd=3.53u as=1.335p ps=6.89u w=3u l=0.4u
X489 a_36325_56340# a_16549_52000# VR.t182 VR.t181 pfet_03v3 ad=0.795p pd=3.53u as=0.795p ps=3.53u w=3u l=0.4u
X490 a_35309_56340# a_17193_52000# VSS VSS nfet_03v3 ad=1.06p pd=4.53u as=1.78p ps=8.89u w=4u l=0.4u
X491 a_10387_27249.t0 a_35309_56340# VR.t76 VR.t75 pfet_03v3 ad=1.78p pd=8.89u as=1.78p ps=8.89u w=4u l=0.28u
X492 VR.t203 a_35769_13109.t37 a_18109_11960.t2 VDD pfet_03v3 ad=1.325p pd=5.53u as=1.325p ps=5.53u w=5u l=0.28u
X493 a_3640_91340# a_5347_78349.t5 VR.t195 VR.t194 pfet_03v3 ad=3.56p pd=16.89u as=3.56p ps=16.89u w=8u l=0.28u
X494 a_25829_57069# a_35309_56340# VR.t80 VR.t79 pfet_03v3 ad=0.795p pd=3.53u as=0.795p ps=3.53u w=3u l=0.4u
X495 VR.t111 a_35769_13109.t3 a_18109_11960.t1 VDD pfet_03v3 ad=1.325p pd=5.53u as=1.325p ps=5.53u w=5u l=0.28u
X496 a_43160_3486# a_42320_1364# VSS ppolyf_u_1k r_width=1u r_length=10u
X497 VR.t209 a_13305_77480# LOIN.t1 VR.t208 pfet_03v3 ad=0.795p pd=3.53u as=0.795p ps=3.53u w=3u l=0.28u
X498 a_44840_3486# a_45680_1364# VSS ppolyf_u_1k r_width=1u r_length=10u
X499 VR.t291 a_10387_27249.t8 a_26067_78349.t1 VR.t290 pfet_03v3 ad=1.335p pd=6.89u as=0.795p ps=3.53u w=3u l=0.28u
X500 VDD VR.t6 VSS ppolyf_u_1k r_width=2u r_length=5u
X501 a_57545_77480# a_25129_65609.t4 a_57400_77480# VSS nfet_03v3 ad=0.89p pd=4.89u as=0.89p ps=4.89u w=2u l=0.28u
X502 a_7027_78349.t1 a_24365_56340.t6 VR.t43 VR.t42 pfet_03v3 ad=0.795p pd=3.53u as=0.795p ps=3.53u w=3u l=0.28u
X503 VDD a_17709_13109.t137 a_18109_11960.t28 VDD pfet_03v3 ad=1.325p pd=5.53u as=1.325p ps=5.53u w=5u l=0.28u
X504 VSS a_17737_52869# a_16549_52000# VSS nfet_03v3 ad=1.78p pd=8.89u as=1.06p ps=4.53u w=4u l=0.4u
X505 a_17193_52000# VSS VSS VSS nfet_03v3 ad=1.06p pd=4.53u as=1.78p ps=8.89u w=4u l=0.4u
X506 VR.t50 a_31569_13109# a_21997_11960# VDD pfet_03v3 ad=1.325p pd=5.53u as=1.325p ps=5.53u w=5u l=0.28u
X507 VR.t328 VSS cap_mim_2f0_m4m5_noshield c_width=5u c_length=5u
X508 a_60345_27002# a_22825_56340.t2 VSS VSS nfet_03v3 ad=0.445p pd=2.89u as=0.445p ps=2.89u w=1u l=0.28u
X509 a_32345_77480# a_24387_78349# a_32200_91340# VR.t103 pfet_03v3 ad=3.56p pd=16.89u as=3.56p ps=16.89u w=8u l=0.28u
X510 VSS a_26845_57069# a_17093_52869# VSS nfet_03v3 ad=1.78p pd=8.89u as=1.06p ps=4.53u w=4u l=0.4u
X511 VR.t329 VSS cap_mim_2f0_m4m5_noshield c_width=5u c_length=5u
X512 a_38505_26660# a_16665_27002# VR.t47 VR.t46 pfet_03v3 ad=0.89p pd=4.89u as=0.89p ps=4.89u w=2u l=0.28u
X513 a_41900_3486# a_41060_1364# VSS ppolyf_u_1k r_width=1u r_length=10u
X514 a_35769_13109.t1 B1.t1 VDD VDD pfet_03v3 ad=0.89p pd=4.89u as=0.89p ps=4.89u w=2u l=0.28u
X515 VR.t202 a_35769_13109.t35 a_18109_11960.t2 VDD pfet_03v3 ad=1.325p pd=5.53u as=1.325p ps=5.53u w=5u l=0.28u
X516 LOIP.t1 a_3785_77480# VR.t232 VR.t231 pfet_03v3 ad=0.795p pd=3.53u as=0.795p ps=3.53u w=3u l=0.28u
X517 a_13160_91340# a_3667_82689.t5 VR.t148 VR.t147 pfet_03v3 ad=3.56p pd=16.89u as=3.56p ps=16.89u w=8u l=0.28u
X518 a_35309_56340# a_17193_52000# VR.t224 VR.t223 pfet_03v3 ad=0.795p pd=3.53u as=0.795p ps=3.53u w=3u l=0.4u
X519 a_26845_57069# a_36325_56340# VR.t286 VR.t285 pfet_03v3 ad=0.795p pd=3.53u as=0.795p ps=3.53u w=3u l=0.4u
X520 VR.t54 a_31569_13109# a_21997_11960# VDD pfet_03v3 ad=1.325p pd=5.53u as=1.325p ps=5.53u w=5u l=0.28u
X521 a_57545_77480# a_31849_65609.t6 VR.t9 VR.t8 pfet_03v3 ad=0.89p pd=4.89u as=0.89p ps=4.89u w=2u l=0.28u
X522 VR.t329 VSS cap_mim_2f0_m4m5_noshield c_width=5u c_length=5u
X523 VR.t164 a_22825_77480# LOQN VR.t163 pfet_03v3 ad=1.335p pd=6.89u as=0.795p ps=3.53u w=3u l=0.28u
X524 a_65385_77822# a_25129_65609.t3 VSS VSS nfet_03v3 ad=0.445p pd=2.89u as=0.445p ps=2.89u w=1u l=0.28u
X525 a_22707_78349.t1 a_8707_27249.t6 VR.t65 VR.t64 pfet_03v3 ad=0.795p pd=3.53u as=0.795p ps=3.53u w=3u l=0.28u
X526 a_17737_52869# a_26067_27389# a_24505_30860# VR.t289 pfet_03v3 ad=1.78p pd=8.89u as=1.78p ps=8.89u w=4u l=0.28u
X527 VR.t230 a_3785_77480# LOIP.t0 VR.t229 pfet_03v3 ad=0.795p pd=3.53u as=0.795p ps=3.53u w=3u l=0.28u
X528 VSS a_8707_27249.t6 a_22707_78349.t2 VSS nfet_03v3 ad=1.335p pd=6.89u as=0.795p ps=3.53u w=3u l=0.28u
X529 VR.t328 VSS cap_mim_2f0_m4m5_noshield c_width=5u c_length=5u
X530 VR.t156 a_22825_56340.t6 a_3667_78349.t0 VR.t155 pfet_03v3 ad=0.795p pd=3.53u as=0.795p ps=3.53u w=3u l=0.28u
X531 VR.t329 VSS cap_mim_2f0_m4m5_noshield c_width=5u c_length=5u
X532 VSS a_38569_65609# a_3667_82689.t2 VSS nfet_03v3 ad=1.335p pd=6.89u as=0.795p ps=3.53u w=3u l=0.28u
X533 VR.t261 a_26845_57069# a_17093_52869# VR.t260 pfet_03v3 ad=0.795p pd=3.53u as=0.795p ps=3.53u w=3u l=0.4u
X534 a_36325_56340# a_35309_56340# VSS VSS nfet_03v3 ad=0.445p pd=2.89u as=0.445p ps=2.89u w=1u l=0.4u
X535 LOIN.t2 a_13305_77480# VSS VSS nfet_03v3 ad=0.795p pd=3.53u as=1.335p ps=6.89u w=3u l=0.28u
X536 VR.t82 a_35309_56340# a_25829_57069# VR.t81 pfet_03v3 ad=1.335p pd=6.89u as=0.795p ps=3.53u w=3u l=0.4u
X537 a_26845_57069# a_25829_57069# VR.t19 VR.t18 pfet_03v3 ad=0.89p pd=4.89u as=0.89p ps=4.89u w=2u l=0.4u
X538 VR.t152 a_22825_56340.t6 a_3667_78349.t1 VR.t151 pfet_03v3 ad=1.335p pd=6.89u as=0.795p ps=3.53u w=3u l=0.28u
X539 a_16449_52869# VSS VSS VSS nfet_03v3 ad=1.06p pd=4.53u as=1.78p ps=8.89u w=4u l=0.4u
X540 a_46520_3486# a_8825_26660# VSS ppolyf_u_1k r_width=1u r_length=10u
X541 a_22825_77480# a_26067_78349.t4 a_22825_81820# VSS nfet_03v3 ad=1.78p pd=8.89u as=1.78p ps=8.89u w=4u l=0.28u
X542 a_26067_78349.t1 a_10387_27249.t9 VR.t98 VR.t97 pfet_03v3 ad=0.795p pd=3.53u as=0.795p ps=3.53u w=3u l=0.28u
X543 a_8707_27249.t1 a_36325_56340# VSS VSS nfet_03v3 ad=0.89p pd=4.89u as=0.89p ps=4.89u w=2u l=0.28u
C0 a_32560_69020# VR 0.50376f
C1 a_31569_13109# VDD 6.77969f
C2 a_36484_51940# a_35309_56340# 0.01785f
C3 a_40067_27249# VDD 1.22732f
C4 VDD a_41016_13271# 0.69733f
C5 a_24505_30860# VR 0.89698f
C6 a_38416_51940# a_36325_56340# 0.01823f
C7 a_32494_91280# a_32345_77480# 0.08473f
C8 a_26684_51940# a_16449_52869# 0.02272f
C9 a_3934_91280# a_3785_77480# 0.08473f
C10 a_3785_77480# a_7294_77420# 0.04071f
C11 a_46000_43540# VR 0.50376f
C12 a_8825_26660# a_46100_1364# 0.04189f
C13 a_17528_51940# a_17093_52869# 0.01067f
C14 a_13044_91280# a_13160_91340# 0.07639f
C15 a_21420_52282# a_16549_52000# 0.01468f
C16 a_18494_30800# a_18084_30800# 0.0129f
C17 VR a_46000_104860# 0.50376f
C18 a_44544_18340# VDD 0.36569f
C19 a_31664_69020# VR 0.50376f
C20 a_50704_56280# a_25829_57069# 0.01512f
C21 VDD a_35584_13271# 0.69733f
C22 a_24244_30800# VR 0.63502f
C23 a_3785_77480# a_6884_77420# 0.01991f
C24 a_37772_51940# a_36325_56340# 0.03352f
C25 a_3640_91340# a_3785_77480# 0.99338f
C26 a_32200_91340# a_32345_77480# 1.00157f
C27 a_35854_86100# a_32345_77480# 0.07629f
C28 a_45104_43540# VR 0.50376f
C29 a_65385_77822# a_67214_81620# 0.04066f
C30 a_16665_27002# a_37337_52869# 0.04307f
C31 a_17737_52869# a_16549_52000# 0.19128f
C32 a_28616_51940# a_17093_52869# 0.01932f
C33 a_20338_52282# a_16549_52000# 0.02098f
C34 a_22680_77480# a_24654_77420# 0.04066f
C35 a_31569_13109# a_44954_18340# 0.02481f
C36 VR a_45104_104860# 0.50376f
C37 a_25840_69020# VR 0.50376f
C38 a_49598_56280# a_25829_57069# 0.03137f
C39 a_18494_30800# VR 0.58576f
C40 a_37128_51940# a_36325_56340# 0.01477f
C41 a_32084_91280# a_32345_77480# 0.01114f
C42 a_3524_91280# a_3785_77480# 0.01114f
C43 a_39924_30660# VR 0.36374f
C44 a_35444_86100# a_32345_77480# 0.02926f
C45 a_65124_81620# a_65534_81620# 0.0129f
C46 a_41734_56280# a_41324_56280# 0.0129f
C47 a_24387_78349# a_32345_81820# 0.62125f
C48 a_16549_52000# a_36325_56340# 0.53248f
C49 a_24387_78349# LOIN 2.63526f
C50 a_66804_81620# a_67214_81620# 0.0129f
C51 a_27972_51940# a_17093_52869# 0.01143f
C52 a_22680_77480# a_24244_77420# 0.01615f
C53 B1 a_37337_52869# 0.4495f
C54 a_8825_26660# a_46940_3486# 0.0513f
C55 a_41865_77480# a_43427_78069# 0.54864f
C56 VR a_32345_77480# 3.76721f
C57 a_40067_27249# a_31569_13109# 0.04198f
C58 a_60345_30860# VR 0.89698f
C59 a_16449_52869# a_26845_57069# 0.11491f
C60 a_52654_56280# VR 0.60202f
C61 a_38569_65609# a_51114_56280# 0.0541f
C62 a_3785_81820# a_3934_81760# 0.0476f
C63 a_16665_27002# B1 2.14114f
C64 a_57400_77480# a_59374_77420# 0.01988f
C65 a_26067_27389# VR 1.72125f
C66 a_17737_52869# a_17093_52869# 0.03755f
C67 a_27328_51940# a_17093_52869# 0.01375f
C68 a_22680_77480# a_22974_77420# 0.01483f
C69 a_52244_30660# VR 0.36293f
C70 a_8564_26600# a_8825_26660# 0.01292f
C71 a_13454_86100# a_13044_86100# 0.02581f
C72 a_3785_77480# a_3934_77420# 0.04851f
C73 a_22707_82689# a_32345_77480# 0.03707f
C74 a_41865_77480# a_42014_81480# 0.02235f
C75 a_16449_52869# a_25829_57069# 1.96166f
C76 a_62174_30800# VR 0.58576f
C77 LOQN a_32345_77480# 0.04457f
C78 a_37128_51940# a_35309_56340# 0.0132f
C79 a_24387_78349# VDD 0.23364f
C80 a_32345_27002# VR 0.93665f
C81 a_16549_52000# a_35309_56340# 0.17465f
C82 VR a_21997_11960# 7.55857f
C83 a_26684_51940# a_17093_52869# 0.01003f
C84 a_46494_30800# VR 0.3476f
C85 a_3785_77480# a_3640_77480# 0.41268f
C86 a_8825_26660# a_46520_3486# 0.01166f
C87 a_38505_26660# a_40067_27249# 0.17062f
C88 a_57400_77480# a_57694_77420# 0.01069f
C89 a_60345_27002# VR 0.8238f
C90 a_16549_52000# a_26845_57069# 1.87985f
C91 a_40067_27249# VCTRL 0.5674f
C92 VDD a_17524_13271# 0.75357f
C93 a_17737_52869# LOIP 1.67054f
C94 a_32084_30800# VR 0.36569f
C95 a_24505_30860# a_24654_30800# 0.0476f
C96 a_46084_30800# VR 0.36569f
C97 VR a_31384_11900# 0.01692f
C98 a_41604_81480# a_41865_77480# 0.01167f
C99 VR a_35000_56280# 0.5866f
C100 a_32345_27002# a_32494_26942# 0.01511f
C101 a_38505_26660# a_38654_30660# 0.02238f
C102 a_26636_56280# a_25829_57069# 0.01308f
C103 a_16665_27002# a_18494_30800# 0.04066f
C104 a_16549_52000# a_25829_57069# 0.11722f
C105 a_61764_30800# VR 0.58512f
C106 a_24244_30800# a_24654_30800# 0.0129f
C107 a_26334_30800# VR 0.58576f
C108 a_3640_91340# a_7294_86100# 0.01096f
C109 a_40334_30660# VR 0.35048f
C110 VDD a_3785_77480# 0.25314f
C111 VR a_30084_11900# 0.0136f
C112 a_8974_26600# a_8825_26660# 0.01991f
C113 VR a_39280_104860# 0.50376f
C114 a_66804_81620# a_65385_77822# 0.02019f
C115 a_22825_81820# VR 0.25314f
C116 LOIP a_22825_77480# 0.07919f
C117 VR a_37032_56280# 0.58366f
C118 a_26067_27389# a_16665_27002# 0.07952f
C119 a_60494_30800# VR 0.60202f
C120 a_17093_52869# a_26845_57069# 1.19904f
C121 a_17737_52869# VR 1.8912f
C122 VDD a_51114_18340# 0.3476f
C123 a_25924_30800# VR 0.58512f
C124 a_3640_91340# a_6884_86100# 0.08463f
C125 a_41060_1364# a_40640_1364# 0.1684f
C126 a_24654_26942# a_17737_52869# 0.01511f
C127 a_52505_26660# VR 1.37387f
C128 a_16404_86100# a_13305_77480# 0.02926f
C129 a_45680_1364# a_46100_1364# 0.1684f
C130 a_26067_27389# B0 0.04385f
C131 a_22825_81820# a_22707_82689# 0.06235f
C132 a_8680_26660# a_8825_26660# 0.1904f
C133 a_38244_30660# a_38505_26660# 0.01168f
C134 VR a_38384_104860# 0.50376f
C135 a_22825_77480# a_13305_77480# 0.1399f
C136 a_35000_1180# a_34840_1120# 0.07454f
C137 VR a_36325_56340# 4.71158f
C138 a_17093_52869# a_25829_57069# 0.42592f
C139 a_46494_30800# a_37337_52869# 0.02481f
C140 a_32345_27002# a_16665_27002# 0.05637f
C141 a_16404_86100# VR 1.06472f
C142 a_26067_27389# a_34840_1120# 0.01454f
C143 a_60084_30800# VR 0.63502f
C144 a_65385_81680# a_65385_77822# 0.38839f
C145 VR a_22825_77480# 3.95834f
C146 LOIP a_26845_57069# 0.03094f
C147 VR a_36016_56280# 0.59288f
C148 a_16449_52869# a_17193_52000# 0.17805f
C149 a_27652_56280# a_26845_57069# 0.01285f
C150 a_26067_27389# a_24505_30860# 0.10248f
C151 a_48058_56280# a_26845_57069# 0.02925f
C152 a_41480_3486# a_40220_3486# 0.01209f
C153 a_10654_30660# a_8825_26660# 0.0199f
C154 a_25924_86100# a_26334_86100# 0.02581f
C155 a_16549_52000# a_24104_56280# 0.01405f
C156 a_15134_86100# VR 1.0911f
C157 a_45260_3486# a_46520_3486# 0.01209f
C158 a_54334_30660# VR 0.35048f
C159 a_22707_82689# a_22825_77480# 0.26116f
C160 VR a_25620_56280# 0.5866f
C161 a_32084_86100# a_32494_86100# 0.02581f
C162 a_65385_81680# a_66804_81620# 0.04818f
C163 VR a_32560_104860# 0.50376f
C164 LOIP a_25829_57069# 0.03088f
C165 a_10244_30660# VR 0.36374f
C166 VR a_35309_56340# 5.00914f
C167 a_3785_81820# a_3785_77480# 0.31831f
C168 a_24387_78349# a_32494_86100# 0.0111f
C169 a_8825_26660# LOIP 0.083f
C170 LOQN a_22825_77480# 0.57803f
C171 a_49705_81680# VR 0.89698f
C172 a_14724_86100# VR 1.15119f
C173 a_26334_26942# a_17737_52869# 0.01149f
C174 a_53924_30660# VR 0.36374f
C175 a_25924_86100# a_22680_91340# 0.08463f
C176 VR a_26845_57069# 5.29648f
C177 a_65385_81680# a_65534_81620# 0.0476f
C178 a_8974_30660# VR 0.35048f
C179 a_24244_86100# a_24654_86100# 0.02581f
C180 a_24387_78349# a_32084_86100# 0.01119f
C181 a_16665_27002# a_17737_52869# 0.27562f
C182 a_57694_81480# VR 0.35048f
C183 VR a_51534_81620# 0.58576f
C184 a_57545_77480# a_57400_77480# 0.1904f
C185 a_41900_3486# a_43160_3486# 0.01209f
C186 a_16549_52000# a_17193_52000# 4.85628f
C187 a_47600_56280# a_25829_57069# 0.01666f
C188 a_49444_81620# VR 0.63502f
C189 VR a_38220_56280# 0.42934f
C190 a_16404_86100# a_13160_91340# 0.08463f
C191 a_41720_77480# LOQN 0.03991f
C192 a_13454_86100# VR 1.08855f
C193 a_26067_27389# a_35000_1180# 0.45175f
C194 a_35444_77420# a_32345_77480# 0.01955f
C195 a_37337_52869# a_36325_56340# 0.11661f
C196 a_52654_30660# VR 0.35048f
C197 a_24244_86100# a_24387_78349# 0.02163f
C198 VR a_25829_57069# 5.66941f
C199 a_32084_77420# a_32200_77480# 0.04076f
C200 a_8825_26660# VR 5.11783f
C201 a_57545_77480# VR 1.37387f
C202 VR a_49705_77822# 0.82207f
C203 a_57545_77480# a_57284_77420# 0.01292f
C204 a_3934_91280# VR 1.06472f
C205 a_46412_56280# a_25829_57069# 0.01274f
C206 a_43694_81480# VR 0.35048f
C207 a_38505_26660# a_38244_26600# 0.01292f
C208 a_15134_86100# a_13160_91340# 0.08073f
C209 a_13305_81820# a_16404_77420# 0.04759f
C210 VR a_24514_56280# 0.60458f
C211 VR a_41324_56280# 0.63502f
C212 a_24654_86100# a_22680_91340# 0.07953f
C213 a_8564_30660# VR 0.36293f
C214 a_57284_81480# VR 0.36293f
C215 B1 a_36325_56340# 0.04446f
C216 VR a_51124_81620# 0.58512f
C217 a_22825_77480# a_22974_77420# 0.04851f
C218 a_3640_91340# VR 3.28133f
C219 a_17093_52869# a_17193_52000# 0.80904f
C220 a_51534_77762# a_49705_77822# 0.01149f
C221 a_45396_56280# a_25829_57069# 0.01203f
C222 a_43284_81480# VR 0.36374f
C223 a_24505_30860# a_17737_52869# 0.38839f
C224 a_14724_86100# a_13160_91340# 0.02016f
C225 a_22680_91340# a_24387_78349# 0.18584f
C226 a_5614_86100# a_3640_91340# 0.07953f
C227 a_16549_52000# a_19918_56280# 0.03874f
C228 a_25924_30800# a_24505_30860# 0.04818f
C229 VR a_40218_56280# 0.40926f
C230 a_37337_52869# a_35309_56340# 0.25434f
C231 a_24244_86100# a_22680_91340# 0.02016f
C232 a_37337_52869# a_46494_26942# 0.01511f
C233 VR a_21458_56280# 0.40379f
C234 a_40640_1364# a_40067_27249# 0.01427f
C235 a_22680_91340# a_26334_86100# 0.01096f
C236 a_60345_30860# a_60345_27002# 0.38839f
C237 VR a_49854_81620# 0.60202f
C238 a_3524_91280# VR 1.06472f
C239 a_22825_77480# a_22680_77480# 0.40446f
C240 a_13454_86100# a_13160_91340# 0.08382f
C241 a_5204_86100# a_3640_91340# 0.02016f
C242 a_22680_91340# a_22974_91280# 0.02009f
C243 a_33764_77420# a_34174_77420# 0.0129f
C244 a_40067_27249# a_38360_26660# 0.04098f
C245 a_32494_77420# a_32345_77480# 0.04851f
C246 VR a_39760_56280# 0.42485f
C247 a_38569_65609# VR 8.09449f
C248 VR a_24104_56280# 0.63502f
C249 LOIP a_17193_52000# 0.03664f
C250 a_60345_30860# a_61764_30800# 0.04818f
C251 B1 a_35309_56340# 0.04432f
C252 a_35000_1180# a_35956_1120# 0.08666f
C253 a_32200_91340# LOIN 0.05574f
C254 a_60345_27002# a_62174_30800# 0.04066f
C255 a_3934_86100# a_3640_91340# 0.08382f
C256 a_22564_91280# a_22974_91280# 0.02581f
C257 a_42864_56280# a_43274_56280# 0.0129f
C258 a_22680_91340# a_22974_86100# 0.08382f
C259 a_26067_27389# a_26334_30800# 0.01196f
C260 a_38505_26660# a_38654_26600# 0.01991f
C261 VR a_38678_56280# 0.40809f
C262 a_25924_77420# a_26334_77420# 0.0129f
C263 LOIN a_13305_77480# 0.57803f
C264 a_26067_27389# a_35956_1120# 0.0139f
C265 B1 a_26845_57069# 0.10282f
C266 a_16665_27002# a_8825_26660# 0.38118f
C267 VR a_22974_56280# 0.60458f
C268 a_51278_52282# a_25829_57069# 0.02359f
C269 a_60345_30860# a_60494_30800# 0.0476f
C270 a_38569_65609# LOQN 0.1576f
C271 a_21997_11960# a_31384_11900# 0.05586f
C272 a_3524_86100# a_3640_91340# 0.01114f
C273 a_26067_27389# a_17737_52869# 0.69929f
C274 a_22564_91280# a_22680_91340# 0.07639f
C275 a_61764_30800# a_62174_30800# 0.0129f
C276 a_26067_27389# a_25924_30800# 0.01245f
C277 a_22680_91340# a_22564_86100# 0.01114f
C278 a_38505_26660# a_38360_26660# 0.1904f
C279 a_22564_86100# a_22974_86100# 0.02581f
C280 a_32345_81820# VR 0.23364f
C281 LOIP VDD 3.36844f
C282 LOIN VR 4.33426f
C283 B1 a_25829_57069# 0.19534f
C284 VR a_17193_52000# 5.96855f
C285 a_52505_26660# a_52244_30660# 0.01168f
C286 a_61764_30800# a_60345_27002# 0.02019f
C287 a_50704_56280# a_51114_56280# 0.0129f
C288 a_65124_81620# VR 0.63502f
C289 a_32345_81820# a_22707_82689# 0.04359f
C290 VDD a_13305_77480# 0.25314f
C291 a_32345_27002# a_17737_52869# 0.06039f
C292 VR a_22564_56280# 0.63535f
C293 a_13305_81820# a_13305_77480# 0.31831f
C294 a_24505_30860# a_8825_26660# 0.0727f
C295 VR a_21000_56280# 0.42896f
C296 a_18172_51940# a_17737_52869# 0.01788f
C297 VR a_34224_11900# 0.01634f
C298 a_59374_81480# VR 0.35048f
C299 VR a_67214_81620# 0.58576f
C300 a_32084_30800# a_17737_52869# 0.0116f
C301 a_3524_81760# a_3934_81760# 0.0129f
C302 VR VDD 37.4367f
C303 a_22825_81820# a_22974_81760# 0.0476f
C304 a_13305_81820# VR 0.25314f
C305 VR a_19918_56280# 0.40379f
C306 a_24244_30800# a_8825_26660# 0.0155f
C307 a_58964_81480# VR 0.36374f
C308 a_22707_82689# VDD 0.23364f
C309 a_31569_13109# LOIP 0.0412f
C310 a_26334_30800# a_17737_52869# 0.04066f
C311 a_40067_27249# LOIP 0.04198f
C312 a_25924_30800# a_26334_30800# 0.0129f
C313 a_42320_1364# a_42740_1364# 0.1684f
C314 a_60345_27002# a_60494_26942# 0.01511f
C315 a_22564_81760# a_22974_81760# 0.0129f
C316 LOQP VR 2.7972f
C317 LOQN VDD 3.31596f
C318 VR a_19460_56280# 0.42934f
C319 a_32494_30800# VR 0.3476f
C320 a_43427_78069# VR 6.57248f
C321 VR a_35584_11900# 0.01621f
C322 a_25924_30800# a_17737_52869# 0.02019f
C323 a_16665_27002# a_18494_26942# 0.01149f
C324 a_52505_26660# a_52654_26600# 0.01991f
C325 a_35854_77420# a_35444_77420# 0.0129f
C326 a_35854_77420# a_32345_77480# 0.04071f
C327 a_43580_3486# a_44840_3486# 0.01209f
C328 VR a_18272_56280# 0.58366f
C329 a_26067_27389# a_8825_26660# 0.09997f
C330 a_7294_86100# a_3785_77480# 0.07629f
C331 a_52360_26660# a_52654_26600# 0.01069f
C332 a_45104_69020# VR 0.50376f
C333 a_31569_13109# VR 1.11944f
C334 a_42014_81480# VR 0.35048f
C335 LOQN LOQP 0.059f
C336 a_40067_27249# VR 1.25428f
C337 a_52505_26660# a_52360_26660# 0.1904f
C338 a_43427_78069# LOQN 0.11749f
C339 a_22825_81820# a_22825_77480# 0.30304f
C340 a_38244_26600# a_38360_26660# 0.01998f
C341 a_33764_86100# a_32200_91340# 0.02016f
C342 a_60084_30800# a_60494_30800# 0.0129f
C343 a_3785_81820# VR 0.25314f
C344 B1 a_17193_52000# 0.08907f
C345 a_6884_86100# a_3785_77480# 0.02926f
C346 a_38569_65609# a_52794_51940# 0.01988f
C347 a_37337_52869# VDD 0.50629f
C348 a_41865_77480# VR 1.33902f
C349 a_31220_52282# a_16449_52869# 0.01817f
C350 a_38654_30660# VR 0.35048f
C351 a_16665_27002# a_16814_26942# 0.01511f
C352 VR a_35584_13271# 0.01175f
C353 a_16665_27002# VDD 0.45065f
C354 a_52505_26660# a_52244_26600# 0.01292f
C355 a_32494_86100# a_32200_91340# 0.08382f
C356 VR a_65385_77822# 0.8238f
C357 a_39938_52282# a_35309_56340# 0.02044f
C358 a_25924_86100# VR 1.06472f
C359 a_38360_26660# a_40334_26600# 0.01988f
C360 a_52244_26600# a_52360_26660# 0.01998f
C361 a_24387_78349# a_32494_91280# 0.01749f
C362 B0 VDD 2.68049f
C363 a_52505_26660# a_54334_30660# 0.0199f
C364 a_30138_52282# a_16449_52869# 0.02336f
C365 a_41604_81480# VR 0.36293f
C366 a_29680_52282# a_17093_52869# 0.01507f
C367 a_33764_86100# VR 1.15119f
C368 a_38505_26660# VR 2.34588f
C369 a_46520_3486# a_46940_3486# 0.1684f
C370 B1 VDD 1.67605f
C371 VCTRL VR 0.46828f
C372 a_41865_77480# LOQN 0.61296f
C373 a_32084_86100# a_32200_91340# 0.01114f
C374 a_24387_78349# LOIP 0.04359f
C375 VR a_66804_81620# 0.58512f
C376 a_34174_86100# a_33764_86100# 0.02581f
C377 a_57545_77480# a_57694_77420# 0.01991f
C378 a_35309_56340# a_36325_56340# 3.01262f
C379 a_24387_78349# a_32200_91340# 0.3401f
C380 a_33764_86100# a_22707_82689# 0.02163f
C381 a_41478_52282# a_36325_56340# 0.02274f
C382 a_32494_86100# VR 1.08855f
C383 a_38244_30660# VR 0.36293f
C384 a_36484_51940# a_16549_52000# 0.01156f
C385 a_50704_18340# B1 0.01161f
C386 a_54334_26600# a_52360_26660# 0.01988f
C387 a_36325_56340# a_26845_57069# 0.83976f
C388 VR a_65534_81620# 0.60202f
C389 a_24654_86100# VR 1.0911f
C390 a_35309_56340# a_36016_56280# 0.01539f
C391 a_38360_26660# a_38654_26600# 0.01069f
C392 a_41720_77480# a_42014_77420# 0.01069f
C393 a_24387_78349# a_32084_91280# 0.02024f
C394 a_8825_26660# a_17737_52869# 0.02056f
C395 a_52505_26660# a_52654_30660# 0.02238f
C396 a_32084_86100# VR 1.15401f
C397 a_16665_27002# a_40067_27249# 0.12962f
C398 a_35444_77420# a_32345_81820# 0.04759f
C399 a_32345_81820# a_32345_77480# 0.30026f
C400 a_46000_69020# VR 0.50376f
C401 a_31678_52282# a_17093_52869# 0.02274f
C402 a_65385_77822# a_67214_77762# 0.01149f
C403 LOIN a_32345_77480# 1.08064f
C404 a_24387_78349# VR 6.58618f
C405 a_46928_51940# a_26845_57069# 0.01053f
C406 a_36325_56340# a_25829_57069# 0.1249f
C407 VR a_65385_81680# 0.89698f
C408 a_46284_51940# a_35309_56340# 0.01928f
C409 a_43427_78069# a_54334_51940# 0.01988f
C410 a_49140_56280# VR 0.42896f
C411 a_24244_86100# VR 1.15119f
C412 a_31569_13109# B0 0.27231f
C413 a_16404_77420# a_16814_77420# 0.0129f
C414 a_40067_27249# B0 0.04326f
C415 a_14724_86100# a_15134_86100# 0.02581f
C416 a_22707_82689# a_32200_77480# 0.09664f
C417 LOIP a_3785_77480# 0.57803f
C418 a_26334_86100# VR 1.06472f
C419 a_16449_52869# a_16549_52000# 1.18566f
C420 a_24387_78349# a_22707_82689# 0.36873f
C421 a_46284_51940# a_26845_57069# 0.01949f
C422 a_46928_51940# a_25829_57069# 0.01432f
C423 a_22974_91280# VR 1.06472f
C424 VR a_43274_56280# 0.60202f
C425 a_41324_56280# a_36325_56340# 0.01258f
C426 a_35309_56340# a_26845_57069# 1.56563f
C427 a_44544_18340# B0 0.01161f
C428 a_38505_26660# a_37337_52869# 0.10471f
C429 a_3785_77480# a_13305_77480# 0.21795f
C430 a_41604_77420# a_41720_77480# 0.01998f
C431 a_17528_51940# a_17193_52000# 0.01482f
C432 a_41020_52282# a_35309_56340# 0.01468f
C433 a_6884_86100# a_7294_86100# 0.02581f
C434 a_52244_56280# VR 0.63502f
C435 a_16665_27002# a_38505_26660# 0.99366f
C436 a_38220_56280# a_35309_56340# 0.01415f
C437 VDD a_32345_77480# 0.25314f
C438 a_8564_26600# a_8680_26660# 0.01998f
C439 a_16449_52869# a_16240_56280# 0.01121f
C440 a_22974_91280# a_22707_82689# 0.01749f
C441 a_65385_77822# a_65534_77762# 0.01511f
C442 a_16449_52869# a_30380_56280# 0.01238f
C443 a_22680_91340# VR 3.28133f
C444 a_40218_56280# a_36325_56340# 0.0254f
C445 a_26067_27389# VDD 1.70541f
C446 a_35309_56340# a_25829_57069# 0.72263f
C447 a_22974_86100# VR 1.08855f
C448 a_18172_51940# a_17193_52000# 0.02485f
C449 VR a_3785_77480# 3.65037f
C450 a_42740_1364# a_44000_1364# 0.01209f
C451 a_51114_56280# VR 0.60202f
C452 VCTRL B0 2.00371f
C453 a_16449_52869# a_17093_52869# 2.15651f
C454 a_22680_91340# a_22707_82689# 0.2973f
C455 a_25829_57069# a_26845_57069# 5.5139f
C456 a_16449_52869# a_29298_56280# 0.02854f
C457 a_49705_81680# a_49705_77822# 0.38839f
C458 a_22974_86100# a_22707_82689# 0.0111f
C459 a_22564_91280# VR 1.06472f
C460 VR a_42864_56280# 0.63502f
C461 a_39760_56280# a_36325_56340# 0.01479f
C462 a_22564_86100# VR 1.15401f
C463 a_8680_26660# a_10654_26600# 0.01988f
C464 a_34224_11900# a_21997_11960# 0.0514f
C465 a_41060_1364# a_42320_1364# 0.01209f
C466 a_38569_65609# a_36325_56340# 1.1011f
C467 LOQP a_32345_77480# 0.57803f
C468 a_8825_26660# a_8974_30660# 0.02238f
C469 VDD a_21997_11960# 8.04466f
C470 a_50704_56280# VR 0.63502f
C471 a_57545_77480# a_57694_81480# 0.02238f
C472 a_60345_27002# a_62174_26942# 0.01149f
C473 a_49705_77822# a_51534_81620# 0.04066f
C474 a_43427_78069# a_52654_56280# 0.05273f
C475 a_49705_81680# a_51124_81620# 0.04818f
C476 a_22564_91280# a_22707_82689# 0.02024f
C477 a_22564_86100# a_22707_82689# 0.01119f
C478 VR a_41734_56280# 0.60202f
C479 a_16814_86100# a_13305_77480# 0.07629f
C480 a_17093_52869# a_17256_56280# 0.01096f
C481 a_31569_13109# a_44954_14482# 0.01511f
C482 a_35000_1180# a_40067_27249# 0.0555f
C483 a_17737_52869# a_17193_52000# 0.22573f
C484 a_49598_56280# VR 0.40926f
C485 LOIP a_16449_52869# 0.06935f
C486 VDD a_31384_11900# 0.70783f
C487 a_51124_81620# a_51534_81620# 0.0129f
C488 a_49705_81680# a_49854_81620# 0.0476f
C489 a_17093_52869# a_26636_56280# 0.01345f
C490 a_32345_27002# a_32494_30800# 0.02481f
C491 a_26067_27389# a_40067_27249# 0.32468f
C492 a_16814_86100# VR 1.06472f
C493 a_8680_26660# a_8974_26600# 0.01069f
C494 a_38569_65609# a_35309_56340# 0.21462f
C495 a_17093_52869# a_16549_52000# 1.9466f
C496 a_41720_77480# a_38569_65609# 0.02828f
C497 a_8564_30660# a_8825_26660# 0.01168f
C498 a_17193_52000# a_36325_56340# 0.01084f
C499 a_24387_78349# a_22680_77480# 0.09664f
C500 a_49705_81680# a_38569_65609# 0.0727f
C501 a_19880_52282# a_17193_52000# 0.01507f
C502 a_57284_81480# a_57545_77480# 0.01168f
C503 VDD a_30084_11900# 0.75817f
C504 a_51124_81620# a_49705_77822# 0.02019f
C505 a_6884_77420# a_7294_77420# 0.0129f
C506 a_49444_81620# a_49854_81620# 0.0129f
C507 a_3640_91340# a_3934_91280# 0.02009f
C508 a_38569_65609# a_26845_57069# 0.59928f
C509 a_13305_77480# a_16814_77420# 0.04071f
C510 LOIN a_22825_77480# 0.16f
C511 a_38678_56280# a_35309_56340# 0.03473f
C512 a_17737_52869# VDD 0.49431f
C513 a_17093_52869# a_30380_56280# 0.01402f
C514 a_31569_13109# a_21997_11960# 0.91962f
C515 a_41480_3486# a_41900_3486# 0.1684f
C516 a_17193_52000# a_36016_56280# 0.01202f
C517 VR a_16449_52869# 5.33977f
C518 a_49444_81620# a_38569_65609# 0.0155f
C519 a_13044_86100# VR 1.15401f
C520 a_18816_51940# a_17193_52000# 0.01823f
C521 a_35000_1180# VCTRL 0.38172f
C522 VDD a_17524_11900# 0.75817f
C523 a_3524_91280# a_3934_91280# 0.02581f
C524 a_16449_52869# a_33484_56280# 0.01484f
C525 a_13305_77480# a_16404_77420# 0.01991f
C526 a_38569_65609# a_25829_57069# 0.37451f
C527 LOIP a_16549_52000# 0.03088f
C528 a_17093_52869# a_29298_56280# 0.01349f
C529 a_26067_27389# VCTRL 2.32671f
C530 a_38569_65609# a_49705_77822# 0.02056f
C531 a_17193_52000# a_35309_56340# 0.46429f
C532 a_7294_86100# VR 1.06472f
C533 VDD a_30084_13271# 0.75357f
C534 VR a_17256_56280# 0.59569f
C535 a_3524_91280# a_3640_91340# 0.07639f
C536 VDD a_22825_77480# 0.25314f
C537 a_16814_86100# a_13160_91340# 0.01096f
C538 a_17193_52000# a_26845_57069# 0.10383f
C539 a_17093_52869# a_28840_56280# 0.01696f
C540 a_24104_56280# a_24514_56280# 0.0129f
C541 a_13454_81760# a_13305_81820# 0.0476f
C542 a_6884_86100# VR 1.06472f
C543 VR a_26636_56280# 0.59569f
C544 a_14724_77420# a_15134_77420# 0.0129f
C545 a_32200_77480# a_32345_77480# 0.40446f
C546 VR a_16549_52000# 5.12766f
C547 a_17093_52869# a_30838_56280# 0.03566f
C548 LOIP a_17093_52869# 0.21103f
C549 a_24387_78349# a_32345_77480# 0.72487f
C550 a_17193_52000# a_25829_57069# 0.1101f
C551 a_17093_52869# a_27652_56280# 0.01274f
C552 a_16665_27002# a_46940_3486# 0.05175f
C553 a_13454_81760# a_13044_81760# 0.0129f
C554 a_13044_86100# a_13160_91340# 0.01114f
C555 a_46084_30800# a_38505_26660# 0.01161f
C556 a_34174_77420# a_32200_77480# 0.04066f
C557 VR a_16240_56280# 0.5866f
C558 a_5204_77420# a_5614_77420# 0.0129f
C559 VR a_30380_56280# 0.42713f
C560 a_24944_43540# VR 0.50376f
C561 a_22974_77420# a_22564_77420# 0.0129f
C562 a_32200_91340# a_32494_91280# 0.02009f
C563 a_40334_30660# a_38505_26660# 0.0199f
C564 a_47572_51940# a_26845_57069# 0.02407f
C565 a_33764_77420# a_32200_77480# 0.01615f
C566 a_13160_77480# a_15134_77420# 0.04066f
C567 a_52244_56280# a_52654_56280# 0.0129f
C568 VR a_17093_52869# 5.51748f
C569 VR a_29298_56280# 0.40703f
C570 a_41720_77480# a_43427_78069# 0.04098f
C571 a_59374_81480# a_57545_77480# 0.0199f
C572 a_8825_26660# VDD 0.50629f
C573 a_17193_52000# a_21458_56280# 0.04097f
C574 a_43427_78069# a_49705_81680# 0.10248f
C575 a_22680_77480# a_22564_77420# 0.04076f
C576 a_5614_77420# a_3640_77480# 0.04066f
C577 a_32084_91280# a_32494_91280# 0.02581f
C578 a_35854_86100# a_32200_91340# 0.01096f
C579 a_16665_27002# a_38360_26660# 0.03744f
C580 a_38384_43540# VR 0.50376f
C581 a_32494_77420# a_32200_77480# 0.01483f
C582 LOIP a_13305_77480# 0.16f
C583 a_43427_78069# a_26845_57069# 0.17927f
C584 B1 a_16449_52869# 0.55294f
C585 a_44380_56280# VR 0.5866f
C586 a_50820_52282# a_26845_57069# 0.01361f
C587 VR a_28840_56280# 0.42707f
C588 a_32494_91280# VR 1.06472f
C589 a_10654_30660# VR 0.35048f
C590 a_42014_77420# a_41865_77480# 0.01988f
C591 a_38569_65609# LOIN 0.04359f
C592 a_43427_78069# a_51534_81620# 0.01196f
C593 a_5204_77420# a_3640_77480# 0.01615f
C594 a_37128_51940# a_37337_52869# 0.01025f
C595 a_32084_91280# a_32200_91340# 0.07639f
C596 a_35444_86100# a_32200_91340# 0.08455f
C597 a_35444_86100# a_35854_86100# 0.02581f
C598 a_37337_52869# a_16549_52000# 0.01116f
C599 a_25924_86100# a_22825_77480# 0.02926f
C600 VR a_31664_104860# 0.50376f
C601 VR a_30838_56280# 0.40703f
C602 a_32494_77420# a_32084_77420# 0.0129f
C603 a_32560_43540# VR 0.50376f
C604 LOIP VR 2.78723f
C605 a_21878_52282# a_17193_52000# 0.02274f
C606 a_3640_77480# a_3934_77420# 0.01483f
C607 a_49738_52282# a_26845_57069# 0.01999f
C608 a_50820_52282# a_25829_57069# 0.01087f
C609 VR a_27652_56280# 0.58375f
C610 a_32345_81820# a_32494_81760# 0.0476f
C611 a_32200_91340# VR 3.28833f
C612 a_41720_77480# a_41865_77480# 0.1904f
C613 a_35854_86100# VR 1.06472f
C614 a_48058_56280# VR 0.40926f
C615 a_43427_78069# a_49705_77822# 0.69929f
C616 a_22825_81820# a_24387_78349# 0.04359f
C617 a_43427_78069# a_43694_81480# 0.01027f
C618 a_18084_30800# VR 0.58512f
C619 a_34174_86100# a_32200_91340# 0.08073f
C620 VR a_13305_77480# 3.8891f
C621 a_22707_82689# LOIP 0.09877f
C622 a_31664_43540# VR 0.50376f
C623 a_57284_77420# a_57400_77480# 0.01998f
C624 a_3524_77420# a_3934_77420# 0.0129f
C625 a_32200_91340# a_22707_82689# 0.18615f
C626 a_49738_52282# a_25829_57069# 0.01321f
C627 a_38569_65609# VDD 0.50629f
C628 VR a_33894_56280# 0.60202f
C629 a_32084_81760# a_32494_81760# 0.0129f
C630 a_8825_26660# a_31569_13109# 0.53824f
C631 a_41604_77420# a_41865_77480# 0.01292f
C632 a_32084_91280# VR 1.06472f
C633 a_40067_27249# a_8825_26660# 0.0418f
C634 a_32345_81820# LOIN 0.04191f
C635 a_16665_30860# a_18084_30800# 0.04818f
C636 B1 a_16549_52000# 0.08773f
C637 a_35444_86100# VR 1.06472f
C638 a_47600_56280# VR 0.42896f
C639 a_43427_78069# a_51124_81620# 0.01245f
C640 a_33484_56280# a_33894_56280# 0.0129f
C641 a_16814_30800# VR 0.60202f
C642 a_13305_77480# a_13454_77420# 0.04851f
C643 a_22707_82689# a_13305_77480# 0.07806f
C644 VR a_25840_104860# 0.50376f
C645 a_25840_43540# VR 0.50376f
C646 a_22564_56280# a_22974_56280# 0.0129f
C647 a_5614_86100# VR 1.0911f
C648 a_3524_77420# a_3640_77480# 0.04076f
C649 a_49280_52282# a_25829_57069# 0.01707f
C650 VR a_33484_56280# 0.63502f
C651 a_34174_86100# VR 1.0911f
C652 a_16665_30860# a_16814_30800# 0.0476f
C653 a_46412_56280# VR 0.58375f
C654 a_24387_78349# a_22825_77480# 0.16643f
C655 a_16665_30860# VR 0.89698f
C656 a_13305_77480# a_13160_77480# 0.41268f
C657 a_41865_77480# a_43694_81480# 0.0199f
C658 a_22707_82689# VR 5.58484f
C659 a_13454_91280# a_13305_77480# 0.08473f
C660 a_17193_52000# a_22564_56280# 0.01082f
C661 VR a_24944_104860# 0.50376f
C662 a_5204_86100# VR 1.15119f
C663 a_43427_78069# a_38569_65609# 0.22593f
C664 a_3785_81820# a_6884_77420# 0.04759f
C665 a_48216_51940# a_25829_57069# 0.01823f
C666 a_26334_86100# a_22825_77480# 0.07629f
C667 a_22825_81820# a_25924_77420# 0.04759f
C668 VR a_32354_56280# 0.60019f
C669 LOIN VDD 0.97865f
C670 a_5204_86100# a_5614_86100# 0.02581f
C671 LOQN VR 2.58765f
C672 a_45260_3486# a_44840_3486# 0.1684f
C673 a_13160_77480# a_14724_77420# 0.01615f
C674 a_16404_30800# a_16814_30800# 0.0129f
C675 B1 a_17093_52869# 0.09227f
C676 a_45396_56280# VR 0.59569f
C677 a_22974_91280# a_22825_77480# 0.08473f
C678 a_16404_30800# VR 0.63502f
C679 VR a_24944_69020# 0.50376f
C680 a_43160_3486# a_43580_3486# 0.1684f
C681 a_44000_1364# a_44420_1364# 0.1684f
C682 a_13160_91340# a_13305_77480# 1.00375f
C683 a_13454_91280# VR 1.06472f
C684 a_16665_27002# LOIP 0.0799f
C685 a_3934_86100# VR 1.08855f
C686 VR a_31944_56280# 0.63502f
C687 a_22825_77480# a_26334_77420# 0.04071f
C688 a_13160_77480# a_13454_77420# 0.01483f
C689 a_22680_91340# a_22825_77480# 0.99338f
C690 a_16665_27002# a_18084_30800# 0.02019f
C691 a_49140_56280# a_26845_57069# 0.01153f
C692 a_13044_91280# a_13305_77480# 0.01114f
C693 LOIP B0 0.04359f
C694 a_13160_91340# VR 3.28833f
C695 LOIN LOQP 0.89981f
C696 a_41720_77480# a_43694_77420# 0.01988f
C697 VDD a_34224_11900# 0.70783f
C698 a_49705_77822# a_49854_77762# 0.01511f
C699 a_17193_52000# a_19460_56280# 0.01031f
C700 a_3524_86100# VR 1.15401f
C701 a_41865_77480# a_38569_65609# 0.91807f
C702 a_43427_78069# LOIN 0.04359f
C703 B1 LOIP 0.12259f
C704 a_22825_77480# a_25924_77420# 0.01962f
C705 a_39280_43540# VR 0.50376f
C706 a_13044_77420# a_13454_77420# 0.0129f
C707 a_22564_91280# a_22825_77480# 0.01114f
C708 a_31944_56280# a_32354_56280# 0.0129f
C709 a_37337_52869# VR 2.04685f
C710 a_49140_56280# a_25829_57069# 0.01047f
C711 a_13044_91280# VR 1.06472f
C712 a_16665_27002# VR 3.15996f
C713 a_17193_52000# a_18272_56280# 0.01555f
C714 a_50704_18340# VDD 0.36569f
C715 a_39280_69020# VR 0.50376f
C716 a_52244_56280# a_26845_57069# 0.01443f
C717 VDD a_41016_11900# 0.70298f
C718 a_13044_77420# a_13160_77480# 0.04076f
C719 a_27972_51940# a_16449_52869# 0.02119f
C720 B0 VR 0.10689f
C721 LOQP VDD 0.28495f
C722 a_16665_27002# a_16665_30860# 0.38839f
C723 a_45680_1364# a_44420_1364# 0.01209f
C724 a_13160_91340# a_13454_91280# 0.02009f
C725 a_17528_51940# a_16549_52000# 0.01254f
C726 a_42864_56280# a_35309_56340# 0.01405f
C727 a_44954_18340# VDD 0.3476f
C728 a_38384_69020# VR 0.50376f
C729 a_43427_78069# VDD 0.50329f
C730 B1 VR 2.15052f
C731 VDD a_35584_11900# 0.70298f
C732 a_24654_30800# VR 0.60202f
C733 a_40220_3486# a_39800_3486# 0.1684f
C734 a_3524_86100# a_3934_86100# 0.02581f
C735 a_39480_52282# a_36325_56340# 0.01514f
C736 a_27328_51940# a_16449_52869# 0.01038f
C737 a_16404_86100# a_16814_86100# 0.02581f
C738 a_16884_51940# a_16549_52000# 0.01785f
C739 a_13044_91280# a_13454_91280# 0.02581f
C740 a_24244_77420# a_24654_77420# 0.0129f
R0 B1 B1.n0 1e-3
R1 B1.n0 B1.t1 1e-3
R2 B1.n0 B1.t0 1e-3
R3 LOIN LOIN.n1 1e-3
R4 LOIN.n1 LOIN.t2 1e-3
R5 LOIN.n1 LOIN.n0 1e-3
R6 LOIN.n0 LOIN.t1 1e-3
R7 LOIN.n0 LOIN.t0 1e-3
R8 LOIP LOIP.n1 1e-3
R9 LOIP.n1 LOIP.t2 1e-3
R10 LOIP.n1 LOIP.n0 1e-3
R11 LOIP.n0 LOIP.t0 1e-3
R12 LOIP.n0 LOIP.t1 1e-3
R13 VR.n259 VR.t281 1e-3
R14 VR.t81 VR.n535 1e-3
R15 VR.n261 VR.t215 1e-3
R16 VR.t183 VR.n519 1e-3
R17 VR.n263 VR.t10 1e-3
R18 VR.t264 VR.n503 1e-3
R19 VR.n265 VR.t122 1e-3
R20 VR.t308 VR.n487 1e-3
R21 VR.n251 VR.t153 1e-3
R22 VR.t151 VR.n358 1e-3
R23 VR.n253 VR.t38 1e-3
R24 VR.t44 VR.n470 1e-3
R25 VR.n255 VR.t60 1e-3
R26 VR.t66 VR.n476 1e-3
R27 VR.n257 VR.t192 1e-3
R28 VR.t290 VR.n483 1e-3
R29 VR.n267 VR.t248 1e-3
R30 VR.t254 VR.n555 1e-3
R31 VR.n269 VR.t315 1e-3
R32 VR.t323 VR.n562 1e-3
R33 VR.n271 VR.t268 1e-3
R34 VR.t274 VR.n575 1e-3
R35 VR.n273 VR.t235 1e-3
R36 VR.t241 VR.n569 1e-3
R37 VR.n275 VR.t113 1e-3
R38 VR.t119 VR.n592 1e-3
R39 VR.n277 VR.t157 1e-3
R40 VR.t163 VR.n598 1e-3
R41 VR.n279 VR.t206 1e-3
R42 VR.t212 VR.n610 1e-3
R43 VR.n281 VR.t227 1e-3
R44 VR.t233 VR.n604 1e-3
R45 VR.t287 VR.n536 1e-3
R46 VR.n536 VR.t71 1e-3
R47 VR.t225 VR.n520 1e-3
R48 VR.n520 VR.t177 1e-3
R49 VR.t16 VR.n504 1e-3
R50 VR.n504 VR.t258 1e-3
R51 VR.t128 VR.n488 1e-3
R52 VR.n488 VR.t302 1e-3
R53 VR.t281 VR.t283 1e-3
R54 VR.t283 VR.t285 1e-3
R55 VR.t285 VR.t287 1e-3
R56 VR.t71 VR.t77 1e-3
R57 VR.t77 VR.t79 1e-3
R58 VR.t79 VR.t81 1e-3
R59 VR.t215 VR.t221 1e-3
R60 VR.t221 VR.t223 1e-3
R61 VR.t223 VR.t225 1e-3
R62 VR.t177 VR.t179 1e-3
R63 VR.t179 VR.t181 1e-3
R64 VR.t181 VR.t183 1e-3
R65 VR.t10 VR.t12 1e-3
R66 VR.t12 VR.t14 1e-3
R67 VR.t14 VR.t16 1e-3
R68 VR.t258 VR.t260 1e-3
R69 VR.t260 VR.t262 1e-3
R70 VR.t262 VR.t264 1e-3
R71 VR.t122 VR.t124 1e-3
R72 VR.t124 VR.t126 1e-3
R73 VR.t126 VR.t128 1e-3
R74 VR.t302 VR.t304 1e-3
R75 VR.t304 VR.t306 1e-3
R76 VR.t306 VR.t308 1e-3
R77 VR.t153 VR.t155 1e-3
R78 VR.t149 VR.t151 1e-3
R79 VR.t38 VR.t40 1e-3
R80 VR.t42 VR.t44 1e-3
R81 VR.t60 VR.t62 1e-3
R82 VR.t64 VR.t66 1e-3
R83 VR.t192 VR.t34 1e-3
R84 VR.t97 VR.t290 1e-3
R85 VR.t248 VR.t252 1e-3
R86 VR.t250 VR.t254 1e-3
R87 VR.t315 VR.t319 1e-3
R88 VR.t321 VR.t323 1e-3
R89 VR.t268 VR.t270 1e-3
R90 VR.t272 VR.t274 1e-3
R91 VR.t235 VR.t237 1e-3
R92 VR.t239 VR.t241 1e-3
R93 VR.t113 VR.t115 1e-3
R94 VR.t117 VR.t119 1e-3
R95 VR.t157 VR.t159 1e-3
R96 VR.t161 VR.t163 1e-3
R97 VR.t206 VR.t208 1e-3
R98 VR.t210 VR.t212 1e-3
R99 VR.t227 VR.t229 1e-3
R100 VR.t231 VR.t233 1e-3
R101 VR.n259 VR.n58 1e-3
R102 VR.n535 VR.n58 1e-3
R103 VR.n261 VR.n62 1e-3
R104 VR.n519 VR.n62 1e-3
R105 VR.n263 VR.n66 1e-3
R106 VR.n503 VR.n66 1e-3
R107 VR.n265 VR.n70 1e-3
R108 VR.n487 VR.n70 1e-3
R109 VR.n259 VR.n59 1e-3
R110 VR.n535 VR.n61 1e-3
R111 VR.n261 VR.n63 1e-3
R112 VR.n519 VR.n65 1e-3
R113 VR.n263 VR.n67 1e-3
R114 VR.n503 VR.n69 1e-3
R115 VR.n265 VR.n71 1e-3
R116 VR.n487 VR.n73 1e-3
R117 VR.n75 VR.n349 1e-3
R118 VR.n78 VR.n345 1e-3
R119 VR.n81 VR.n339 1e-3
R120 VR.n84 VR.n335 1e-3
R121 VR.n87 VR.n330 1e-3
R122 VR.n90 VR.n326 1e-3
R123 VR.n93 VR.t326 1e-3
R124 VR.n96 VR.t134 1e-3
R125 VR.n36 VR.n74 1e-3
R126 VR.n38 VR.n77 1e-3
R127 VR.n40 VR.n80 1e-3
R128 VR.n42 VR.n83 1e-3
R129 VR.n44 VR.n86 1e-3
R130 VR.n46 VR.n89 1e-3
R131 VR.n48 VR.n92 1e-3
R132 VR.n50 VR.n95 1e-3
R133 VR.n251 VR.n355 1e-3
R134 VR.n358 VR.n355 1e-3
R135 VR.n253 VR.n467 1e-3
R136 VR.n470 VR.n467 1e-3
R137 VR.n255 VR.n473 1e-3
R138 VR.n476 VR.n473 1e-3
R139 VR.n257 VR.n480 1e-3
R140 VR.n483 VR.n480 1e-3
R141 VR.n267 VR.n552 1e-3
R142 VR.n555 VR.n552 1e-3
R143 VR.n269 VR.n559 1e-3
R144 VR.n562 VR.n559 1e-3
R145 VR.n271 VR.n572 1e-3
R146 VR.n575 VR.n572 1e-3
R147 VR.n273 VR.n566 1e-3
R148 VR.n569 VR.n566 1e-3
R149 VR.n275 VR.n589 1e-3
R150 VR.n592 VR.n589 1e-3
R151 VR.n277 VR.n595 1e-3
R152 VR.n598 VR.n595 1e-3
R153 VR.n279 VR.n607 1e-3
R154 VR.n610 VR.n607 1e-3
R155 VR.n281 VR.n601 1e-3
R156 VR.n604 VR.n601 1e-3
R157 VR.n251 VR.n357 1e-3
R158 VR.n358 VR.n357 1e-3
R159 VR.n253 VR.n469 1e-3
R160 VR.n470 VR.n469 1e-3
R161 VR.n255 VR.n475 1e-3
R162 VR.n476 VR.n475 1e-3
R163 VR.n257 VR.n482 1e-3
R164 VR.n483 VR.n482 1e-3
R165 VR.n267 VR.n554 1e-3
R166 VR.n555 VR.n554 1e-3
R167 VR.n269 VR.n561 1e-3
R168 VR.n562 VR.n561 1e-3
R169 VR.n271 VR.n574 1e-3
R170 VR.n575 VR.n574 1e-3
R171 VR.n273 VR.n568 1e-3
R172 VR.n569 VR.n568 1e-3
R173 VR.n275 VR.n591 1e-3
R174 VR.n592 VR.n591 1e-3
R175 VR.n277 VR.n597 1e-3
R176 VR.n598 VR.n597 1e-3
R177 VR.n279 VR.n609 1e-3
R178 VR.n610 VR.n609 1e-3
R179 VR.n281 VR.n603 1e-3
R180 VR.n604 VR.n603 1e-3
R181 VR.t155 VR.n359 1e-3
R182 VR.n359 VR.t149 1e-3
R183 VR.t40 VR.n471 1e-3
R184 VR.n471 VR.t42 1e-3
R185 VR.t62 VR.n477 1e-3
R186 VR.n477 VR.t64 1e-3
R187 VR.t34 VR.n484 1e-3
R188 VR.n484 VR.t97 1e-3
R189 VR.t252 VR.n556 1e-3
R190 VR.n556 VR.t250 1e-3
R191 VR.t319 VR.n563 1e-3
R192 VR.n563 VR.t321 1e-3
R193 VR.t270 VR.n576 1e-3
R194 VR.n576 VR.t272 1e-3
R195 VR.t237 VR.n570 1e-3
R196 VR.n570 VR.t239 1e-3
R197 VR.t115 VR.n593 1e-3
R198 VR.n593 VR.t117 1e-3
R199 VR.t159 VR.n599 1e-3
R200 VR.n599 VR.t161 1e-3
R201 VR.t208 VR.n611 1e-3
R202 VR.n611 VR.t210 1e-3
R203 VR.t229 VR.n605 1e-3
R204 VR.n605 VR.t231 1e-3
R205 VR.n400 VR.n205 1e-3
R206 VR.n102 VR.n206 1e-3
R207 VR.n455 VR.n207 1e-3
R208 VR.n120 VR.n208 1e-3
R209 VR.n444 VR.n209 1e-3
R210 VR.n123 VR.n210 1e-3
R211 VR.n132 VR.n211 1e-3
R212 VR.n135 VR.n212 1e-3
R213 VR.n144 VR.n213 1e-3
R214 VR.n147 VR.n214 1e-3
R215 VR.n156 VR.n215 1e-3
R216 VR.n159 VR.n216 1e-3
R217 VR.n168 VR.n217 1e-3
R218 VR.n171 VR.n218 1e-3
R219 VR.n631 VR.n219 1e-3
R220 VR.n186 VR.n220 1e-3
R221 VR.n652 VR.n221 1e-3
R222 VR.n195 VR.n222 1e-3
R223 VR.n224 VR.n399 1e-3
R224 VR.n225 VR.n394 1e-3
R225 VR.n227 VR.n454 1e-3
R226 VR.n228 VR.n449 1e-3
R227 VR.n230 VR.n443 1e-3
R228 VR.n231 VR.n438 1e-3
R229 VR.n232 VR.n547 1e-3
R230 VR.n233 VR.n543 1e-3
R231 VR.n234 VR.n531 1e-3
R232 VR.n235 VR.n527 1e-3
R233 VR.n236 VR.n515 1e-3
R234 VR.n237 VR.n511 1e-3
R235 VR.n238 VR.n499 1e-3
R236 VR.n239 VR.n495 1e-3
R237 VR.n241 VR.n630 1e-3
R238 VR.n242 VR.n625 1e-3
R239 VR.n244 VR.n651 1e-3
R240 VR.n245 VR.n646 1e-3
R241 VR.n36 VR.t104 1e-3
R242 VR.n38 VR.t68 1e-3
R243 VR.n40 VR.t147 1e-3
R244 VR.n42 VR.t144 1e-3
R245 VR.n44 VR.t194 1e-3
R246 VR.n46 VR.t168 1e-3
R247 VR.n75 VR.n35 1e-3
R248 VR.n78 VR.n37 1e-3
R249 VR.n81 VR.n39 1e-3
R250 VR.n84 VR.n41 1e-3
R251 VR.n87 VR.n43 1e-3
R252 VR.n90 VR.n45 1e-3
R253 VR.n93 VR.n47 1e-3
R254 VR.n96 VR.n49 1e-3
R255 VR.n138 VR.t256 1e-3
R256 VR.n141 VR.t18 1e-3
R257 VR.n150 VR.t73 1e-3
R258 VR.n153 VR.t279 1e-3
R259 VR.n162 VR.t130 1e-3
R260 VR.n165 VR.t300 1e-3
R261 VR.n174 VR.t175 1e-3
R262 VR.n177 VR.t219 1e-3
R263 VR.n310 VR.n137 1e-3
R264 VR.n312 VR.n140 1e-3
R265 VR.n314 VR.n149 1e-3
R266 VR.n316 VR.n152 1e-3
R267 VR.n318 VR.n161 1e-3
R268 VR.n320 VR.n164 1e-3
R269 VR.n322 VR.n173 1e-3
R270 VR.n324 VR.n176 1e-3
R271 VR.n99 VR.n282 1e-3
R272 VR.n105 VR.n283 1e-3
R273 VR.n108 VR.n284 1e-3
R274 VR.n111 VR.n285 1e-3
R275 VR.n114 VR.n286 1e-3
R276 VR.n117 VR.n287 1e-3
R277 VR.n126 VR.n288 1e-3
R278 VR.n129 VR.n289 1e-3
R279 VR.n180 VR.n290 1e-3
R280 VR.n183 VR.n291 1e-3
R281 VR.n189 VR.n292 1e-3
R282 VR.n192 VR.n293 1e-3
R283 VR.n294 VR.n462 1e-3
R284 VR.n295 VR.n408 1e-3
R285 VR.n296 VR.n404 1e-3
R286 VR.n297 VR.n414 1e-3
R287 VR.n298 VR.n423 1e-3
R288 VR.n299 VR.n419 1e-3
R289 VR.n300 VR.n433 1e-3
R290 VR.n301 VR.n429 1e-3
R291 VR.n302 VR.n619 1e-3
R292 VR.n303 VR.n615 1e-3
R293 VR.n304 VR.n640 1e-3
R294 VR.n305 VR.n636 1e-3
R295 VR.n399 VR.n205 1e-3
R296 VR.n394 VR.n206 1e-3
R297 VR.n454 VR.n207 1e-3
R298 VR.n449 VR.n208 1e-3
R299 VR.n443 VR.n209 1e-3
R300 VR.n438 VR.n210 1e-3
R301 VR.n547 VR.n211 1e-3
R302 VR.n543 VR.n212 1e-3
R303 VR.n531 VR.n213 1e-3
R304 VR.n527 VR.n214 1e-3
R305 VR.n515 VR.n215 1e-3
R306 VR.n511 VR.n216 1e-3
R307 VR.n499 VR.n217 1e-3
R308 VR.n495 VR.n218 1e-3
R309 VR.n630 VR.n219 1e-3
R310 VR.n625 VR.n220 1e-3
R311 VR.n651 VR.n221 1e-3
R312 VR.n646 VR.n222 1e-3
R313 VR.n400 VR.n224 1e-3
R314 VR.n102 VR.n225 1e-3
R315 VR.n455 VR.n227 1e-3
R316 VR.n120 VR.n228 1e-3
R317 VR.n444 VR.n230 1e-3
R318 VR.n123 VR.n231 1e-3
R319 VR.n132 VR.n232 1e-3
R320 VR.n135 VR.n233 1e-3
R321 VR.n144 VR.n234 1e-3
R322 VR.n147 VR.n235 1e-3
R323 VR.n156 VR.n236 1e-3
R324 VR.n159 VR.n237 1e-3
R325 VR.n168 VR.n238 1e-3
R326 VR.n171 VR.n239 1e-3
R327 VR.n631 VR.n241 1e-3
R328 VR.n186 VR.n242 1e-3
R329 VR.n652 VR.n244 1e-3
R330 VR.n195 VR.n245 1e-3
R331 VR.n138 VR.n309 1e-3
R332 VR.n141 VR.n311 1e-3
R333 VR.n150 VR.n313 1e-3
R334 VR.n153 VR.n315 1e-3
R335 VR.n162 VR.n317 1e-3
R336 VR.n165 VR.n319 1e-3
R337 VR.n174 VR.n321 1e-3
R338 VR.n177 VR.n323 1e-3
R339 VR.n462 VR.n282 1e-3
R340 VR.n408 VR.n283 1e-3
R341 VR.n404 VR.n284 1e-3
R342 VR.n414 VR.n285 1e-3
R343 VR.n423 VR.n286 1e-3
R344 VR.n419 VR.n287 1e-3
R345 VR.n433 VR.n288 1e-3
R346 VR.n429 VR.n289 1e-3
R347 VR.n619 VR.n290 1e-3
R348 VR.n615 VR.n291 1e-3
R349 VR.n640 VR.n292 1e-3
R350 VR.n636 VR.n293 1e-3
R351 VR.n99 VR.n294 1e-3
R352 VR.n105 VR.n295 1e-3
R353 VR.n108 VR.n296 1e-3
R354 VR.n111 VR.n297 1e-3
R355 VR.n114 VR.n298 1e-3
R356 VR.n117 VR.n299 1e-3
R357 VR.n126 VR.n300 1e-3
R358 VR.n129 VR.n301 1e-3
R359 VR.n180 VR.n302 1e-3
R360 VR.n183 VR.n303 1e-3
R361 VR.n189 VR.n304 1e-3
R362 VR.n192 VR.n305 1e-3
R363 VR.n614 VR.n308 1e-3
R364 VR.n56 VR.t6 1e-3
R365 VR.n307 VR.t329 1e-3
R366 VR.n551 VR.n486 1e-3
R367 VR.n578 VR.n571 1e-3
R368 VR.n613 VR.n606 1e-3
R369 VR VR.n656 1e-3
R370 VR.n306 VR.n360 1e-3
R371 VR.n344 VR.n334 1e-3
R372 VR.n448 VR.n437 1e-3
R373 VR.n558 VR.n557 1e-3
R374 VR.n565 VR.n564 1e-3
R375 VR.n578 VR.n577 1e-3
R376 VR.n613 VR.n612 1e-3
R377 VR.n308 VR.n594 1e-3
R378 VR.n306 VR.n466 1e-3
R379 VR.n558 VR.n551 1e-3
R380 VR.n461 VR.n393 1e-3
R381 VR.n587 VR.n579 1e-3
R382 VR.n463 VR.t58 1e-3
R383 VR.n409 VR.t297 1e-3
R384 VR.n405 VR.t4 1e-3
R385 VR.n415 VR.t26 1e-3
R386 VR.n424 VR.t92 1e-3
R387 VR.n420 VR.t47 1e-3
R388 VR.n434 VR.t31 1e-3
R389 VR.n430 VR.t37 1e-3
R390 VR.n540 VR.t257 1e-3
R391 VR.n537 VR.t19 1e-3
R392 VR.n524 VR.t74 1e-3
R393 VR.n521 VR.t280 1e-3
R394 VR.n508 VR.t131 1e-3
R395 VR.n505 VR.t301 1e-3
R396 VR.n492 VR.t176 1e-3
R397 VR.n489 VR.t220 1e-3
R398 VR.n620 VR.t246 1e-3
R399 VR.n616 VR.t314 1e-3
R400 VR.n641 VR.t9 1e-3
R401 VR.n637 VR.t199 1e-3
R402 VR.n354 VR.n353 1e-3
R403 VR.n344 VR.n343 1e-3
R404 VR.n34 VR.t152 1e-3
R405 VR.n34 VR.t154 1e-3
R406 VR.n32 VR.t45 1e-3
R407 VR.n32 VR.t39 1e-3
R408 VR.n30 VR.t67 1e-3
R409 VR.n30 VR.t61 1e-3
R410 VR.n28 VR.t291 1e-3
R411 VR.n28 VR.t193 1e-3
R412 VR.n51 VR.t82 1e-3
R413 VR.n10 VR.t72 1e-3
R414 VR.n10 VR.t288 1e-3
R415 VR.n10 VR.t282 1e-3
R416 VR.n52 VR.t184 1e-3
R417 VR.n8 VR.t178 1e-3
R418 VR.n8 VR.t226 1e-3
R419 VR.n8 VR.t216 1e-3
R420 VR.n53 VR.t265 1e-3
R421 VR.n6 VR.t259 1e-3
R422 VR.n6 VR.t17 1e-3
R423 VR.n6 VR.t11 1e-3
R424 VR.n54 VR.t309 1e-3
R425 VR.n4 VR.t303 1e-3
R426 VR.n4 VR.t129 1e-3
R427 VR.n4 VR.t123 1e-3
R428 VR.n26 VR.t255 1e-3
R429 VR.n26 VR.t249 1e-3
R430 VR.n24 VR.t324 1e-3
R431 VR.n24 VR.t316 1e-3
R432 VR.n22 VR.t275 1e-3
R433 VR.n22 VR.t269 1e-3
R434 VR.n20 VR.t242 1e-3
R435 VR.n20 VR.t236 1e-3
R436 VR.n18 VR.t120 1e-3
R437 VR.n18 VR.t114 1e-3
R438 VR.n16 VR.t164 1e-3
R439 VR.n16 VR.t158 1e-3
R440 VR.n14 VR.t213 1e-3
R441 VR.n14 VR.t207 1e-3
R442 VR.n12 VR.t234 1e-3
R443 VR.n12 VR.t228 1e-3
R444 VR.n413 VR.n403 1e-3
R445 VR.n385 VR.t191 1e-3
R446 VR.n377 VR.t166 1e-3
R447 VR.n370 VR.t172 1e-3
R448 VR.n362 VR.t167 1e-3
R449 VR.n459 VR.n458 1e-3
R450 VR.n448 VR.n447 1e-3
R451 VR.n392 VR.n248 1e-3
R452 VR.n34 VR.t150 1e-3
R453 VR.n32 VR.t43 1e-3
R454 VR.n30 VR.t65 1e-3
R455 VR.n28 VR.t98 1e-3
R456 VR.n51 VR.t80 1e-3
R457 VR.n10 VR.t286 1e-3
R458 VR.n52 VR.t182 1e-3
R459 VR.n8 VR.t224 1e-3
R460 VR.n53 VR.t263 1e-3
R461 VR.n6 VR.t15 1e-3
R462 VR.n54 VR.t307 1e-3
R463 VR.n4 VR.t127 1e-3
R464 VR.n26 VR.t251 1e-3
R465 VR.n24 VR.t322 1e-3
R466 VR.n22 VR.t273 1e-3
R467 VR.n20 VR.t240 1e-3
R468 VR.n18 VR.t118 1e-3
R469 VR.n16 VR.t162 1e-3
R470 VR.n14 VR.t211 1e-3
R471 VR.n12 VR.t232 1e-3
R472 VR.n250 VR.n34 1e-3
R473 VR.n252 VR.n32 1e-3
R474 VR.n254 VR.n30 1e-3
R475 VR.n256 VR.n28 1e-3
R476 VR.n266 VR.n26 1e-3
R477 VR.n268 VR.n24 1e-3
R478 VR.n270 VR.n22 1e-3
R479 VR.n272 VR.n20 1e-3
R480 VR.n274 VR.n18 1e-3
R481 VR.n276 VR.n16 1e-3
R482 VR.n278 VR.n14 1e-3
R483 VR.n280 VR.n12 1e-3
R484 VR.n392 VR.n307 1e-3
R485 VR.n385 VR.t294 1e-3
R486 VR.n386 VR.t185 1e-3
R487 VR.n387 VR.t197 1e-3
R488 VR.n388 VR.t298 1e-3
R489 VR.n389 VR.t292 1e-3
R490 VR.n390 VR.t312 1e-3
R491 VR.n384 VR.t146 1e-3
R492 VR.n383 VR.t23 1e-3
R493 VR.n382 VR.t214 1e-3
R494 VR.n381 VR.t136 1e-3
R495 VR.n380 VR.t90 1e-3
R496 VR.n379 VR.t196 1e-3
R497 VR.n378 VR.t5 1e-3
R498 VR.n377 VR.t200 1e-3
R499 VR.n370 VR.t96 1e-3
R500 VR.n371 VR.t89 1e-3
R501 VR.n372 VR.t139 1e-3
R502 VR.n373 VR.t186 1e-3
R503 VR.n374 VR.t86 1e-3
R504 VR.n375 VR.t141 1e-3
R505 VR.n369 VR.t24 1e-3
R506 VR.n368 VR.t110 1e-3
R507 VR.n367 VR.t171 1e-3
R508 VR.n366 VR.t83 1e-3
R509 VR.n365 VR.t165 1e-3
R510 VR.n364 VR.t108 1e-3
R511 VR.n363 VR.t59 1e-3
R512 VR.n362 VR.t201 1e-3
R513 VR.n361 VR.n249 1e-3
R514 VR.n137 VR.n540 1e-3
R515 VR.n140 VR.n537 1e-3
R516 VR.n149 VR.n524 1e-3
R517 VR.n152 VR.n521 1e-3
R518 VR.n161 VR.n508 1e-3
R519 VR.n164 VR.n505 1e-3
R520 VR.n173 VR.n492 1e-3
R521 VR.n176 VR.n489 1e-3
R522 VR.n307 VR.n376 1e-3
R523 VR.n98 VR.n463 1e-3
R524 VR.n104 VR.n409 1e-3
R525 VR.n107 VR.n405 1e-3
R526 VR.n110 VR.n415 1e-3
R527 VR.n113 VR.n424 1e-3
R528 VR.n116 VR.n420 1e-3
R529 VR.n125 VR.n434 1e-3
R530 VR.n128 VR.n430 1e-3
R531 VR.n179 VR.n620 1e-3
R532 VR.n182 VR.n616 1e-3
R533 VR.n188 VR.n641 1e-3
R534 VR.n191 VR.n637 1e-3
R535 VR.n540 VR.n139 1e-3
R536 VR.n537 VR.n142 1e-3
R537 VR.n10 VR.n9 1e-3
R538 VR.n258 VR.n51 1e-3
R539 VR.n524 VR.n151 1e-3
R540 VR.n521 VR.n154 1e-3
R541 VR.n8 VR.n7 1e-3
R542 VR.n260 VR.n52 1e-3
R543 VR.n508 VR.n163 1e-3
R544 VR.n505 VR.n166 1e-3
R545 VR.n6 VR.n5 1e-3
R546 VR.n262 VR.n53 1e-3
R547 VR.n492 VR.n175 1e-3
R548 VR.n489 VR.n178 1e-3
R549 VR.n4 VR.n3 1e-3
R550 VR.n264 VR.n54 1e-3
R551 VR.n463 VR.n100 1e-3
R552 VR.n409 VR.n106 1e-3
R553 VR.n405 VR.n109 1e-3
R554 VR.n415 VR.n112 1e-3
R555 VR.n424 VR.n115 1e-3
R556 VR.n420 VR.n118 1e-3
R557 VR.n434 VR.n127 1e-3
R558 VR.n430 VR.n130 1e-3
R559 VR.n34 VR.n33 1e-3
R560 VR.n32 VR.n31 1e-3
R561 VR.n30 VR.n29 1e-3
R562 VR.n28 VR.n27 1e-3
R563 VR.n26 VR.n25 1e-3
R564 VR.n24 VR.n23 1e-3
R565 VR.n22 VR.n21 1e-3
R566 VR.n20 VR.n19 1e-3
R567 VR.n18 VR.n17 1e-3
R568 VR.n16 VR.n15 1e-3
R569 VR.n14 VR.n13 1e-3
R570 VR.n12 VR.n11 1e-3
R571 VR.n620 VR.n181 1e-3
R572 VR.n616 VR.n184 1e-3
R573 VR.n641 VR.n190 1e-3
R574 VR.n637 VR.n193 1e-3
R575 VR.n418 VR.n417 1e-3
R576 VR.n306 VR.n472 1e-3
R577 VR.n479 VR.n478 1e-3
R578 VR.n486 VR.n485 1e-3
R579 VR.n308 VR.n600 1e-3
R580 VR.n307 VR.n391 1e-3
R581 VR.n361 VR.n325 1e-3
R582 VR.n354 VR.n344 1e-3
R583 VR.n588 VR.n354 1e-3
R584 VR.n395 VR.t188 1e-3
R585 VR.n450 VR.t138 1e-3
R586 VR.n439 VR.t33 1e-3
R587 VR.n548 VR.t267 1e-3
R588 VR.n544 VR.t21 1e-3
R589 VR.n532 VR.t76 1e-3
R590 VR.n528 VR.t278 1e-3
R591 VR.n516 VR.t133 1e-3
R592 VR.n512 VR.t311 1e-3
R593 VR.n500 VR.t174 1e-3
R594 VR.n496 VR.t218 1e-3
R595 VR.n626 VR.t318 1e-3
R596 VR.n647 VR.t244 1e-3
R597 VR.n460 VR.n428 1e-3
R598 VR.n459 VR.n448 1e-3
R599 VR.n656 VR.n645 1e-3
R600 VR.n645 VR.n635 1e-3
R601 VR.n635 VR.n624 1e-3
R602 VR.n418 VR.n413 1e-3
R603 VR.n479 VR.n306 1e-3
R604 VR.n565 VR.n558 1e-3
R605 VR.n486 VR.n479 1e-3
R606 VR.n350 VR.t105 1e-3
R607 VR.n346 VR.t69 1e-3
R608 VR.n340 VR.t148 1e-3
R609 VR.n336 VR.t145 1e-3
R610 VR.n331 VR.t195 1e-3
R611 VR.n327 VR.t169 1e-3
R612 VR.n583 VR.t327 1e-3
R613 VR.n580 VR.t135 1e-3
R614 VR.n308 VR.n613 1e-3
R615 VR.n428 VR.n418 1e-3
R616 VR.n246 VR.n70 1e-3
R617 VR.n466 VR.n465 1e-3
R618 VR.n460 VR.n459 1e-3
R619 VR.n201 VR.n348 1e-3
R620 VR.n202 VR.n338 1e-3
R621 VR.n203 VR.n329 1e-3
R622 VR.n204 VR.n582 1e-3
R623 VR.n403 VR.n397 1e-3
R624 VR.n412 VR.n407 1e-3
R625 VR.n427 VR.n422 1e-3
R626 VR.n458 VR.n452 1e-3
R627 VR.n447 VR.n441 1e-3
R628 VR.n437 VR.n432 1e-3
R629 VR.n623 VR.n618 1e-3
R630 VR.n634 VR.n628 1e-3
R631 VR.n644 VR.n639 1e-3
R632 VR.n655 VR.n649 1e-3
R633 VR.n635 VR.n634 1e-3
R634 VR.n656 VR.n655 1e-3
R635 VR.n413 VR.n412 1e-3
R636 VR.n428 VR.n427 1e-3
R637 VR.n624 VR.n623 1e-3
R638 VR.n645 VR.n644 1e-3
R639 VR.n393 VR.n361 1e-3
R640 VR.n74 VR.n350 1e-3
R641 VR.n77 VR.n346 1e-3
R642 VR.n80 VR.n340 1e-3
R643 VR.n83 VR.n336 1e-3
R644 VR.n86 VR.n331 1e-3
R645 VR.n89 VR.n327 1e-3
R646 VR.n92 VR.n583 1e-3
R647 VR.n95 VR.n580 1e-3
R648 VR.n101 VR.n395 1e-3
R649 VR.n119 VR.n450 1e-3
R650 VR.n122 VR.n439 1e-3
R651 VR.n131 VR.n548 1e-3
R652 VR.n134 VR.n544 1e-3
R653 VR.n143 VR.n532 1e-3
R654 VR.n146 VR.n528 1e-3
R655 VR.n155 VR.n516 1e-3
R656 VR.n158 VR.n512 1e-3
R657 VR.n167 VR.n500 1e-3
R658 VR.n170 VR.n496 1e-3
R659 VR.n185 VR.n626 1e-3
R660 VR.n194 VR.n647 1e-3
R661 VR.n350 VR.n76 1e-3
R662 VR.n346 VR.n79 1e-3
R663 VR.n340 VR.n82 1e-3
R664 VR.n336 VR.n85 1e-3
R665 VR.n331 VR.n88 1e-3
R666 VR.n327 VR.n91 1e-3
R667 VR.n583 VR.n94 1e-3
R668 VR.n580 VR.n97 1e-3
R669 VR.n395 VR.n103 1e-3
R670 VR.n450 VR.n121 1e-3
R671 VR.n439 VR.n124 1e-3
R672 VR.n548 VR.n133 1e-3
R673 VR.n544 VR.n136 1e-3
R674 VR.n532 VR.n145 1e-3
R675 VR.n528 VR.n148 1e-3
R676 VR.n516 VR.n157 1e-3
R677 VR.n512 VR.n160 1e-3
R678 VR.n500 VR.n169 1e-3
R679 VR.n496 VR.n172 1e-3
R680 VR.n626 VR.n187 1e-3
R681 VR.n647 VR.n196 1e-3
R682 VR.n247 VR.n542 1e-3
R683 VR.n57 VR.n539 1e-3
R684 VR.n1 VR.n526 1e-3
R685 VR.n1 VR.n523 1e-3
R686 VR.n0 VR.n510 1e-3
R687 VR.n0 VR.n507 1e-3
R688 VR.n2 VR.n494 1e-3
R689 VR.n246 VR.n491 1e-3
R690 VR.n57 VR.n58 1e-3
R691 VR.n1 VR.n62 1e-3
R692 VR.n0 VR.n66 1e-3
R693 VR.n201 VR.n352 1e-3
R694 VR.n202 VR.n342 1e-3
R695 VR.n203 VR.n333 1e-3
R696 VR.n204 VR.n585 1e-3
R697 VR.n403 VR.n402 1e-3
R698 VR.n412 VR.n411 1e-3
R699 VR.n427 VR.n426 1e-3
R700 VR.n458 VR.n457 1e-3
R701 VR.n447 VR.n446 1e-3
R702 VR.n437 VR.n436 1e-3
R703 VR.n247 VR.n550 1e-3
R704 VR.n247 VR.n546 1e-3
R705 VR.n1 VR.n534 1e-3
R706 VR.n1 VR.n530 1e-3
R707 VR.n0 VR.n518 1e-3
R708 VR.n0 VR.n514 1e-3
R709 VR.n2 VR.n502 1e-3
R710 VR.n2 VR.n498 1e-3
R711 VR.n623 VR.n622 1e-3
R712 VR.n634 VR.n633 1e-3
R713 VR.n644 VR.n643 1e-3
R714 VR.n655 VR.n654 1e-3
R715 VR.n624 VR.n614 1e-3
R716 VR.n58 VR.n258 1e-3
R717 VR.n58 VR.n9 1e-3
R718 VR.n62 VR.n260 1e-3
R719 VR.n62 VR.n7 1e-3
R720 VR.n66 VR.n262 1e-3
R721 VR.n66 VR.n5 1e-3
R722 VR.n70 VR.n264 1e-3
R723 VR.n70 VR.n3 1e-3
R724 VR.n587 VR.n586 1e-3
R725 VR.n309 VR.n310 1e-3
R726 VR.n311 VR.n312 1e-3
R727 VR.n313 VR.n314 1e-3
R728 VR.n315 VR.n316 1e-3
R729 VR.n317 VR.n318 1e-3
R730 VR.n319 VR.n320 1e-3
R731 VR.n321 VR.n322 1e-3
R732 VR.n323 VR.n324 1e-3
R733 VR.n579 VR.n565 1e-3
R734 VR.n60 VR.n61 1e-3
R735 VR.n60 VR.n59 1e-3
R736 VR.n64 VR.n65 1e-3
R737 VR.n64 VR.n63 1e-3
R738 VR.n68 VR.n69 1e-3
R739 VR.n68 VR.n67 1e-3
R740 VR.n72 VR.n73 1e-3
R741 VR.n72 VR.n71 1e-3
R742 VR.n384 VR.n383 1e-3
R743 VR.n369 VR.n368 1e-3
R744 VR.n47 VR.n48 1e-3
R745 VR.n49 VR.n50 1e-3
R746 VR.n35 VR.n36 1e-3
R747 VR.n37 VR.n38 1e-3
R748 VR.n39 VR.n40 1e-3
R749 VR.n41 VR.n42 1e-3
R750 VR.n43 VR.n44 1e-3
R751 VR.n45 VR.n46 1e-3
R752 VR.n352 VR.n74 1e-3
R753 VR.n352 VR.n76 1e-3
R754 VR.n348 VR.n77 1e-3
R755 VR.n348 VR.n79 1e-3
R756 VR.n342 VR.n80 1e-3
R757 VR.n342 VR.n82 1e-3
R758 VR.n338 VR.n83 1e-3
R759 VR.n338 VR.n85 1e-3
R760 VR.n333 VR.n86 1e-3
R761 VR.n333 VR.n88 1e-3
R762 VR.n329 VR.n89 1e-3
R763 VR.n329 VR.n91 1e-3
R764 VR.n585 VR.n92 1e-3
R765 VR.n585 VR.n94 1e-3
R766 VR.n582 VR.n95 1e-3
R767 VR.n582 VR.n97 1e-3
R768 VR.n614 VR.n588 1e-3
R769 VR.n383 VR.n382 1e-3
R770 VR.n368 VR.n367 1e-3
R771 VR.n351 VR.n74 1e-3
R772 VR.n351 VR.n76 1e-3
R773 VR.n347 VR.n77 1e-3
R774 VR.n347 VR.n79 1e-3
R775 VR.n341 VR.n80 1e-3
R776 VR.n341 VR.n82 1e-3
R777 VR.n337 VR.n83 1e-3
R778 VR.n337 VR.n85 1e-3
R779 VR.n332 VR.n86 1e-3
R780 VR.n332 VR.n88 1e-3
R781 VR.n328 VR.n89 1e-3
R782 VR.n328 VR.n91 1e-3
R783 VR.n584 VR.n92 1e-3
R784 VR.n584 VR.n94 1e-3
R785 VR.n581 VR.n95 1e-3
R786 VR.n581 VR.n97 1e-3
R787 VR.n360 VR.n250 1e-3
R788 VR.n360 VR.n33 1e-3
R789 VR.n472 VR.n252 1e-3
R790 VR.n472 VR.n31 1e-3
R791 VR.n478 VR.n254 1e-3
R792 VR.n478 VR.n29 1e-3
R793 VR.n485 VR.n256 1e-3
R794 VR.n485 VR.n27 1e-3
R795 VR.n557 VR.n266 1e-3
R796 VR.n557 VR.n25 1e-3
R797 VR.n564 VR.n268 1e-3
R798 VR.n564 VR.n23 1e-3
R799 VR.n577 VR.n270 1e-3
R800 VR.n577 VR.n21 1e-3
R801 VR.n571 VR.n272 1e-3
R802 VR.n571 VR.n19 1e-3
R803 VR.n594 VR.n274 1e-3
R804 VR.n594 VR.n17 1e-3
R805 VR.n600 VR.n276 1e-3
R806 VR.n600 VR.n15 1e-3
R807 VR.n612 VR.n278 1e-3
R808 VR.n612 VR.n13 1e-3
R809 VR.n606 VR.n280 1e-3
R810 VR.n606 VR.n11 1e-3
R811 VR.n352 VR.n349 1e-3
R812 VR.n348 VR.n345 1e-3
R813 VR.n342 VR.n339 1e-3
R814 VR.n338 VR.n335 1e-3
R815 VR.n333 VR.n330 1e-3
R816 VR.n329 VR.n326 1e-3
R817 VR.n585 VR.t326 1e-3
R818 VR.n582 VR.t134 1e-3
R819 VR.n465 VR.n282 1e-3
R820 VR.n294 VR.n464 1e-3
R821 VR.n402 VR.n205 1e-3
R822 VR.n224 VR.n223 1e-3
R823 VR.n397 VR.n206 1e-3
R824 VR.n225 VR.n396 1e-3
R825 VR.n411 VR.n283 1e-3
R826 VR.n295 VR.n410 1e-3
R827 VR.n407 VR.n284 1e-3
R828 VR.n296 VR.n406 1e-3
R829 VR.n417 VR.n285 1e-3
R830 VR.n297 VR.n416 1e-3
R831 VR.n426 VR.n286 1e-3
R832 VR.n298 VR.n425 1e-3
R833 VR.n422 VR.n287 1e-3
R834 VR.n299 VR.n421 1e-3
R835 VR.n457 VR.n207 1e-3
R836 VR.n227 VR.n226 1e-3
R837 VR.n452 VR.n208 1e-3
R838 VR.n228 VR.n451 1e-3
R839 VR.n446 VR.n209 1e-3
R840 VR.n230 VR.n229 1e-3
R841 VR.n441 VR.n210 1e-3
R842 VR.n231 VR.n440 1e-3
R843 VR.n436 VR.n288 1e-3
R844 VR.n300 VR.n435 1e-3
R845 VR.n432 VR.n289 1e-3
R846 VR.n301 VR.n431 1e-3
R847 VR.n550 VR.n211 1e-3
R848 VR.n232 VR.n549 1e-3
R849 VR.n546 VR.n212 1e-3
R850 VR.n233 VR.n545 1e-3
R851 VR.n534 VR.n213 1e-3
R852 VR.n234 VR.n533 1e-3
R853 VR.n530 VR.n214 1e-3
R854 VR.n235 VR.n529 1e-3
R855 VR.n518 VR.n215 1e-3
R856 VR.n236 VR.n517 1e-3
R857 VR.n514 VR.n216 1e-3
R858 VR.n237 VR.n513 1e-3
R859 VR.n502 VR.n217 1e-3
R860 VR.n238 VR.n501 1e-3
R861 VR.n498 VR.n218 1e-3
R862 VR.n239 VR.n497 1e-3
R863 VR.n622 VR.n290 1e-3
R864 VR.n302 VR.n621 1e-3
R865 VR.n618 VR.n291 1e-3
R866 VR.n303 VR.n617 1e-3
R867 VR.n633 VR.n219 1e-3
R868 VR.n241 VR.n240 1e-3
R869 VR.n628 VR.n220 1e-3
R870 VR.n242 VR.n627 1e-3
R871 VR.n643 VR.n292 1e-3
R872 VR.n304 VR.n642 1e-3
R873 VR.n639 VR.n293 1e-3
R874 VR.n305 VR.n638 1e-3
R875 VR.n654 VR.n221 1e-3
R876 VR.n244 VR.n243 1e-3
R877 VR.n649 VR.n222 1e-3
R878 VR.n245 VR.n648 1e-3
R879 VR.n293 VR.t198 1e-3
R880 VR.n292 VR.t8 1e-3
R881 VR.n291 VR.t313 1e-3
R882 VR.n290 VR.t245 1e-3
R883 VR.n289 VR.t36 1e-3
R884 VR.n288 VR.t30 1e-3
R885 VR.n287 VR.t46 1e-3
R886 VR.n286 VR.t91 1e-3
R887 VR.n285 VR.t25 1e-3
R888 VR.n284 VR.t3 1e-3
R889 VR.n283 VR.t296 1e-3
R890 VR.n282 VR.t57 1e-3
R891 VR.n305 VR.t198 1e-3
R892 VR.n304 VR.t8 1e-3
R893 VR.n303 VR.t313 1e-3
R894 VR.n302 VR.t245 1e-3
R895 VR.n301 VR.t36 1e-3
R896 VR.n300 VR.t30 1e-3
R897 VR.n299 VR.t46 1e-3
R898 VR.n298 VR.t91 1e-3
R899 VR.n297 VR.t25 1e-3
R900 VR.n296 VR.t3 1e-3
R901 VR.n295 VR.t296 1e-3
R902 VR.n294 VR.t57 1e-3
R903 VR.n222 VR.t243 1e-3
R904 VR.n221 VR.t7 1e-3
R905 VR.n220 VR.t317 1e-3
R906 VR.n219 VR.t247 1e-3
R907 VR.n218 VR.t217 1e-3
R908 VR.n217 VR.t173 1e-3
R909 VR.n216 VR.t310 1e-3
R910 VR.n215 VR.t132 1e-3
R911 VR.n214 VR.t277 1e-3
R912 VR.n213 VR.t75 1e-3
R913 VR.n212 VR.t20 1e-3
R914 VR.n211 VR.t266 1e-3
R915 VR.n210 VR.t32 1e-3
R916 VR.n209 VR.t29 1e-3
R917 VR.n208 VR.t137 1e-3
R918 VR.n207 VR.t289 1e-3
R919 VR.n206 VR.t187 1e-3
R920 VR.n205 VR.t295 1e-3
R921 VR.n245 VR.t243 1e-3
R922 VR.n244 VR.t7 1e-3
R923 VR.n242 VR.t317 1e-3
R924 VR.n241 VR.t247 1e-3
R925 VR.n239 VR.t217 1e-3
R926 VR.n238 VR.t173 1e-3
R927 VR.n237 VR.t310 1e-3
R928 VR.n236 VR.t132 1e-3
R929 VR.n235 VR.t277 1e-3
R930 VR.n234 VR.t75 1e-3
R931 VR.n233 VR.t20 1e-3
R932 VR.n232 VR.t266 1e-3
R933 VR.n231 VR.t32 1e-3
R934 VR.n230 VR.t29 1e-3
R935 VR.n228 VR.t137 1e-3
R936 VR.n227 VR.t289 1e-3
R937 VR.n225 VR.t187 1e-3
R938 VR.n224 VR.t295 1e-3
R939 VR.n579 VR.n578 1e-3
R940 VR.n323 VR.n490 1e-3
R941 VR.n321 VR.n493 1e-3
R942 VR.n319 VR.n506 1e-3
R943 VR.n317 VR.n509 1e-3
R944 VR.n315 VR.n522 1e-3
R945 VR.n313 VR.n525 1e-3
R946 VR.n311 VR.n538 1e-3
R947 VR.n309 VR.n541 1e-3
R948 VR.n356 VR.n250 1e-3
R949 VR.n356 VR.n33 1e-3
R950 VR.n468 VR.n252 1e-3
R951 VR.n468 VR.n31 1e-3
R952 VR.n474 VR.n254 1e-3
R953 VR.n474 VR.n29 1e-3
R954 VR.n481 VR.n256 1e-3
R955 VR.n481 VR.n27 1e-3
R956 VR.n553 VR.n266 1e-3
R957 VR.n553 VR.n25 1e-3
R958 VR.n560 VR.n268 1e-3
R959 VR.n560 VR.n23 1e-3
R960 VR.n573 VR.n270 1e-3
R961 VR.n573 VR.n21 1e-3
R962 VR.n567 VR.n272 1e-3
R963 VR.n567 VR.n19 1e-3
R964 VR.n590 VR.n274 1e-3
R965 VR.n590 VR.n17 1e-3
R966 VR.n596 VR.n276 1e-3
R967 VR.n596 VR.n15 1e-3
R968 VR.n608 VR.n278 1e-3
R969 VR.n608 VR.n13 1e-3
R970 VR.n602 VR.n280 1e-3
R971 VR.n602 VR.n11 1e-3
R972 VR.n402 VR.n398 1e-3
R973 VR.n402 VR.n401 1e-3
R974 VR.n397 VR.n101 1e-3
R975 VR.n397 VR.n103 1e-3
R976 VR.n457 VR.n453 1e-3
R977 VR.n457 VR.n456 1e-3
R978 VR.n452 VR.n119 1e-3
R979 VR.n452 VR.n121 1e-3
R980 VR.n446 VR.n442 1e-3
R981 VR.n446 VR.n445 1e-3
R982 VR.n441 VR.n122 1e-3
R983 VR.n441 VR.n124 1e-3
R984 VR.n550 VR.n131 1e-3
R985 VR.n550 VR.n133 1e-3
R986 VR.n546 VR.n134 1e-3
R987 VR.n546 VR.n136 1e-3
R988 VR.n534 VR.n143 1e-3
R989 VR.n534 VR.n145 1e-3
R990 VR.n530 VR.n146 1e-3
R991 VR.n530 VR.n148 1e-3
R992 VR.n518 VR.n155 1e-3
R993 VR.n518 VR.n157 1e-3
R994 VR.n514 VR.n158 1e-3
R995 VR.n514 VR.n160 1e-3
R996 VR.n502 VR.n167 1e-3
R997 VR.n502 VR.n169 1e-3
R998 VR.n498 VR.n170 1e-3
R999 VR.n498 VR.n172 1e-3
R1000 VR.n633 VR.n629 1e-3
R1001 VR.n633 VR.n632 1e-3
R1002 VR.n628 VR.n185 1e-3
R1003 VR.n628 VR.n187 1e-3
R1004 VR.n654 VR.n650 1e-3
R1005 VR.n654 VR.n653 1e-3
R1006 VR.n649 VR.n194 1e-3
R1007 VR.n649 VR.n196 1e-3
R1008 VR.n223 VR.n398 1e-3
R1009 VR.n401 VR.n223 1e-3
R1010 VR.n226 VR.n453 1e-3
R1011 VR.n456 VR.n226 1e-3
R1012 VR.n229 VR.n442 1e-3
R1013 VR.n445 VR.n229 1e-3
R1014 VR.n240 VR.n629 1e-3
R1015 VR.n632 VR.n240 1e-3
R1016 VR.n243 VR.n650 1e-3
R1017 VR.n653 VR.n243 1e-3
R1018 VR.n542 VR.t256 1e-3
R1019 VR.n539 VR.t18 1e-3
R1020 VR.n526 VR.t73 1e-3
R1021 VR.n523 VR.t279 1e-3
R1022 VR.n510 VR.t130 1e-3
R1023 VR.n507 VR.t300 1e-3
R1024 VR.n494 VR.t175 1e-3
R1025 VR.n491 VR.t219 1e-3
R1026 VR.n324 VR.t219 1e-3
R1027 VR.n322 VR.t175 1e-3
R1028 VR.n320 VR.t300 1e-3
R1029 VR.n318 VR.t130 1e-3
R1030 VR.n316 VR.t279 1e-3
R1031 VR.n314 VR.t73 1e-3
R1032 VR.n312 VR.t18 1e-3
R1033 VR.n310 VR.t256 1e-3
R1034 VR.n542 VR.n137 1e-3
R1035 VR.n542 VR.n139 1e-3
R1036 VR.n539 VR.n140 1e-3
R1037 VR.n539 VR.n142 1e-3
R1038 VR.n526 VR.n149 1e-3
R1039 VR.n526 VR.n151 1e-3
R1040 VR.n523 VR.n152 1e-3
R1041 VR.n523 VR.n154 1e-3
R1042 VR.n510 VR.n161 1e-3
R1043 VR.n510 VR.n163 1e-3
R1044 VR.n507 VR.n164 1e-3
R1045 VR.n507 VR.n166 1e-3
R1046 VR.n494 VR.n173 1e-3
R1047 VR.n494 VR.n175 1e-3
R1048 VR.n491 VR.n176 1e-3
R1049 VR.n491 VR.n178 1e-3
R1050 VR.n490 VR.n176 1e-3
R1051 VR.n493 VR.n173 1e-3
R1052 VR.n506 VR.n164 1e-3
R1053 VR.n509 VR.n161 1e-3
R1054 VR.n522 VR.n152 1e-3
R1055 VR.n525 VR.n149 1e-3
R1056 VR.n538 VR.n140 1e-3
R1057 VR.n541 VR.n137 1e-3
R1058 VR.n465 VR.n98 1e-3
R1059 VR.n465 VR.n100 1e-3
R1060 VR.n411 VR.n104 1e-3
R1061 VR.n411 VR.n106 1e-3
R1062 VR.n407 VR.n107 1e-3
R1063 VR.n407 VR.n109 1e-3
R1064 VR.n417 VR.n110 1e-3
R1065 VR.n417 VR.n112 1e-3
R1066 VR.n426 VR.n113 1e-3
R1067 VR.n426 VR.n115 1e-3
R1068 VR.n422 VR.n116 1e-3
R1069 VR.n422 VR.n118 1e-3
R1070 VR.n436 VR.n125 1e-3
R1071 VR.n436 VR.n127 1e-3
R1072 VR.n432 VR.n128 1e-3
R1073 VR.n432 VR.n130 1e-3
R1074 VR.n622 VR.n179 1e-3
R1075 VR.n622 VR.n181 1e-3
R1076 VR.n618 VR.n182 1e-3
R1077 VR.n618 VR.n184 1e-3
R1078 VR.n643 VR.n188 1e-3
R1079 VR.n643 VR.n190 1e-3
R1080 VR.n639 VR.n191 1e-3
R1081 VR.n639 VR.n193 1e-3
R1082 VR.n391 VR.n390 1e-3
R1083 VR.n376 VR.n375 1e-3
R1084 VR.n193 VR.n192 1e-3
R1085 VR.n636 VR.n191 1e-3
R1086 VR.n190 VR.n189 1e-3
R1087 VR.n640 VR.n188 1e-3
R1088 VR.n184 VR.n183 1e-3
R1089 VR.n615 VR.n182 1e-3
R1090 VR.n181 VR.n180 1e-3
R1091 VR.n619 VR.n179 1e-3
R1092 VR.n178 VR.n177 1e-3
R1093 VR.n175 VR.n174 1e-3
R1094 VR.n166 VR.n165 1e-3
R1095 VR.n163 VR.n162 1e-3
R1096 VR.n154 VR.n153 1e-3
R1097 VR.n151 VR.n150 1e-3
R1098 VR.n142 VR.n141 1e-3
R1099 VR.n139 VR.n138 1e-3
R1100 VR.n130 VR.n129 1e-3
R1101 VR.n429 VR.n128 1e-3
R1102 VR.n127 VR.n126 1e-3
R1103 VR.n433 VR.n125 1e-3
R1104 VR.n118 VR.n117 1e-3
R1105 VR.n419 VR.n116 1e-3
R1106 VR.n115 VR.n114 1e-3
R1107 VR.n423 VR.n113 1e-3
R1108 VR.n112 VR.n111 1e-3
R1109 VR.n414 VR.n110 1e-3
R1110 VR.n109 VR.n108 1e-3
R1111 VR.n404 VR.n107 1e-3
R1112 VR.n106 VR.n105 1e-3
R1113 VR.n408 VR.n104 1e-3
R1114 VR.n100 VR.n99 1e-3
R1115 VR.n462 VR.n98 1e-3
R1116 VR.n466 VR.n461 1e-3
R1117 VR.n396 VR.n101 1e-3
R1118 VR.n396 VR.n103 1e-3
R1119 VR.n451 VR.n119 1e-3
R1120 VR.n451 VR.n121 1e-3
R1121 VR.n440 VR.n122 1e-3
R1122 VR.n440 VR.n124 1e-3
R1123 VR.n549 VR.n131 1e-3
R1124 VR.n549 VR.n133 1e-3
R1125 VR.n545 VR.n134 1e-3
R1126 VR.n545 VR.n136 1e-3
R1127 VR.n533 VR.n143 1e-3
R1128 VR.n533 VR.n145 1e-3
R1129 VR.n529 VR.n146 1e-3
R1130 VR.n529 VR.n148 1e-3
R1131 VR.n517 VR.n155 1e-3
R1132 VR.n517 VR.n157 1e-3
R1133 VR.n513 VR.n158 1e-3
R1134 VR.n513 VR.n160 1e-3
R1135 VR.n501 VR.n167 1e-3
R1136 VR.n501 VR.n169 1e-3
R1137 VR.n497 VR.n170 1e-3
R1138 VR.n497 VR.n172 1e-3
R1139 VR.n627 VR.n185 1e-3
R1140 VR.n627 VR.n187 1e-3
R1141 VR.n648 VR.n194 1e-3
R1142 VR.n648 VR.n196 1e-3
R1143 VR.n199 VR.n198 1e-3
R1144 VR.n56 VR.n55 1e-3
R1145 VR.n588 VR.n587 1e-3
R1146 VR.n461 VR.n460 1e-3
R1147 VR.n248 VR.n197 1e-3
R1148 VR.n196 VR.n195 1e-3
R1149 VR.n646 VR.n194 1e-3
R1150 VR.n187 VR.n186 1e-3
R1151 VR.n625 VR.n185 1e-3
R1152 VR.n172 VR.n171 1e-3
R1153 VR.n495 VR.n170 1e-3
R1154 VR.n169 VR.n168 1e-3
R1155 VR.n499 VR.n167 1e-3
R1156 VR.n160 VR.n159 1e-3
R1157 VR.n511 VR.n158 1e-3
R1158 VR.n157 VR.n156 1e-3
R1159 VR.n515 VR.n155 1e-3
R1160 VR.n148 VR.n147 1e-3
R1161 VR.n527 VR.n146 1e-3
R1162 VR.n145 VR.n144 1e-3
R1163 VR.n531 VR.n143 1e-3
R1164 VR.n136 VR.n135 1e-3
R1165 VR.n543 VR.n134 1e-3
R1166 VR.n133 VR.n132 1e-3
R1167 VR.n547 VR.n131 1e-3
R1168 VR.n124 VR.n123 1e-3
R1169 VR.n438 VR.n122 1e-3
R1170 VR.n121 VR.n120 1e-3
R1171 VR.n449 VR.n119 1e-3
R1172 VR.n103 VR.n102 1e-3
R1173 VR.n394 VR.n101 1e-3
R1174 VR.n11 VR.n281 1e-3
R1175 VR.n604 VR.n280 1e-3
R1176 VR.n13 VR.n279 1e-3
R1177 VR.n610 VR.n278 1e-3
R1178 VR.n15 VR.n277 1e-3
R1179 VR.n598 VR.n276 1e-3
R1180 VR.n17 VR.n275 1e-3
R1181 VR.n592 VR.n274 1e-3
R1182 VR.n19 VR.n273 1e-3
R1183 VR.n569 VR.n272 1e-3
R1184 VR.n21 VR.n271 1e-3
R1185 VR.n575 VR.n270 1e-3
R1186 VR.n23 VR.n269 1e-3
R1187 VR.n562 VR.n268 1e-3
R1188 VR.n25 VR.n267 1e-3
R1189 VR.n555 VR.n266 1e-3
R1190 VR.n3 VR.n71 1e-3
R1191 VR.n73 VR.n264 1e-3
R1192 VR.n5 VR.n67 1e-3
R1193 VR.n69 VR.n262 1e-3
R1194 VR.n7 VR.n63 1e-3
R1195 VR.n65 VR.n260 1e-3
R1196 VR.n9 VR.n59 1e-3
R1197 VR.n61 VR.n258 1e-3
R1198 VR.n27 VR.n257 1e-3
R1199 VR.n483 VR.n256 1e-3
R1200 VR.n29 VR.n255 1e-3
R1201 VR.n476 VR.n254 1e-3
R1202 VR.n31 VR.n253 1e-3
R1203 VR.n470 VR.n252 1e-3
R1204 VR.n33 VR.n251 1e-3
R1205 VR.n358 VR.n250 1e-3
R1206 VR.n386 VR.n385 1e-3
R1207 VR.n387 VR.n386 1e-3
R1208 VR.n388 VR.n387 1e-3
R1209 VR.n389 VR.n388 1e-3
R1210 VR.n390 VR.n389 1e-3
R1211 VR.n382 VR.n381 1e-3
R1212 VR.n381 VR.n380 1e-3
R1213 VR.n380 VR.n379 1e-3
R1214 VR.n379 VR.n378 1e-3
R1215 VR.n378 VR.n377 1e-3
R1216 VR.n371 VR.n370 1e-3
R1217 VR.n372 VR.n371 1e-3
R1218 VR.n373 VR.n372 1e-3
R1219 VR.n374 VR.n373 1e-3
R1220 VR.n375 VR.n374 1e-3
R1221 VR.n367 VR.n366 1e-3
R1222 VR.n366 VR.n365 1e-3
R1223 VR.n365 VR.n364 1e-3
R1224 VR.n364 VR.n363 1e-3
R1225 VR.n363 VR.n362 1e-3
R1226 VR.n247 VR.n57 1e-3
R1227 VR.n541 VR.n139 1e-3
R1228 VR.n538 VR.n142 1e-3
R1229 VR.n525 VR.n151 1e-3
R1230 VR.n522 VR.n154 1e-3
R1231 VR.n509 VR.n163 1e-3
R1232 VR.n506 VR.n166 1e-3
R1233 VR.n493 VR.n175 1e-3
R1234 VR.n490 VR.n178 1e-3
R1235 VR.n464 VR.n98 1e-3
R1236 VR.n464 VR.n100 1e-3
R1237 VR.n410 VR.n104 1e-3
R1238 VR.n410 VR.n106 1e-3
R1239 VR.n406 VR.n107 1e-3
R1240 VR.n406 VR.n109 1e-3
R1241 VR.n416 VR.n110 1e-3
R1242 VR.n416 VR.n112 1e-3
R1243 VR.n425 VR.n113 1e-3
R1244 VR.n425 VR.n115 1e-3
R1245 VR.n421 VR.n116 1e-3
R1246 VR.n421 VR.n118 1e-3
R1247 VR.n435 VR.n125 1e-3
R1248 VR.n435 VR.n127 1e-3
R1249 VR.n431 VR.n128 1e-3
R1250 VR.n431 VR.n130 1e-3
R1251 VR.n621 VR.n179 1e-3
R1252 VR.n621 VR.n181 1e-3
R1253 VR.n617 VR.n182 1e-3
R1254 VR.n617 VR.n184 1e-3
R1255 VR.n642 VR.n188 1e-3
R1256 VR.n642 VR.n190 1e-3
R1257 VR.n638 VR.n191 1e-3
R1258 VR.n638 VR.n193 1e-3
R1259 VR.n359 VR.n355 1e-3
R1260 VR.n360 VR.n355 1e-3
R1261 VR.n359 VR.n357 1e-3
R1262 VR.n357 VR.n356 1e-3
R1263 VR.n471 VR.n467 1e-3
R1264 VR.n472 VR.n467 1e-3
R1265 VR.n471 VR.n469 1e-3
R1266 VR.n469 VR.n468 1e-3
R1267 VR.n477 VR.n473 1e-3
R1268 VR.n478 VR.n473 1e-3
R1269 VR.n477 VR.n475 1e-3
R1270 VR.n475 VR.n474 1e-3
R1271 VR.n484 VR.n480 1e-3
R1272 VR.n485 VR.n480 1e-3
R1273 VR.n484 VR.n482 1e-3
R1274 VR.n482 VR.n481 1e-3
R1275 VR.n556 VR.n552 1e-3
R1276 VR.n557 VR.n552 1e-3
R1277 VR.n556 VR.n554 1e-3
R1278 VR.n554 VR.n553 1e-3
R1279 VR.n563 VR.n559 1e-3
R1280 VR.n564 VR.n559 1e-3
R1281 VR.n563 VR.n561 1e-3
R1282 VR.n561 VR.n560 1e-3
R1283 VR.n576 VR.n572 1e-3
R1284 VR.n577 VR.n572 1e-3
R1285 VR.n576 VR.n574 1e-3
R1286 VR.n574 VR.n573 1e-3
R1287 VR.n570 VR.n566 1e-3
R1288 VR.n571 VR.n566 1e-3
R1289 VR.n570 VR.n568 1e-3
R1290 VR.n568 VR.n567 1e-3
R1291 VR.n593 VR.n589 1e-3
R1292 VR.n594 VR.n589 1e-3
R1293 VR.n593 VR.n591 1e-3
R1294 VR.n591 VR.n590 1e-3
R1295 VR.n599 VR.n595 1e-3
R1296 VR.n600 VR.n595 1e-3
R1297 VR.n599 VR.n597 1e-3
R1298 VR.n597 VR.n596 1e-3
R1299 VR.n611 VR.n607 1e-3
R1300 VR.n612 VR.n607 1e-3
R1301 VR.n611 VR.n609 1e-3
R1302 VR.n609 VR.n608 1e-3
R1303 VR.n605 VR.n601 1e-3
R1304 VR.n606 VR.n601 1e-3
R1305 VR.n605 VR.n603 1e-3
R1306 VR.n603 VR.n602 1e-3
R1307 VR.t150 VR.t156 1e-3
R1308 VR.t43 VR.t41 1e-3
R1309 VR.t65 VR.t63 1e-3
R1310 VR.t98 VR.t35 1e-3
R1311 VR.t80 VR.t78 1e-3
R1312 VR.t286 VR.t284 1e-3
R1313 VR.t182 VR.t180 1e-3
R1314 VR.t224 VR.t222 1e-3
R1315 VR.t263 VR.t261 1e-3
R1316 VR.t15 VR.t13 1e-3
R1317 VR.t307 VR.t305 1e-3
R1318 VR.t127 VR.t125 1e-3
R1319 VR.t251 VR.t253 1e-3
R1320 VR.t322 VR.t320 1e-3
R1321 VR.t273 VR.t271 1e-3
R1322 VR.t240 VR.t238 1e-3
R1323 VR.t118 VR.t116 1e-3
R1324 VR.t162 VR.t160 1e-3
R1325 VR.t211 VR.t209 1e-3
R1326 VR.t232 VR.t230 1e-3
R1327 VR.n551 VR.n247 1e-3
R1328 VR.n586 VR.n204 1e-3
R1329 VR.n334 VR.n203 1e-3
R1330 VR.n343 VR.n202 1e-3
R1331 VR.n353 VR.n201 1e-3
R1332 VR.t329 VR.t328 1e-3
R1333 VR.n0 VR.n2 1e-3
R1334 VR.n393 VR.n392 1e-3
R1335 VR.n488 VR.n72 1e-3
R1336 VR.n488 VR.n70 1e-3
R1337 VR.n504 VR.n68 1e-3
R1338 VR.n504 VR.n66 1e-3
R1339 VR.n520 VR.n64 1e-3
R1340 VR.n520 VR.n62 1e-3
R1341 VR.n536 VR.n60 1e-3
R1342 VR.n536 VR.n58 1e-3
R1343 VR.n97 VR.n96 1e-3
R1344 VR.n94 VR.n93 1e-3
R1345 VR.n91 VR.n90 1e-3
R1346 VR.n88 VR.n87 1e-3
R1347 VR.n85 VR.n84 1e-3
R1348 VR.n82 VR.n81 1e-3
R1349 VR.n79 VR.n78 1e-3
R1350 VR.n76 VR.n75 1e-3
R1351 VR.n200 VR.n199 1e-3
R1352 VR.n391 VR.n384 1e-3
R1353 VR.n376 VR.n369 1e-3
R1354 VR.n249 VR.n200 1e-3
R1355 VR.n2 VR.n246 1e-3
R1356 VR.n399 VR.n398 1e-3
R1357 VR.n401 VR.n400 1e-3
R1358 VR.n454 VR.n453 1e-3
R1359 VR.n456 VR.n455 1e-3
R1360 VR.n443 VR.n442 1e-3
R1361 VR.n445 VR.n444 1e-3
R1362 VR.n630 VR.n629 1e-3
R1363 VR.n632 VR.n631 1e-3
R1364 VR.n651 VR.n650 1e-3
R1365 VR.n653 VR.n652 1e-3
R1366 VR.t325 VR.n353 1e-3
R1367 VR.t170 VR.n201 1e-3
R1368 VR.t104 VR.n349 1e-3
R1369 VR.t68 VR.n345 1e-3
R1370 VR.t70 VR.n343 1e-3
R1371 VR.t276 VR.n202 1e-3
R1372 VR.t147 VR.n339 1e-3
R1373 VR.t144 VR.n335 1e-3
R1374 VR.t22 VR.n334 1e-3
R1375 VR.t48 VR.n203 1e-3
R1376 VR.t194 VR.n330 1e-3
R1377 VR.t168 VR.n326 1e-3
R1378 VR.t103 VR.n586 1e-3
R1379 VR.t121 VR.n204 1e-3
R1380 VR.n198 VR.t202 1e-3
R1381 VR.n197 VR.t56 1e-3
R1382 VR.n55 VR.t111 1e-3
R1383 VR.n249 VR.t102 1e-3
R1384 VR.n249 VR.t299 1e-3
R1385 VR.n249 VR.t28 1e-3
R1386 VR.n200 VR.t27 1e-3
R1387 VR.n200 VR.t189 1e-3
R1388 VR.n200 VR.t101 1e-3
R1389 VR.n200 VR.t100 1e-3
R1390 VR.n199 VR.t205 1e-3
R1391 VR.n199 VR.t107 1e-3
R1392 VR.n199 VR.t106 1e-3
R1393 VR.n199 VR.t109 1e-3
R1394 VR.n198 VR.t88 1e-3
R1395 VR.n198 VR.t87 1e-3
R1396 VR.n198 VR.t99 1e-3
R1397 VR.n198 VR.t203 1e-3
R1398 VR.n248 VR.t49 1e-3
R1399 VR.n325 VR.t293 1e-3
R1400 VR.n248 VR.t50 1e-3
R1401 VR.n248 VR.t51 1e-3
R1402 VR.n197 VR.t52 1e-3
R1403 VR.n197 VR.t53 1e-3
R1404 VR.n197 VR.t54 1e-3
R1405 VR.n197 VR.t55 1e-3
R1406 VR.n325 VR.t190 1e-3
R1407 VR.n56 VR.t85 1e-3
R1408 VR.n56 VR.t84 1e-3
R1409 VR.n56 VR.t94 1e-3
R1410 VR.n56 VR.t1 1e-3
R1411 VR.n56 VR.t0 1e-3
R1412 VR.n56 VR.t204 1e-3
R1413 VR.n56 VR.t143 1e-3
R1414 VR.n56 VR.t142 1e-3
R1415 VR.n56 VR.t95 1e-3
R1416 VR.n55 VR.t93 1e-3
R1417 VR.n55 VR.t2 1e-3
R1418 VR.n55 VR.t112 1e-3
R1419 VR.n55 VR.t140 1e-3
R1420 VR.n51 VR.n10 1e-3
R1421 VR.n52 VR.n8 1e-3
R1422 VR.n53 VR.n6 1e-3
R1423 VR.n54 VR.n4 1e-3
R1424 VR.n57 VR.n1 1e-3
R1425 VR.n49 VR.n581 1e-3
R1426 VR.n47 VR.n584 1e-3
R1427 VR.n45 VR.n328 1e-3
R1428 VR.n43 VR.n332 1e-3
R1429 VR.n41 VR.n337 1e-3
R1430 VR.n39 VR.n341 1e-3
R1431 VR.n37 VR.n347 1e-3
R1432 VR.n35 VR.n351 1e-3
R1433 VR.n1 VR.n0 1e-3
R1434 VR.n50 VR.t134 1e-3
R1435 VR.n48 VR.t326 1e-3
R1436 VR.n325 VR.n56 1e-3
R1437 a_18109_11960.t2 a_18109_11960.n18 1e-3
R1438 a_18109_11960.t1 a_18109_11960.t2 1e-3
R1439 a_18109_11960.n18 a_18109_11960.n1 1e-3
R1440 a_18109_11960.n4 a_18109_11960.t10 1e-3
R1441 a_18109_11960.n6 a_18109_11960.t19 1e-3
R1442 a_18109_11960.n0 a_18109_11960.t23 1e-3
R1443 a_18109_11960.n2 a_18109_11960.t3 1e-3
R1444 a_18109_11960.n4 a_18109_11960.t22 1e-3
R1445 a_18109_11960.n5 a_18109_11960.t7 1e-3
R1446 a_18109_11960.n5 a_18109_11960.t16 1e-3
R1447 a_18109_11960.n5 a_18109_11960.t28 1e-3
R1448 a_18109_11960.n8 a_18109_11960.t6 1e-3
R1449 a_18109_11960.n14 a_18109_11960.t31 1e-3
R1450 a_18109_11960.n11 a_18109_11960.t13 1e-3
R1451 a_18109_11960.n11 a_18109_11960.t21 1e-3
R1452 a_18109_11960.n13 a_18109_11960.t34 1e-3
R1453 a_18109_11960.n12 a_18109_11960.t15 1e-3
R1454 a_18109_11960.n7 a_18109_11960.t5 1e-3
R1455 a_18109_11960.n7 a_18109_11960.t11 1e-3
R1456 a_18109_11960.n6 a_18109_11960.t4 1e-3
R1457 a_18109_11960.n6 a_18109_11960.t17 1e-3
R1458 a_18109_11960.n0 a_18109_11960.t29 1e-3
R1459 a_18109_11960.n1 a_18109_11960.t20 1e-3
R1460 a_18109_11960.n1 a_18109_11960.t26 1e-3
R1461 a_18109_11960.n1 a_18109_11960.t32 1e-3
R1462 a_18109_11960.n9 a_18109_11960.t30 1e-3
R1463 a_18109_11960.n17 a_18109_11960.t24 1e-3
R1464 a_18109_11960.n10 a_18109_11960.t27 1e-3
R1465 a_18109_11960.n10 a_18109_11960.t33 1e-3
R1466 a_18109_11960.n16 a_18109_11960.t18 1e-3
R1467 a_18109_11960.n15 a_18109_11960.t14 1e-3
R1468 a_18109_11960.n3 a_18109_11960.t8 1e-3
R1469 a_18109_11960.n3 a_18109_11960.t25 1e-3
R1470 a_18109_11960.n2 a_18109_11960.t9 1e-3
R1471 a_18109_11960.n2 a_18109_11960.t12 1e-3
R1472 a_18109_11960.n18 a_18109_11960.n5 1e-3
R1473 a_18109_11960.t0 a_18109_11960.t1 1e-3
R1474 a_18109_11960.n14 a_18109_11960.n11 1e-3
R1475 a_18109_11960.n17 a_18109_11960.n10 1e-3
R1476 a_18109_11960.n10 a_18109_11960.n16 1e-3
R1477 a_18109_11960.n11 a_18109_11960.n13 1e-3
R1478 a_18109_11960.n1 a_18109_11960.n9 1e-3
R1479 a_18109_11960.n5 a_18109_11960.n8 1e-3
R1480 a_18109_11960.n7 a_18109_11960.n6 1e-3
R1481 a_18109_11960.n12 a_18109_11960.n7 1e-3
R1482 a_18109_11960.n5 a_18109_11960.n4 1e-3
R1483 a_18109_11960.n3 a_18109_11960.n2 1e-3
R1484 a_18109_11960.n15 a_18109_11960.n3 1e-3
R1485 a_18109_11960.n1 a_18109_11960.n0 1e-3
R1486 a_18109_11960.n9 a_18109_11960.n17 1e-3
R1487 a_18109_11960.n16 a_18109_11960.n15 1e-3
R1488 a_18109_11960.n8 a_18109_11960.n14 1e-3
R1489 a_18109_11960.n13 a_18109_11960.n12 1e-3
R1490 a_17709_13109.n0 a_17709_13109.t85 1e-3
R1491 a_17709_13109.n37 a_17709_13109.t156 1e-3
R1492 a_17709_13109.n76 a_17709_13109.t13 1e-3
R1493 a_17709_13109.n113 a_17709_13109.t84 1e-3
R1494 a_17709_13109.n0 a_17709_13109.t86 1e-3
R1495 a_17709_13109.n1 a_17709_13109.t87 1e-3
R1496 a_17709_13109.n2 a_17709_13109.t88 1e-3
R1497 a_17709_13109.n3 a_17709_13109.t89 1e-3
R1498 a_17709_13109.n4 a_17709_13109.t90 1e-3
R1499 a_17709_13109.n5 a_17709_13109.t91 1e-3
R1500 a_17709_13109.n6 a_17709_13109.t92 1e-3
R1501 a_17709_13109.n7 a_17709_13109.t93 1e-3
R1502 a_17709_13109.n8 a_17709_13109.t94 1e-3
R1503 a_17709_13109.n9 a_17709_13109.t95 1e-3
R1504 a_17709_13109.n10 a_17709_13109.t96 1e-3
R1505 a_17709_13109.n11 a_17709_13109.t97 1e-3
R1506 a_17709_13109.n12 a_17709_13109.t98 1e-3
R1507 a_17709_13109.n13 a_17709_13109.t99 1e-3
R1508 a_17709_13109.n14 a_17709_13109.t100 1e-3
R1509 a_17709_13109.n15 a_17709_13109.t101 1e-3
R1510 a_17709_13109.n16 a_17709_13109.t102 1e-3
R1511 a_17709_13109.n17 a_17709_13109.t103 1e-3
R1512 a_17709_13109.n18 a_17709_13109.t104 1e-3
R1513 a_17709_13109.n19 a_17709_13109.t105 1e-3
R1514 a_17709_13109.n20 a_17709_13109.t106 1e-3
R1515 a_17709_13109.n21 a_17709_13109.t107 1e-3
R1516 a_17709_13109.n22 a_17709_13109.t108 1e-3
R1517 a_17709_13109.n23 a_17709_13109.t109 1e-3
R1518 a_17709_13109.n24 a_17709_13109.t110 1e-3
R1519 a_17709_13109.n25 a_17709_13109.t111 1e-3
R1520 a_17709_13109.n26 a_17709_13109.t112 1e-3
R1521 a_17709_13109.n27 a_17709_13109.t113 1e-3
R1522 a_17709_13109.n28 a_17709_13109.t114 1e-3
R1523 a_17709_13109.n29 a_17709_13109.t4 1e-3
R1524 a_17709_13109.n30 a_17709_13109.t3 1e-3
R1525 a_17709_13109.n31 a_17709_13109.t115 1e-3
R1526 a_17709_13109.n32 a_17709_13109.t116 1e-3
R1527 a_17709_13109.n33 a_17709_13109.t117 1e-3
R1528 a_17709_13109.n34 a_17709_13109.t118 1e-3
R1529 a_17709_13109.n35 a_17709_13109.t119 1e-3
R1530 a_17709_13109.n36 a_17709_13109.t120 1e-3
R1531 a_17709_13109.n73 a_17709_13109.t121 1e-3
R1532 a_17709_13109.n72 a_17709_13109.t122 1e-3
R1533 a_17709_13109.n71 a_17709_13109.t123 1e-3
R1534 a_17709_13109.n70 a_17709_13109.t124 1e-3
R1535 a_17709_13109.n69 a_17709_13109.t125 1e-3
R1536 a_17709_13109.n68 a_17709_13109.t126 1e-3
R1537 a_17709_13109.n67 a_17709_13109.t2 1e-3
R1538 a_17709_13109.n66 a_17709_13109.t0 1e-3
R1539 a_17709_13109.n65 a_17709_13109.t127 1e-3
R1540 a_17709_13109.n64 a_17709_13109.t128 1e-3
R1541 a_17709_13109.n63 a_17709_13109.t129 1e-3
R1542 a_17709_13109.n62 a_17709_13109.t130 1e-3
R1543 a_17709_13109.n61 a_17709_13109.t131 1e-3
R1544 a_17709_13109.n60 a_17709_13109.t132 1e-3
R1545 a_17709_13109.n59 a_17709_13109.t133 1e-3
R1546 a_17709_13109.n58 a_17709_13109.t134 1e-3
R1547 a_17709_13109.n57 a_17709_13109.t135 1e-3
R1548 a_17709_13109.n56 a_17709_13109.t136 1e-3
R1549 a_17709_13109.n55 a_17709_13109.t137 1e-3
R1550 a_17709_13109.n54 a_17709_13109.t138 1e-3
R1551 a_17709_13109.n53 a_17709_13109.t139 1e-3
R1552 a_17709_13109.n52 a_17709_13109.t140 1e-3
R1553 a_17709_13109.n51 a_17709_13109.t141 1e-3
R1554 a_17709_13109.n50 a_17709_13109.t142 1e-3
R1555 a_17709_13109.n49 a_17709_13109.t143 1e-3
R1556 a_17709_13109.n48 a_17709_13109.t144 1e-3
R1557 a_17709_13109.n47 a_17709_13109.t145 1e-3
R1558 a_17709_13109.n46 a_17709_13109.t146 1e-3
R1559 a_17709_13109.n45 a_17709_13109.t147 1e-3
R1560 a_17709_13109.n44 a_17709_13109.t148 1e-3
R1561 a_17709_13109.n43 a_17709_13109.t149 1e-3
R1562 a_17709_13109.n42 a_17709_13109.t150 1e-3
R1563 a_17709_13109.n41 a_17709_13109.t151 1e-3
R1564 a_17709_13109.n40 a_17709_13109.t152 1e-3
R1565 a_17709_13109.n39 a_17709_13109.t153 1e-3
R1566 a_17709_13109.n38 a_17709_13109.t154 1e-3
R1567 a_17709_13109.n37 a_17709_13109.t155 1e-3
R1568 a_17709_13109.n76 a_17709_13109.t14 1e-3
R1569 a_17709_13109.n77 a_17709_13109.t15 1e-3
R1570 a_17709_13109.n78 a_17709_13109.t16 1e-3
R1571 a_17709_13109.n79 a_17709_13109.t17 1e-3
R1572 a_17709_13109.n80 a_17709_13109.t18 1e-3
R1573 a_17709_13109.n81 a_17709_13109.t19 1e-3
R1574 a_17709_13109.n82 a_17709_13109.t20 1e-3
R1575 a_17709_13109.n83 a_17709_13109.t21 1e-3
R1576 a_17709_13109.n84 a_17709_13109.t22 1e-3
R1577 a_17709_13109.n85 a_17709_13109.t23 1e-3
R1578 a_17709_13109.n86 a_17709_13109.t24 1e-3
R1579 a_17709_13109.n87 a_17709_13109.t25 1e-3
R1580 a_17709_13109.n88 a_17709_13109.t26 1e-3
R1581 a_17709_13109.n89 a_17709_13109.t27 1e-3
R1582 a_17709_13109.n90 a_17709_13109.t28 1e-3
R1583 a_17709_13109.n91 a_17709_13109.t29 1e-3
R1584 a_17709_13109.n92 a_17709_13109.t30 1e-3
R1585 a_17709_13109.n93 a_17709_13109.t31 1e-3
R1586 a_17709_13109.n94 a_17709_13109.t32 1e-3
R1587 a_17709_13109.n95 a_17709_13109.t33 1e-3
R1588 a_17709_13109.n96 a_17709_13109.t34 1e-3
R1589 a_17709_13109.n97 a_17709_13109.t35 1e-3
R1590 a_17709_13109.n98 a_17709_13109.t36 1e-3
R1591 a_17709_13109.n99 a_17709_13109.t37 1e-3
R1592 a_17709_13109.n100 a_17709_13109.t38 1e-3
R1593 a_17709_13109.n101 a_17709_13109.t39 1e-3
R1594 a_17709_13109.n102 a_17709_13109.t40 1e-3
R1595 a_17709_13109.n103 a_17709_13109.t41 1e-3
R1596 a_17709_13109.n104 a_17709_13109.t42 1e-3
R1597 a_17709_13109.n105 a_17709_13109.t10 1e-3
R1598 a_17709_13109.n106 a_17709_13109.t8 1e-3
R1599 a_17709_13109.n107 a_17709_13109.t43 1e-3
R1600 a_17709_13109.n108 a_17709_13109.t44 1e-3
R1601 a_17709_13109.n109 a_17709_13109.t45 1e-3
R1602 a_17709_13109.n110 a_17709_13109.t46 1e-3
R1603 a_17709_13109.n111 a_17709_13109.t47 1e-3
R1604 a_17709_13109.n112 a_17709_13109.t48 1e-3
R1605 a_17709_13109.n149 a_17709_13109.t49 1e-3
R1606 a_17709_13109.n148 a_17709_13109.t50 1e-3
R1607 a_17709_13109.n147 a_17709_13109.t51 1e-3
R1608 a_17709_13109.n146 a_17709_13109.t52 1e-3
R1609 a_17709_13109.n145 a_17709_13109.t53 1e-3
R1610 a_17709_13109.n144 a_17709_13109.t54 1e-3
R1611 a_17709_13109.n143 a_17709_13109.t7 1e-3
R1612 a_17709_13109.n142 a_17709_13109.t5 1e-3
R1613 a_17709_13109.n141 a_17709_13109.t55 1e-3
R1614 a_17709_13109.n140 a_17709_13109.t56 1e-3
R1615 a_17709_13109.n139 a_17709_13109.t57 1e-3
R1616 a_17709_13109.n138 a_17709_13109.t58 1e-3
R1617 a_17709_13109.n137 a_17709_13109.t59 1e-3
R1618 a_17709_13109.n136 a_17709_13109.t60 1e-3
R1619 a_17709_13109.n135 a_17709_13109.t61 1e-3
R1620 a_17709_13109.n134 a_17709_13109.t62 1e-3
R1621 a_17709_13109.n133 a_17709_13109.t63 1e-3
R1622 a_17709_13109.n132 a_17709_13109.t64 1e-3
R1623 a_17709_13109.n131 a_17709_13109.t65 1e-3
R1624 a_17709_13109.n130 a_17709_13109.t66 1e-3
R1625 a_17709_13109.n129 a_17709_13109.t67 1e-3
R1626 a_17709_13109.n128 a_17709_13109.t68 1e-3
R1627 a_17709_13109.n127 a_17709_13109.t69 1e-3
R1628 a_17709_13109.n126 a_17709_13109.t70 1e-3
R1629 a_17709_13109.n125 a_17709_13109.t71 1e-3
R1630 a_17709_13109.n124 a_17709_13109.t72 1e-3
R1631 a_17709_13109.n123 a_17709_13109.t73 1e-3
R1632 a_17709_13109.n122 a_17709_13109.t74 1e-3
R1633 a_17709_13109.n121 a_17709_13109.t75 1e-3
R1634 a_17709_13109.n120 a_17709_13109.t76 1e-3
R1635 a_17709_13109.n119 a_17709_13109.t77 1e-3
R1636 a_17709_13109.n118 a_17709_13109.t78 1e-3
R1637 a_17709_13109.n117 a_17709_13109.t79 1e-3
R1638 a_17709_13109.n116 a_17709_13109.t80 1e-3
R1639 a_17709_13109.n115 a_17709_13109.t81 1e-3
R1640 a_17709_13109.n114 a_17709_13109.t82 1e-3
R1641 a_17709_13109.n113 a_17709_13109.t83 1e-3
R1642 a_17709_13109.n151 a_17709_13109.n75 1e-3
R1643 a_17709_13109.t1 a_17709_13109.n152 1e-3
R1644 a_17709_13109.n152 a_17709_13109.n74 1e-3
R1645 a_17709_13109.n151 a_17709_13109.n150 1e-3
R1646 a_17709_13109.n114 a_17709_13109.n113 1e-3
R1647 a_17709_13109.n115 a_17709_13109.n114 1e-3
R1648 a_17709_13109.n116 a_17709_13109.n115 1e-3
R1649 a_17709_13109.n117 a_17709_13109.n116 1e-3
R1650 a_17709_13109.n118 a_17709_13109.n117 1e-3
R1651 a_17709_13109.n119 a_17709_13109.n118 1e-3
R1652 a_17709_13109.n120 a_17709_13109.n119 1e-3
R1653 a_17709_13109.n121 a_17709_13109.n120 1e-3
R1654 a_17709_13109.n122 a_17709_13109.n121 1e-3
R1655 a_17709_13109.n123 a_17709_13109.n122 1e-3
R1656 a_17709_13109.n124 a_17709_13109.n123 1e-3
R1657 a_17709_13109.n125 a_17709_13109.n124 1e-3
R1658 a_17709_13109.n126 a_17709_13109.n125 1e-3
R1659 a_17709_13109.n127 a_17709_13109.n126 1e-3
R1660 a_17709_13109.n128 a_17709_13109.n127 1e-3
R1661 a_17709_13109.n129 a_17709_13109.n128 1e-3
R1662 a_17709_13109.n130 a_17709_13109.n129 1e-3
R1663 a_17709_13109.n131 a_17709_13109.n130 1e-3
R1664 a_17709_13109.n132 a_17709_13109.n131 1e-3
R1665 a_17709_13109.n133 a_17709_13109.n132 1e-3
R1666 a_17709_13109.n134 a_17709_13109.n133 1e-3
R1667 a_17709_13109.n135 a_17709_13109.n134 1e-3
R1668 a_17709_13109.n136 a_17709_13109.n135 1e-3
R1669 a_17709_13109.n137 a_17709_13109.n136 1e-3
R1670 a_17709_13109.n138 a_17709_13109.n137 1e-3
R1671 a_17709_13109.n139 a_17709_13109.n138 1e-3
R1672 a_17709_13109.n140 a_17709_13109.n139 1e-3
R1673 a_17709_13109.n141 a_17709_13109.n140 1e-3
R1674 a_17709_13109.n142 a_17709_13109.n141 1e-3
R1675 a_17709_13109.n143 a_17709_13109.n142 1e-3
R1676 a_17709_13109.n144 a_17709_13109.n143 1e-3
R1677 a_17709_13109.n145 a_17709_13109.n144 1e-3
R1678 a_17709_13109.n146 a_17709_13109.n145 1e-3
R1679 a_17709_13109.n147 a_17709_13109.n146 1e-3
R1680 a_17709_13109.n148 a_17709_13109.n147 1e-3
R1681 a_17709_13109.n149 a_17709_13109.n148 1e-3
R1682 a_17709_13109.n112 a_17709_13109.n111 1e-3
R1683 a_17709_13109.n111 a_17709_13109.n110 1e-3
R1684 a_17709_13109.n110 a_17709_13109.n109 1e-3
R1685 a_17709_13109.n109 a_17709_13109.n108 1e-3
R1686 a_17709_13109.n108 a_17709_13109.n107 1e-3
R1687 a_17709_13109.n107 a_17709_13109.n106 1e-3
R1688 a_17709_13109.n106 a_17709_13109.n105 1e-3
R1689 a_17709_13109.n105 a_17709_13109.n104 1e-3
R1690 a_17709_13109.n104 a_17709_13109.n103 1e-3
R1691 a_17709_13109.n103 a_17709_13109.n102 1e-3
R1692 a_17709_13109.n102 a_17709_13109.n101 1e-3
R1693 a_17709_13109.n101 a_17709_13109.n100 1e-3
R1694 a_17709_13109.n100 a_17709_13109.n99 1e-3
R1695 a_17709_13109.n99 a_17709_13109.n98 1e-3
R1696 a_17709_13109.n98 a_17709_13109.n97 1e-3
R1697 a_17709_13109.n97 a_17709_13109.n96 1e-3
R1698 a_17709_13109.n96 a_17709_13109.n95 1e-3
R1699 a_17709_13109.n95 a_17709_13109.n94 1e-3
R1700 a_17709_13109.n94 a_17709_13109.n93 1e-3
R1701 a_17709_13109.n93 a_17709_13109.n92 1e-3
R1702 a_17709_13109.n92 a_17709_13109.n91 1e-3
R1703 a_17709_13109.n91 a_17709_13109.n90 1e-3
R1704 a_17709_13109.n90 a_17709_13109.n89 1e-3
R1705 a_17709_13109.n89 a_17709_13109.n88 1e-3
R1706 a_17709_13109.n88 a_17709_13109.n87 1e-3
R1707 a_17709_13109.n87 a_17709_13109.n86 1e-3
R1708 a_17709_13109.n86 a_17709_13109.n85 1e-3
R1709 a_17709_13109.n85 a_17709_13109.n84 1e-3
R1710 a_17709_13109.n84 a_17709_13109.n83 1e-3
R1711 a_17709_13109.n83 a_17709_13109.n82 1e-3
R1712 a_17709_13109.n82 a_17709_13109.n81 1e-3
R1713 a_17709_13109.n81 a_17709_13109.n80 1e-3
R1714 a_17709_13109.n80 a_17709_13109.n79 1e-3
R1715 a_17709_13109.n79 a_17709_13109.n78 1e-3
R1716 a_17709_13109.n78 a_17709_13109.n77 1e-3
R1717 a_17709_13109.n77 a_17709_13109.n76 1e-3
R1718 a_17709_13109.n38 a_17709_13109.n37 1e-3
R1719 a_17709_13109.n39 a_17709_13109.n38 1e-3
R1720 a_17709_13109.n40 a_17709_13109.n39 1e-3
R1721 a_17709_13109.n41 a_17709_13109.n40 1e-3
R1722 a_17709_13109.n42 a_17709_13109.n41 1e-3
R1723 a_17709_13109.n43 a_17709_13109.n42 1e-3
R1724 a_17709_13109.n44 a_17709_13109.n43 1e-3
R1725 a_17709_13109.n45 a_17709_13109.n44 1e-3
R1726 a_17709_13109.n46 a_17709_13109.n45 1e-3
R1727 a_17709_13109.n47 a_17709_13109.n46 1e-3
R1728 a_17709_13109.n48 a_17709_13109.n47 1e-3
R1729 a_17709_13109.n49 a_17709_13109.n48 1e-3
R1730 a_17709_13109.n50 a_17709_13109.n49 1e-3
R1731 a_17709_13109.n51 a_17709_13109.n50 1e-3
R1732 a_17709_13109.n52 a_17709_13109.n51 1e-3
R1733 a_17709_13109.n53 a_17709_13109.n52 1e-3
R1734 a_17709_13109.n54 a_17709_13109.n53 1e-3
R1735 a_17709_13109.n55 a_17709_13109.n54 1e-3
R1736 a_17709_13109.n56 a_17709_13109.n55 1e-3
R1737 a_17709_13109.n57 a_17709_13109.n56 1e-3
R1738 a_17709_13109.n58 a_17709_13109.n57 1e-3
R1739 a_17709_13109.n59 a_17709_13109.n58 1e-3
R1740 a_17709_13109.n60 a_17709_13109.n59 1e-3
R1741 a_17709_13109.n61 a_17709_13109.n60 1e-3
R1742 a_17709_13109.n62 a_17709_13109.n61 1e-3
R1743 a_17709_13109.n63 a_17709_13109.n62 1e-3
R1744 a_17709_13109.n64 a_17709_13109.n63 1e-3
R1745 a_17709_13109.n65 a_17709_13109.n64 1e-3
R1746 a_17709_13109.n66 a_17709_13109.n65 1e-3
R1747 a_17709_13109.n67 a_17709_13109.n66 1e-3
R1748 a_17709_13109.n68 a_17709_13109.n67 1e-3
R1749 a_17709_13109.n69 a_17709_13109.n68 1e-3
R1750 a_17709_13109.n70 a_17709_13109.n69 1e-3
R1751 a_17709_13109.n71 a_17709_13109.n70 1e-3
R1752 a_17709_13109.n72 a_17709_13109.n71 1e-3
R1753 a_17709_13109.n73 a_17709_13109.n72 1e-3
R1754 a_17709_13109.n36 a_17709_13109.n35 1e-3
R1755 a_17709_13109.n35 a_17709_13109.n34 1e-3
R1756 a_17709_13109.n34 a_17709_13109.n33 1e-3
R1757 a_17709_13109.n33 a_17709_13109.n32 1e-3
R1758 a_17709_13109.n32 a_17709_13109.n31 1e-3
R1759 a_17709_13109.n31 a_17709_13109.n30 1e-3
R1760 a_17709_13109.n30 a_17709_13109.n29 1e-3
R1761 a_17709_13109.n29 a_17709_13109.n28 1e-3
R1762 a_17709_13109.n28 a_17709_13109.n27 1e-3
R1763 a_17709_13109.n27 a_17709_13109.n26 1e-3
R1764 a_17709_13109.n26 a_17709_13109.n25 1e-3
R1765 a_17709_13109.n25 a_17709_13109.n24 1e-3
R1766 a_17709_13109.n24 a_17709_13109.n23 1e-3
R1767 a_17709_13109.n23 a_17709_13109.n22 1e-3
R1768 a_17709_13109.n22 a_17709_13109.n21 1e-3
R1769 a_17709_13109.n21 a_17709_13109.n20 1e-3
R1770 a_17709_13109.n20 a_17709_13109.n19 1e-3
R1771 a_17709_13109.n19 a_17709_13109.n18 1e-3
R1772 a_17709_13109.n18 a_17709_13109.n17 1e-3
R1773 a_17709_13109.n17 a_17709_13109.n16 1e-3
R1774 a_17709_13109.n16 a_17709_13109.n15 1e-3
R1775 a_17709_13109.n15 a_17709_13109.n14 1e-3
R1776 a_17709_13109.n14 a_17709_13109.n13 1e-3
R1777 a_17709_13109.n13 a_17709_13109.n12 1e-3
R1778 a_17709_13109.n12 a_17709_13109.n11 1e-3
R1779 a_17709_13109.n11 a_17709_13109.n10 1e-3
R1780 a_17709_13109.n10 a_17709_13109.n9 1e-3
R1781 a_17709_13109.n9 a_17709_13109.n8 1e-3
R1782 a_17709_13109.n8 a_17709_13109.n7 1e-3
R1783 a_17709_13109.n7 a_17709_13109.n6 1e-3
R1784 a_17709_13109.n6 a_17709_13109.n5 1e-3
R1785 a_17709_13109.n5 a_17709_13109.n4 1e-3
R1786 a_17709_13109.n4 a_17709_13109.n3 1e-3
R1787 a_17709_13109.n3 a_17709_13109.n2 1e-3
R1788 a_17709_13109.n2 a_17709_13109.n1 1e-3
R1789 a_17709_13109.n1 a_17709_13109.n0 1e-3
R1790 a_17709_13109.t6 a_17709_13109.t1 1e-3
R1791 a_17709_13109.n150 a_17709_13109.n149 1e-3
R1792 a_17709_13109.n150 a_17709_13109.n112 1e-3
R1793 a_17709_13109.n74 a_17709_13109.n73 1e-3
R1794 a_17709_13109.n74 a_17709_13109.n36 1e-3
R1795 a_17709_13109.t9 a_17709_13109.t6 1e-3
R1796 a_17709_13109.n75 a_17709_13109.t12 1e-3
R1797 a_17709_13109.n75 a_17709_13109.t11 1e-3
R1798 a_17709_13109.n152 a_17709_13109.n151 1e-3
R1799 a_35769_13109.n31 a_35769_13109.t34 1e-3
R1800 a_35769_13109.n46 a_35769_13109.t65 1e-3
R1801 a_35769_13109.n0 a_35769_13109.t2 1e-3
R1802 a_35769_13109.n15 a_35769_13109.t33 1e-3
R1803 a_35769_13109.n31 a_35769_13109.t35 1e-3
R1804 a_35769_13109.n32 a_35769_13109.t36 1e-3
R1805 a_35769_13109.n33 a_35769_13109.t37 1e-3
R1806 a_35769_13109.n34 a_35769_13109.t38 1e-3
R1807 a_35769_13109.n35 a_35769_13109.t39 1e-3
R1808 a_35769_13109.n36 a_35769_13109.t40 1e-3
R1809 a_35769_13109.n37 a_35769_13109.t41 1e-3
R1810 a_35769_13109.n38 a_35769_13109.t42 1e-3
R1811 a_35769_13109.n39 a_35769_13109.t43 1e-3
R1812 a_35769_13109.n40 a_35769_13109.t44 1e-3
R1813 a_35769_13109.n41 a_35769_13109.t45 1e-3
R1814 a_35769_13109.n42 a_35769_13109.t46 1e-3
R1815 a_35769_13109.n43 a_35769_13109.t47 1e-3
R1816 a_35769_13109.n44 a_35769_13109.t48 1e-3
R1817 a_35769_13109.n45 a_35769_13109.t49 1e-3
R1818 a_35769_13109.n60 a_35769_13109.t50 1e-3
R1819 a_35769_13109.n59 a_35769_13109.t51 1e-3
R1820 a_35769_13109.n58 a_35769_13109.t52 1e-3
R1821 a_35769_13109.n57 a_35769_13109.t53 1e-3
R1822 a_35769_13109.n56 a_35769_13109.t54 1e-3
R1823 a_35769_13109.n55 a_35769_13109.t55 1e-3
R1824 a_35769_13109.n54 a_35769_13109.t56 1e-3
R1825 a_35769_13109.n53 a_35769_13109.t57 1e-3
R1826 a_35769_13109.n52 a_35769_13109.t58 1e-3
R1827 a_35769_13109.n51 a_35769_13109.t59 1e-3
R1828 a_35769_13109.n50 a_35769_13109.t60 1e-3
R1829 a_35769_13109.n49 a_35769_13109.t61 1e-3
R1830 a_35769_13109.n48 a_35769_13109.t62 1e-3
R1831 a_35769_13109.n47 a_35769_13109.t63 1e-3
R1832 a_35769_13109.n46 a_35769_13109.t64 1e-3
R1833 a_35769_13109.n0 a_35769_13109.t3 1e-3
R1834 a_35769_13109.n1 a_35769_13109.t4 1e-3
R1835 a_35769_13109.n2 a_35769_13109.t5 1e-3
R1836 a_35769_13109.n3 a_35769_13109.t6 1e-3
R1837 a_35769_13109.n4 a_35769_13109.t7 1e-3
R1838 a_35769_13109.n5 a_35769_13109.t8 1e-3
R1839 a_35769_13109.n6 a_35769_13109.t9 1e-3
R1840 a_35769_13109.n7 a_35769_13109.t10 1e-3
R1841 a_35769_13109.n8 a_35769_13109.t11 1e-3
R1842 a_35769_13109.n9 a_35769_13109.t12 1e-3
R1843 a_35769_13109.n10 a_35769_13109.t13 1e-3
R1844 a_35769_13109.n11 a_35769_13109.t14 1e-3
R1845 a_35769_13109.n12 a_35769_13109.t15 1e-3
R1846 a_35769_13109.n13 a_35769_13109.t16 1e-3
R1847 a_35769_13109.n14 a_35769_13109.t17 1e-3
R1848 a_35769_13109.n29 a_35769_13109.t18 1e-3
R1849 a_35769_13109.n28 a_35769_13109.t19 1e-3
R1850 a_35769_13109.n27 a_35769_13109.t20 1e-3
R1851 a_35769_13109.n26 a_35769_13109.t21 1e-3
R1852 a_35769_13109.n25 a_35769_13109.t22 1e-3
R1853 a_35769_13109.n24 a_35769_13109.t23 1e-3
R1854 a_35769_13109.n23 a_35769_13109.t24 1e-3
R1855 a_35769_13109.n22 a_35769_13109.t25 1e-3
R1856 a_35769_13109.n21 a_35769_13109.t26 1e-3
R1857 a_35769_13109.n20 a_35769_13109.t27 1e-3
R1858 a_35769_13109.n19 a_35769_13109.t28 1e-3
R1859 a_35769_13109.n18 a_35769_13109.t29 1e-3
R1860 a_35769_13109.n17 a_35769_13109.t30 1e-3
R1861 a_35769_13109.n16 a_35769_13109.t31 1e-3
R1862 a_35769_13109.n15 a_35769_13109.t32 1e-3
R1863 a_35769_13109.t0 a_35769_13109.n62 1e-3
R1864 a_35769_13109.t1 a_35769_13109.t0 1e-3
R1865 a_35769_13109.n16 a_35769_13109.n15 1e-3
R1866 a_35769_13109.n17 a_35769_13109.n16 1e-3
R1867 a_35769_13109.n18 a_35769_13109.n17 1e-3
R1868 a_35769_13109.n19 a_35769_13109.n18 1e-3
R1869 a_35769_13109.n20 a_35769_13109.n19 1e-3
R1870 a_35769_13109.n21 a_35769_13109.n20 1e-3
R1871 a_35769_13109.n22 a_35769_13109.n21 1e-3
R1872 a_35769_13109.n23 a_35769_13109.n22 1e-3
R1873 a_35769_13109.n24 a_35769_13109.n23 1e-3
R1874 a_35769_13109.n25 a_35769_13109.n24 1e-3
R1875 a_35769_13109.n26 a_35769_13109.n25 1e-3
R1876 a_35769_13109.n27 a_35769_13109.n26 1e-3
R1877 a_35769_13109.n28 a_35769_13109.n27 1e-3
R1878 a_35769_13109.n29 a_35769_13109.n28 1e-3
R1879 a_35769_13109.n14 a_35769_13109.n13 1e-3
R1880 a_35769_13109.n13 a_35769_13109.n12 1e-3
R1881 a_35769_13109.n12 a_35769_13109.n11 1e-3
R1882 a_35769_13109.n11 a_35769_13109.n10 1e-3
R1883 a_35769_13109.n10 a_35769_13109.n9 1e-3
R1884 a_35769_13109.n9 a_35769_13109.n8 1e-3
R1885 a_35769_13109.n8 a_35769_13109.n7 1e-3
R1886 a_35769_13109.n7 a_35769_13109.n6 1e-3
R1887 a_35769_13109.n6 a_35769_13109.n5 1e-3
R1888 a_35769_13109.n5 a_35769_13109.n4 1e-3
R1889 a_35769_13109.n4 a_35769_13109.n3 1e-3
R1890 a_35769_13109.n3 a_35769_13109.n2 1e-3
R1891 a_35769_13109.n2 a_35769_13109.n1 1e-3
R1892 a_35769_13109.n1 a_35769_13109.n0 1e-3
R1893 a_35769_13109.n47 a_35769_13109.n46 1e-3
R1894 a_35769_13109.n48 a_35769_13109.n47 1e-3
R1895 a_35769_13109.n49 a_35769_13109.n48 1e-3
R1896 a_35769_13109.n50 a_35769_13109.n49 1e-3
R1897 a_35769_13109.n51 a_35769_13109.n50 1e-3
R1898 a_35769_13109.n52 a_35769_13109.n51 1e-3
R1899 a_35769_13109.n53 a_35769_13109.n52 1e-3
R1900 a_35769_13109.n54 a_35769_13109.n53 1e-3
R1901 a_35769_13109.n55 a_35769_13109.n54 1e-3
R1902 a_35769_13109.n56 a_35769_13109.n55 1e-3
R1903 a_35769_13109.n57 a_35769_13109.n56 1e-3
R1904 a_35769_13109.n58 a_35769_13109.n57 1e-3
R1905 a_35769_13109.n59 a_35769_13109.n58 1e-3
R1906 a_35769_13109.n60 a_35769_13109.n59 1e-3
R1907 a_35769_13109.n45 a_35769_13109.n44 1e-3
R1908 a_35769_13109.n44 a_35769_13109.n43 1e-3
R1909 a_35769_13109.n43 a_35769_13109.n42 1e-3
R1910 a_35769_13109.n42 a_35769_13109.n41 1e-3
R1911 a_35769_13109.n41 a_35769_13109.n40 1e-3
R1912 a_35769_13109.n40 a_35769_13109.n39 1e-3
R1913 a_35769_13109.n39 a_35769_13109.n38 1e-3
R1914 a_35769_13109.n38 a_35769_13109.n37 1e-3
R1915 a_35769_13109.n37 a_35769_13109.n36 1e-3
R1916 a_35769_13109.n36 a_35769_13109.n35 1e-3
R1917 a_35769_13109.n35 a_35769_13109.n34 1e-3
R1918 a_35769_13109.n34 a_35769_13109.n33 1e-3
R1919 a_35769_13109.n33 a_35769_13109.n32 1e-3
R1920 a_35769_13109.n32 a_35769_13109.n31 1e-3
R1921 a_35769_13109.n62 a_35769_13109.n30 1e-3
R1922 a_35769_13109.n62 a_35769_13109.n61 1e-3
R1923 a_35769_13109.n30 a_35769_13109.n29 1e-3
R1924 a_35769_13109.n30 a_35769_13109.n14 1e-3
R1925 a_35769_13109.n61 a_35769_13109.n60 1e-3
R1926 a_35769_13109.n61 a_35769_13109.n45 1e-3
R1927 a_10387_27249.n0 a_10387_27249.t4 1e-3
R1928 a_10387_27249.n1 a_10387_27249.t3 1e-3
R1929 a_10387_27249.n8 a_10387_27249.n2 1e-3
R1930 a_10387_27249.n3 a_10387_27249.t8 1e-3
R1931 a_10387_27249.n4 a_10387_27249.t11 1e-3
R1932 a_10387_27249.n1 a_10387_27249.t5 1e-3
R1933 a_10387_27249.n6 a_10387_27249.t6 1e-3
R1934 a_10387_27249.n6 a_10387_27249.t7 1e-3
R1935 a_10387_27249.n0 a_10387_27249.t2 1e-3
R1936 a_10387_27249.n3 a_10387_27249.t9 1e-3
R1937 a_10387_27249.n4 a_10387_27249.t10 1e-3
R1938 a_10387_27249.t1 a_10387_27249.n8 1e-3
R1939 a_10387_27249.n2 a_10387_27249.n1 1e-3
R1940 a_10387_27249.n7 a_10387_27249.n6 1e-3
R1941 a_10387_27249.t0 a_10387_27249.t1 1e-3
R1942 a_10387_27249.n7 a_10387_27249.n5 1e-3
R1943 a_10387_27249.n2 a_10387_27249.n0 1e-3
R1944 a_10387_27249.n8 a_10387_27249.n7 1e-3
R1945 a_10387_27249.n5 a_10387_27249.n4 1e-3
R1946 a_10387_27249.n5 a_10387_27249.n3 1e-3
R1947 a_8707_27249.n1 a_8707_27249.t4 1e-3
R1948 a_8707_27249.n0 a_8707_27249.t5 1e-3
R1949 a_8707_27249.t6 a_8707_27249.n2 1e-3
R1950 a_8707_27249.n0 a_8707_27249.t3 1e-3
R1951 a_8707_27249.t1 a_8707_27249.t6 1e-3
R1952 a_8707_27249.n1 a_8707_27249.t2 1e-3
R1953 a_8707_27249.t0 a_8707_27249.t1 1e-3
R1954 a_8707_27249.n2 a_8707_27249.n0 1e-3
R1955 a_8707_27249.n2 a_8707_27249.n1 1e-3
R1956 a_24365_56340.n0 a_24365_56340.t4 1e-3
R1957 a_24365_56340.n1 a_24365_56340.t3 1e-3
R1958 a_24365_56340.n1 a_24365_56340.t5 1e-3
R1959 a_24365_56340.n0 a_24365_56340.t2 1e-3
R1960 a_24365_56340.t6 a_24365_56340.n2 1e-3
R1961 a_24365_56340.t1 a_24365_56340.t6 1e-3
R1962 a_24365_56340.n2 a_24365_56340.n0 1e-3
R1963 a_24365_56340.n2 a_24365_56340.n1 1e-3
R1964 a_24365_56340.t0 a_24365_56340.t1 1e-3
R1965 a_22825_56340.n0 a_22825_56340.t4 1e-3
R1966 a_22825_56340.n1 a_22825_56340.t5 1e-3
R1967 a_22825_56340.t6 a_22825_56340.n2 1e-3
R1968 a_22825_56340.n1 a_22825_56340.t3 1e-3
R1969 a_22825_56340.n0 a_22825_56340.t2 1e-3
R1970 a_22825_56340.t1 a_22825_56340.t6 1e-3
R1971 a_22825_56340.n2 a_22825_56340.n0 1e-3
R1972 a_22825_56340.t0 a_22825_56340.t1 1e-3
R1973 a_22825_56340.n2 a_22825_56340.n1 1e-3
R1974 a_31849_65609.n0 a_31849_65609.t5 1e-3
R1975 a_31849_65609.n1 a_31849_65609.t4 1e-3
R1976 a_31849_65609.t2 a_31849_65609.n2 1e-3
R1977 a_31849_65609.n1 a_31849_65609.t6 1e-3
R1978 a_31849_65609.n0 a_31849_65609.t3 1e-3
R1979 a_31849_65609.t1 a_31849_65609.t2 1e-3
R1980 a_31849_65609.n2 a_31849_65609.n0 1e-3
R1981 a_31849_65609.n2 a_31849_65609.n1 1e-3
R1982 a_31849_65609.t0 a_31849_65609.t1 1e-3
R1983 a_25129_65609.n0 a_25129_65609.t5 1e-3
R1984 a_25129_65609.n1 a_25129_65609.t6 1e-3
R1985 a_25129_65609.t2 a_25129_65609.n2 1e-3
R1986 a_25129_65609.n1 a_25129_65609.t4 1e-3
R1987 a_25129_65609.n0 a_25129_65609.t3 1e-3
R1988 a_25129_65609.t1 a_25129_65609.t2 1e-3
R1989 a_25129_65609.n2 a_25129_65609.n0 1e-3
R1990 a_25129_65609.n2 a_25129_65609.n1 1e-3
R1991 a_25129_65609.t0 a_25129_65609.t1 1e-3
R1992 a_26067_78349.n0 a_26067_78349.t5 1e-3
R1993 a_26067_78349.n1 a_26067_78349.t6 1e-3
R1994 a_26067_78349.t2 a_26067_78349.n2 1e-3
R1995 a_26067_78349.n0 a_26067_78349.t3 1e-3
R1996 a_26067_78349.n1 a_26067_78349.t4 1e-3
R1997 a_26067_78349.n2 a_26067_78349.n1 1e-3
R1998 a_26067_78349.n2 a_26067_78349.n0 1e-3
R1999 a_26067_78349.t0 a_26067_78349.t2 1e-3
R2000 a_26067_78349.t1 a_26067_78349.t0 1e-3
R2001 a_22707_78349.n0 a_22707_78349.t5 1e-3
R2002 a_22707_78349.n1 a_22707_78349.t6 1e-3
R2003 a_22707_78349.t2 a_22707_78349.n2 1e-3
R2004 a_22707_78349.n0 a_22707_78349.t3 1e-3
R2005 a_22707_78349.n1 a_22707_78349.t4 1e-3
R2006 a_22707_78349.n2 a_22707_78349.n1 1e-3
R2007 a_22707_78349.n2 a_22707_78349.n0 1e-3
R2008 a_22707_78349.t0 a_22707_78349.t2 1e-3
R2009 a_22707_78349.t1 a_22707_78349.t0 1e-3
R2010 a_7027_78349.n0 a_7027_78349.t5 1e-3
R2011 a_7027_78349.n1 a_7027_78349.t6 1e-3
R2012 a_7027_78349.t2 a_7027_78349.n2 1e-3
R2013 a_7027_78349.n0 a_7027_78349.t3 1e-3
R2014 a_7027_78349.n1 a_7027_78349.t4 1e-3
R2015 a_7027_78349.n2 a_7027_78349.n1 1e-3
R2016 a_7027_78349.n2 a_7027_78349.n0 1e-3
R2017 a_7027_78349.t0 a_7027_78349.t2 1e-3
R2018 a_7027_78349.t1 a_7027_78349.t0 1e-3
R2019 a_3667_78349.n0 a_3667_78349.t5 1e-3
R2020 a_3667_78349.n1 a_3667_78349.t6 1e-3
R2021 a_3667_78349.t2 a_3667_78349.n2 1e-3
R2022 a_3667_78349.n0 a_3667_78349.t3 1e-3
R2023 a_3667_78349.n1 a_3667_78349.t4 1e-3
R2024 a_3667_78349.n2 a_3667_78349.n1 1e-3
R2025 a_3667_78349.n2 a_3667_78349.n0 1e-3
R2026 a_3667_78349.t0 a_3667_78349.t2 1e-3
R2027 a_3667_78349.t1 a_3667_78349.t0 1e-3
R2028 a_5347_78349.n1 a_5347_78349.t5 1e-3
R2029 a_5347_78349.n0 a_5347_78349.t6 1e-3
R2030 a_5347_78349.t2 a_5347_78349.n2 1e-3
R2031 a_5347_78349.n1 a_5347_78349.t3 1e-3
R2032 a_5347_78349.n0 a_5347_78349.t4 1e-3
R2033 a_5347_78349.n2 a_5347_78349.n1 1e-3
R2034 a_5347_78349.n2 a_5347_78349.n0 1e-3
R2035 a_5347_78349.t0 a_5347_78349.t2 1e-3
R2036 a_5347_78349.t1 a_5347_78349.t0 1e-3
R2037 a_3667_82689.n1 a_3667_82689.t5 1e-3
R2038 a_3667_82689.n0 a_3667_82689.t6 1e-3
R2039 a_3667_82689.t2 a_3667_82689.n2 1e-3
R2040 a_3667_82689.n1 a_3667_82689.t3 1e-3
R2041 a_3667_82689.n0 a_3667_82689.t4 1e-3
R2042 a_3667_82689.n2 a_3667_82689.n0 1e-3
R2043 a_3667_82689.n2 a_3667_82689.n1 1e-3
R2044 a_3667_82689.t0 a_3667_82689.t2 1e-3
R2045 a_3667_82689.t1 a_3667_82689.t0 1e-3
C741 VCTRL VSS 19.519f
C742 B1 VSS 40.21551f
C743 B0 VSS 27.231f
C744 LOQP VSS 22.5416f
C745 LOQN VSS 22.6496f
C746 LOIN VSS 38.86171f
C747 LOIP VSS 48.79766f
C748 VDD VSS 0.55898p
C749 VR VSS 0.96676p
C750 a_46940_3486# VSS 0.88455f ; **FLOATING
C751 a_46520_3486# VSS 0.85051f ; **FLOATING
C752 a_46100_1364# VSS 0.84806f ; **FLOATING
C753 a_45680_1364# VSS 0.85293f ; **FLOATING
C754 a_45260_3486# VSS 0.85871f ; **FLOATING
C755 a_44840_3486# VSS 0.85051f ; **FLOATING
C756 a_44420_1364# VSS 0.8637f ; **FLOATING
C757 a_44000_1364# VSS 0.85197f ; **FLOATING
C758 a_43580_3486# VSS 0.85871f ; **FLOATING
C759 a_43160_3486# VSS 0.85051f ; **FLOATING
C760 a_42740_1364# VSS 0.86578f ; **FLOATING
C761 a_42320_1364# VSS 0.851f ; **FLOATING
C762 a_41900_3486# VSS 0.85871f ; **FLOATING
C763 a_41480_3486# VSS 0.85051f ; **FLOATING
C764 a_41060_1364# VSS 0.86484f ; **FLOATING
C765 a_40640_1364# VSS 0.85048f ; **FLOATING
C766 a_40220_3486# VSS 0.85871f ; **FLOATING
C767 a_39800_3486# VSS 0.8665f ; **FLOATING
C768 a_35956_1120# VSS 1.02722f
C769 a_35000_1180# VSS 1.78228f ; **FLOATING
C770 a_34840_1120# VSS 1.029f
C771 a_51114_14482# VSS 0.24128f ; **FLOATING
C772 a_50704_14482# VSS 0.25327f ; **FLOATING
C773 a_44954_14482# VSS 0.24128f
C774 a_44544_14482# VSS 0.25327f ; **FLOATING
C775 a_41016_11900# VSS 0.12095f
C776 a_35584_11900# VSS 0.12095f
C777 a_41016_13271# VSS 0.1189f
C778 a_35584_13271# VSS 0.1189f
C779 a_34224_11900# VSS 0.12306f
C780 a_31384_11900# VSS 0.12306f
C781 a_30084_11900# VSS 0.12095f
C782 a_17524_11900# VSS 0.12095f
C783 a_30084_13271# VSS 0.1189f
C784 a_21997_11960# VSS 1.57637f ; **FLOATING
C785 a_17524_13271# VSS 0.1189f
C786 a_51114_18340# VSS 0.04368f
C787 a_50704_18340# VSS 0.04368f
C788 a_44954_18340# VSS 0.04368f
C789 a_31569_13109# VSS 7.37677f ; **FLOATING
C790 a_44544_18340# VSS 0.04368f
C791 a_62174_26942# VSS 0.24358f
C792 a_61764_26942# VSS 0.2518f ; **FLOATING
C793 a_60494_26942# VSS 0.24128f
C794 a_60084_26942# VSS 0.25327f ; **FLOATING
C795 a_54334_26600# VSS 0.39521f
C796 a_53924_26600# VSS 0.4082f ; **FLOATING
C797 a_52654_26600# VSS 0.38483f
C798 a_52360_26660# VSS 1.15362f ; **FLOATING
C799 a_52244_26600# VSS 0.38539f
C800 a_46494_26942# VSS 0.24128f
C801 a_46084_26942# VSS 0.25327f ; **FLOATING
C802 a_40334_26600# VSS 0.39521f
C803 a_39924_26600# VSS 0.4082f ; **FLOATING
C804 a_38654_26600# VSS 0.38483f
C805 a_38360_26660# VSS 1.15362f ; **FLOATING
C806 a_38244_26600# VSS 0.38539f
C807 a_32494_26942# VSS 0.24128f
C808 a_32084_26942# VSS 0.25327f ; **FLOATING
C809 a_26334_26942# VSS 0.24358f
C810 a_25924_26942# VSS 0.2518f ; **FLOATING
C811 a_24654_26942# VSS 0.24128f
C812 a_24244_26942# VSS 0.25327f ; **FLOATING
C813 a_18494_26942# VSS 0.24358f
C814 a_18084_26942# VSS 0.2518f ; **FLOATING
C815 a_16814_26942# VSS 0.24128f
C816 a_16404_26942# VSS 0.25327f ; **FLOATING
C817 a_10654_26600# VSS 0.39521f
C818 a_10244_26600# VSS 0.4082f ; **FLOATING
C819 a_8974_26600# VSS 0.38483f
C820 a_8680_26660# VSS 1.15362f ; **FLOATING
C821 a_8564_26600# VSS 0.38539f
C822 a_62174_30800# VSS 0.07326f
C823 a_60345_27002# VSS 3.20709f ; **FLOATING
C824 a_61764_30800# VSS 0.07326f
C825 a_60494_30800# VSS 0.07326f
C826 a_60345_30860# VSS 0.53402f ; **FLOATING
C827 a_60084_30800# VSS 0.07326f
C828 a_54334_30660# VSS 0.04368f
C829 a_53924_30660# VSS 0.04368f
C830 a_52654_30660# VSS 0.04368f
C831 a_52505_26660# VSS 2.85213f ; **FLOATING
C832 a_52244_30660# VSS 0.04368f
C833 a_46494_30800# VSS 0.04368f
C834 a_46084_30800# VSS 0.04368f
C835 a_40334_30660# VSS 0.04368f
C836 a_39924_30660# VSS 0.04368f
C837 a_40067_27249# VSS 15.1339f ; **FLOATING
C838 a_38654_30660# VSS 0.04368f
C839 a_38505_26660# VSS 7.11369f ; **FLOATING
C840 a_38244_30660# VSS 0.04368f
C841 a_32494_30800# VSS 0.04368f
C842 a_32345_27002# VSS 3.25077f ; **FLOATING
C843 a_32084_30800# VSS 0.04368f
C844 a_26334_30800# VSS 0.07326f
C845 a_25924_30800# VSS 0.07326f
C846 a_26067_27389# VSS 18.95f ; **FLOATING
C847 a_24654_30800# VSS 0.07326f
C848 a_24505_30860# VSS 0.53402f ; **FLOATING
C849 a_24244_30800# VSS 0.07326f
C850 a_18494_30800# VSS 0.07326f
C851 a_16665_27002# VSS 23.588f ; **FLOATING
C852 a_18084_30800# VSS 0.07326f
C853 a_16814_30800# VSS 0.07326f
C854 a_16665_30860# VSS 0.53402f ; **FLOATING
C855 a_16404_30800# VSS 0.07326f
C856 a_10654_30660# VSS 0.04368f
C857 a_10244_30660# VSS 0.04368f
C858 a_8974_30660# VSS 0.04368f
C859 a_8825_26660# VSS 25.8417f ; **FLOATING
C860 a_8564_30660# VSS 0.04368f
C861 a_45676_39340# VSS 0.58425f ; **FLOATING
C862 a_45104_39340# VSS 0.58298f ; **FLOATING
C863 a_38956_39340# VSS 0.58425f ; **FLOATING
C864 a_38384_39340# VSS 0.58298f ; **FLOATING
C865 a_32236_39340# VSS 0.58425f ; **FLOATING
C866 a_31664_39340# VSS 0.58298f ; **FLOATING
C867 a_25516_39340# VSS 0.58425f ; **FLOATING
C868 a_24944_39340# VSS 0.58298f ; **FLOATING
C869 a_46000_43540# VSS 0.07989f
C870 a_45104_43540# VSS 0.07989f
C871 a_39280_43540# VSS 0.07989f
C872 a_38384_43540# VSS 0.07989f
C873 a_32560_43540# VSS 0.07989f
C874 a_31664_43540# VSS 0.07989f
C875 a_25840_43540# VSS 0.07989f
C876 a_24944_43540# VSS 0.07989f
C877 a_54334_51940# VSS 0.39521f
C878 a_53924_51940# VSS 0.40738f ; **FLOATING
C879 a_52794_51940# VSS 0.39521f
C880 a_52384_51940# VSS 0.40738f ; **FLOATING
C881 a_51278_52282# VSS 0.28139f
C882 a_50820_52282# VSS 0.29389f
C883 a_49738_52282# VSS 0.27965f
C884 a_49280_52282# VSS 0.29512f
C885 a_48216_51940# VSS 0.85008f
C886 a_47572_51940# VSS 0.84219f
C887 a_46928_51940# VSS 0.83488f
C888 a_46284_51940# VSS 0.82323f
C889 a_45640_51940# VSS 0.84915f ; **FLOATING
C890 a_44534_51940# VSS 0.39521f ; **FLOATING
C891 a_44124_51940# VSS 0.40738f ; **FLOATING
C892 a_42994_51940# VSS 0.39203f ; **FLOATING
C893 a_42584_51940# VSS 0.41056f ; **FLOATING
C894 a_41478_52282# VSS 0.28205f
C895 a_41020_52282# VSS 0.29578f
C896 a_39938_52282# VSS 0.28324f
C897 a_39480_52282# VSS 0.29578f
C898 a_38416_51940# VSS 0.85282f
C899 a_37772_51940# VSS 0.82939f
C900 a_37128_51940# VSS 0.83003f
C901 a_36484_51940# VSS 0.82469f
C902 a_35840_51940# VSS 0.8515f ; **FLOATING
C903 a_37337_52869# VSS 15.5078f ; **FLOATING
C904 a_34734_51940# VSS 0.39521f ; **FLOATING
C905 a_34324_51940# VSS 0.40738f ; **FLOATING
C906 a_33194_51940# VSS 0.39521f ; **FLOATING
C907 a_32784_51940# VSS 0.40738f ; **FLOATING
C908 a_31678_52282# VSS 0.2821f
C909 a_31220_52282# VSS 0.29425f
C910 a_30138_52282# VSS 0.28067f
C911 a_29680_52282# VSS 0.2961f
C912 a_28616_51940# VSS 0.85353f
C913 a_27972_51940# VSS 0.8409f
C914 a_27328_51940# VSS 0.83396f
C915 a_26684_51940# VSS 0.82532f
C916 a_26040_51940# VSS 0.84954f ; **FLOATING
C917 a_24934_51940# VSS 0.39521f ; **FLOATING
C918 a_24524_51940# VSS 0.40738f ; **FLOATING
C919 a_23394_51940# VSS 0.39521f ; **FLOATING
C920 a_22984_51940# VSS 0.40738f ; **FLOATING
C921 a_21878_52282# VSS 0.2821f
C922 a_21420_52282# VSS 0.29584f
C923 a_20338_52282# VSS 0.2833f
C924 a_19880_52282# VSS 0.29584f
C925 a_18816_51940# VSS 0.85942f
C926 a_18172_51940# VSS 0.82967f
C927 a_17528_51940# VSS 0.8248f
C928 a_16884_51940# VSS 0.82482f
C929 a_16240_51940# VSS 0.84894f ; **FLOATING
C930 a_17737_52869# VSS 15.5577f ; **FLOATING
C931 a_52654_56280# VSS 0.07326f
C932 a_52244_56280# VSS 0.07326f
C933 a_51114_56280# VSS 0.07326f
C934 a_50704_56280# VSS 0.07326f
C935 a_49598_56280# VSS 0.04627f
C936 a_49140_56280# VSS 0.04627f
C937 a_48058_56280# VSS 0.04627f
C938 a_47600_56280# VSS 0.04627f
C939 a_46412_56280# VSS 0.08258f
C940 a_45396_56280# VSS 0.05202f
C941 a_44380_56280# VSS 0.08258f
C942 a_43274_56280# VSS 0.07326f
C943 a_42864_56280# VSS 0.07326f
C944 a_41734_56280# VSS 0.07326f
C945 a_41324_56280# VSS 0.07326f
C946 a_40218_56280# VSS 0.04627f
C947 a_39760_56280# VSS 0.04627f
C948 a_38678_56280# VSS 0.04627f
C949 a_38220_56280# VSS 0.04627f
C950 a_37032_56280# VSS 0.08258f
C951 a_36325_56340# VSS 9.73211f ; **FLOATING
C952 a_36016_56280# VSS 0.05202f
C953 a_35309_56340# VSS 9.02329f ; **FLOATING
C954 a_35000_56280# VSS 0.08258f
C955 a_33894_56280# VSS 0.07326f
C956 a_33484_56280# VSS 0.07326f
C957 a_32354_56280# VSS 0.07326f
C958 a_31944_56280# VSS 0.07326f
C959 a_30838_56280# VSS 0.04627f
C960 a_30380_56280# VSS 0.04627f
C961 a_29298_56280# VSS 0.04627f
C962 a_28840_56280# VSS 0.04627f
C963 a_27652_56280# VSS 0.08258f
C964 a_26636_56280# VSS 0.05202f
C965 a_25620_56280# VSS 0.08258f
C966 a_26845_57069# VSS 10.2499f ; **FLOATING
C967 a_25829_57069# VSS 10.1823f ; **FLOATING
C968 a_24514_56280# VSS 0.07326f
C969 a_24104_56280# VSS 0.07326f
C970 a_22974_56280# VSS 0.07326f
C971 a_22564_56280# VSS 0.07326f
C972 a_21458_56280# VSS 0.04627f
C973 a_21000_56280# VSS 0.04627f
C974 a_19918_56280# VSS 0.04627f
C975 a_19460_56280# VSS 0.04627f
C976 a_18272_56280# VSS 0.08258f
C977 a_17193_52000# VSS 11.8812f ; **FLOATING
C978 a_17256_56280# VSS 0.05202f
C979 a_16549_52000# VSS 8.76548f ; **FLOATING
C980 a_16240_56280# VSS 0.08258f
C981 a_17093_52869# VSS 9.73873f ; **FLOATING
C982 a_16449_52869# VSS 9.70507f ; **FLOATING
C983 a_45676_64820# VSS 0.58425f ; **FLOATING
C984 a_45104_64820# VSS 0.58298f ; **FLOATING
C985 a_38956_64820# VSS 0.58425f ; **FLOATING
C986 a_38384_64820# VSS 0.58298f ; **FLOATING
C987 a_32236_64820# VSS 0.58425f ; **FLOATING
C988 a_31664_64820# VSS 0.58298f ; **FLOATING
C989 a_25516_64820# VSS 0.58425f ; **FLOATING
C990 a_24944_64820# VSS 0.58298f ; **FLOATING
C991 a_46000_69020# VSS 0.07989f
C992 a_45104_69020# VSS 0.07989f
C993 a_39280_69020# VSS 0.07989f
C994 a_38384_69020# VSS 0.07989f
C995 a_32560_69020# VSS 0.07989f
C996 a_31664_69020# VSS 0.07989f
C997 a_25840_69020# VSS 0.07989f
C998 a_24944_69020# VSS 0.07989f
C999 a_67214_77762# VSS 0.24358f
C1000 a_66804_77762# VSS 0.2518f ; **FLOATING
C1001 a_65534_77762# VSS 0.24128f
C1002 a_65124_77762# VSS 0.25327f ; **FLOATING
C1003 a_59374_77420# VSS 0.39521f
C1004 a_58964_77420# VSS 0.4082f ; **FLOATING
C1005 a_57694_77420# VSS 0.38483f
C1006 a_57400_77480# VSS 1.15362f ; **FLOATING
C1007 a_57284_77420# VSS 0.38539f
C1008 a_51534_77762# VSS 0.24358f
C1009 a_51124_77762# VSS 0.2518f ; **FLOATING
C1010 a_49854_77762# VSS 0.24128f
C1011 a_49444_77762# VSS 0.25327f ; **FLOATING
C1012 a_43694_77420# VSS 0.39521f
C1013 a_43284_77420# VSS 0.4082f ; **FLOATING
C1014 a_42014_77420# VSS 0.38483f
C1015 a_41720_77480# VSS 1.15362f ; **FLOATING
C1016 a_41604_77420# VSS 0.38539f
C1017 a_35854_77420# VSS 0.65977f
C1018 a_35444_77420# VSS 0.65883f
C1019 a_34174_77420# VSS 0.67777f
C1020 a_33764_77420# VSS 0.70598f
C1021 a_32494_77420# VSS 0.65883f
C1022 a_32200_77480# VSS 1.31911f ; **FLOATING
C1023 a_32084_77420# VSS 0.65774f
C1024 a_26334_77420# VSS 0.65977f
C1025 a_25924_77420# VSS 0.65883f
C1026 a_24654_77420# VSS 0.67777f
C1027 a_24244_77420# VSS 0.70598f
C1028 a_22974_77420# VSS 0.65883f
C1029 a_22680_77480# VSS 1.31911f ; **FLOATING
C1030 a_22564_77420# VSS 0.65774f
C1031 a_16814_77420# VSS 0.65977f
C1032 a_16404_77420# VSS 0.65883f
C1033 a_15134_77420# VSS 0.67777f
C1034 a_14724_77420# VSS 0.70598f
C1035 a_13454_77420# VSS 0.65883f
C1036 a_13160_77480# VSS 1.31911f ; **FLOATING
C1037 a_13044_77420# VSS 0.65774f
C1038 a_7294_77420# VSS 0.65977f
C1039 a_6884_77420# VSS 0.65883f
C1040 a_5614_77420# VSS 0.67777f
C1041 a_5204_77420# VSS 0.70598f
C1042 a_3934_77420# VSS 0.65883f
C1043 a_3640_77480# VSS 1.31911f ; **FLOATING
C1044 a_3524_77420# VSS 0.65774f
C1045 a_67214_81620# VSS 0.07326f
C1046 a_65385_77822# VSS 3.20709f ; **FLOATING
C1047 a_66804_81620# VSS 0.07326f
C1048 a_65534_81620# VSS 0.07326f
C1049 a_65385_81680# VSS 0.53402f ; **FLOATING
C1050 a_65124_81620# VSS 0.07326f
C1051 a_59374_81480# VSS 0.04368f
C1052 a_58964_81480# VSS 0.04368f
C1053 a_57694_81480# VSS 0.04368f
C1054 a_57545_77480# VSS 2.85213f ; **FLOATING
C1055 a_57284_81480# VSS 0.04368f
C1056 a_51534_81620# VSS 0.07326f
C1057 a_49705_77822# VSS 3.20273f ; **FLOATING
C1058 a_51124_81620# VSS 0.07326f
C1059 a_49854_81620# VSS 0.07326f
C1060 a_49705_81680# VSS 0.53402f ; **FLOATING
C1061 a_49444_81620# VSS 0.07326f
C1062 a_43694_81480# VSS 0.04368f
C1063 a_43284_81480# VSS 0.04368f
C1064 a_43427_78069# VSS 25.959f ; **FLOATING
C1065 a_42014_81480# VSS 0.04368f
C1066 a_41865_77480# VSS 2.30534f ; **FLOATING
C1067 a_41604_81480# VSS 0.04368f
C1068 a_38569_65609# VSS 23.7798f ; **FLOATING
C1069 a_32494_81760# VSS 0.67521f
C1070 a_32345_81820# VSS 3.03738f ; **FLOATING
C1071 a_32084_81760# VSS 0.71057f
C1072 a_22974_81760# VSS 0.67521f
C1073 a_22825_81820# VSS 3.6619f ; **FLOATING
C1074 a_22564_81760# VSS 0.71057f
C1075 a_13454_81760# VSS 0.67521f
C1076 a_13305_81820# VSS 3.66721f ; **FLOATING
C1077 a_13044_81760# VSS 0.71057f
C1078 a_3934_81760# VSS 0.67521f
C1079 a_3785_81820# VSS 3.6619f ; **FLOATING
C1080 a_3524_81760# VSS 0.71057f
C1081 a_35854_86100# VSS 0.13083f
C1082 a_35444_86100# VSS 0.13083f
C1083 a_34174_86100# VSS 0.13083f
C1084 a_33764_86100# VSS 0.13083f
C1085 a_32494_86100# VSS 0.13083f
C1086 a_32084_86100# VSS 0.13083f
C1087 a_26334_86100# VSS 0.13083f
C1088 a_25924_86100# VSS 0.13083f
C1089 a_24654_86100# VSS 0.13083f
C1090 a_24244_86100# VSS 0.13083f
C1091 a_22974_86100# VSS 0.13083f
C1092 a_22564_86100# VSS 0.13083f
C1093 a_16814_86100# VSS 0.13083f
C1094 a_16404_86100# VSS 0.13083f
C1095 a_15134_86100# VSS 0.13083f
C1096 a_14724_86100# VSS 0.13083f
C1097 a_13454_86100# VSS 0.13083f
C1098 a_13044_86100# VSS 0.13083f
C1099 a_7294_86100# VSS 0.13083f
C1100 a_6884_86100# VSS 0.13083f
C1101 a_5614_86100# VSS 0.13083f
C1102 a_5204_86100# VSS 0.13083f
C1103 a_3934_86100# VSS 0.13083f
C1104 a_3524_86100# VSS 0.13083f
C1105 a_32494_91280# VSS 0.13083f
C1106 a_32200_91340# VSS 2.79989f ; **FLOATING
C1107 a_32084_91280# VSS 0.13083f
C1108 a_24387_78349# VSS 25.2594f ; **FLOATING
C1109 a_22974_91280# VSS 0.13083f
C1110 a_22680_91340# VSS 2.80856f ; **FLOATING
C1111 a_22564_91280# VSS 0.13083f
C1112 a_22707_82689# VSS 22.7043f ; **FLOATING
C1113 a_13454_91280# VSS 0.13083f
C1114 a_13160_91340# VSS 2.82314f ; **FLOATING
C1115 a_13044_91280# VSS 0.13083f
C1116 a_3934_91280# VSS 0.13083f
C1117 a_3640_91340# VSS 2.80856f ; **FLOATING
C1118 a_3524_91280# VSS 0.13083f
C1119 a_45676_100660# VSS 0.58425f ; **FLOATING
C1120 a_45104_100660# VSS 0.58298f ; **FLOATING
C1121 a_38956_100660# VSS 0.58425f ; **FLOATING
C1122 a_38384_100660# VSS 0.58298f ; **FLOATING
C1123 a_32236_100660# VSS 0.58425f ; **FLOATING
C1124 a_31664_100660# VSS 0.58298f ; **FLOATING
C1125 a_25516_100660# VSS 0.58425f ; **FLOATING
C1126 a_24944_100660# VSS 0.58298f ; **FLOATING
C1127 a_46000_104860# VSS 0.07989f
C1128 a_45104_104860# VSS 0.07989f
C1129 a_32345_77480# VSS 17.3215f ; **FLOATING
C1130 a_39280_104860# VSS 0.07989f
C1131 a_38384_104860# VSS 0.07989f
C1132 a_22825_77480# VSS 20.6991f ; **FLOATING
C1133 a_32560_104860# VSS 0.07989f
C1134 a_31664_104860# VSS 0.07989f
C1135 a_13305_77480# VSS 22.1514f ; **FLOATING
C1136 a_25840_104860# VSS 0.07989f
C1137 a_24944_104860# VSS 0.07989f
C1138 a_3785_77480# VSS 22.1049f ; **FLOATING
C1139 a_3667_82689.t1 VSS 0.20842f ; **FLOATING
C1140 a_3667_82689.t6 VSS 0.19259f ; **FLOATING
C1141 a_3667_82689.t4 VSS 0.21428f ; **FLOATING
C1142 a_3667_82689.n0 VSS 2.84292f ; **FLOATING
C1143 a_3667_82689.t5 VSS 0.24824f ; **FLOATING
C1144 a_3667_82689.t3 VSS 0.21762f ; **FLOATING
C1145 a_3667_82689.n1 VSS 2.17651f ; **FLOATING
C1146 a_3667_82689.n2 VSS 5.72569f ; **FLOATING
C1147 a_3667_82689.t2 VSS 4.13504f ; **FLOATING
C1148 a_3667_82689.t0 VSS 0.37353f ; **FLOATING
C1149 a_5347_78349.t1 VSS 0.16228f ; **FLOATING
C1150 a_5347_78349.t6 VSS 0.14996f ; **FLOATING
C1151 a_5347_78349.t4 VSS 0.16684f ; **FLOATING
C1152 a_5347_78349.n0 VSS 1.77617f ; **FLOATING
C1153 a_5347_78349.t5 VSS 0.19329f ; **FLOATING
C1154 a_5347_78349.t3 VSS 0.16945f ; **FLOATING
C1155 a_5347_78349.n1 VSS 2.13281f ; **FLOATING
C1156 a_5347_78349.n2 VSS 4.86124f ; **FLOATING
C1157 a_5347_78349.t2 VSS 3.5661f ; **FLOATING
C1158 a_5347_78349.t0 VSS 0.29084f ; **FLOATING
C1159 a_3667_78349.t1 VSS 0.16753f ; **FLOATING
C1160 a_3667_78349.t3 VSS 0.08423f ; **FLOATING
C1161 a_3667_78349.t5 VSS 0.25727f ; **FLOATING
C1162 a_3667_78349.n0 VSS 1.59077f ; **FLOATING
C1163 a_3667_78349.t4 VSS 0.08423f ; **FLOATING
C1164 a_3667_78349.t6 VSS 0.25727f ; **FLOATING
C1165 a_3667_78349.n1 VSS 2.07011f ; **FLOATING
C1166 a_3667_78349.n2 VSS 4.47892f ; **FLOATING
C1167 a_3667_78349.t2 VSS 3.64473f ; **FLOATING
C1168 a_3667_78349.t0 VSS 0.30025f ; **FLOATING
C1169 a_7027_78349.t1 VSS 0.16064f ; **FLOATING
C1170 a_7027_78349.t5 VSS 0.1453f ; **FLOATING
C1171 a_7027_78349.t3 VSS 0.16964f ; **FLOATING
C1172 a_7027_78349.n0 VSS 1.51768f ; **FLOATING
C1173 a_7027_78349.t6 VSS 0.1453f ; **FLOATING
C1174 a_7027_78349.t4 VSS 0.16964f ; **FLOATING
C1175 a_7027_78349.n1 VSS 2.03997f ; **FLOATING
C1176 a_7027_78349.n2 VSS 5.62242f ; **FLOATING
C1177 a_7027_78349.t2 VSS 4.26262f ; **FLOATING
C1178 a_7027_78349.t0 VSS 0.2879f ; **FLOATING
C1179 a_22707_78349.t1 VSS 0.19475f ; **FLOATING
C1180 a_22707_78349.t3 VSS 0.09792f ; **FLOATING
C1181 a_22707_78349.t5 VSS 0.29907f ; **FLOATING
C1182 a_22707_78349.n0 VSS 1.84924f ; **FLOATING
C1183 a_22707_78349.t4 VSS 0.09792f ; **FLOATING
C1184 a_22707_78349.t6 VSS 0.29907f ; **FLOATING
C1185 a_22707_78349.n1 VSS 2.40646f ; **FLOATING
C1186 a_22707_78349.n2 VSS 4.8262f ; **FLOATING
C1187 a_22707_78349.t2 VSS 3.94864f ; **FLOATING
C1188 a_22707_78349.t0 VSS 0.34903f ; **FLOATING
C1189 a_26067_78349.t1 VSS 0.18182f ; **FLOATING
C1190 a_26067_78349.t5 VSS 0.16446f ; **FLOATING
C1191 a_26067_78349.t3 VSS 0.19201f ; **FLOATING
C1192 a_26067_78349.n0 VSS 1.71784f ; **FLOATING
C1193 a_26067_78349.t6 VSS 0.16446f ; **FLOATING
C1194 a_26067_78349.t4 VSS 0.19201f ; **FLOATING
C1195 a_26067_78349.n1 VSS 2.309f ; **FLOATING
C1196 a_26067_78349.n2 VSS 5.84309f ; **FLOATING
C1197 a_26067_78349.t2 VSS 4.72123f ; **FLOATING
C1198 a_26067_78349.t0 VSS 0.32587f ; **FLOATING
C1199 a_25129_65609.t3 VSS 0.05443f ; **FLOATING
C1200 a_25129_65609.t5 VSS 0.18162f ; **FLOATING
C1201 a_25129_65609.n0 VSS 1.42503f ; **FLOATING
C1202 a_25129_65609.t4 VSS 0.07203f ; **FLOATING
C1203 a_25129_65609.t6 VSS 0.15989f ; **FLOATING
C1204 a_25129_65609.n1 VSS 1.15135f ; **FLOATING
C1205 a_25129_65609.n2 VSS 4.20169f ; **FLOATING
C1206 a_25129_65609.t2 VSS 7.12746f ; **FLOATING
C1207 a_25129_65609.t1 VSS 2.35791f ; **FLOATING
C1208 a_25129_65609.t0 VSS 0.29245f ; **FLOATING
C1209 a_31849_65609.t5 VSS 0.09625f ; **FLOATING
C1210 a_31849_65609.t3 VSS 0.07937f ; **FLOATING
C1211 a_31849_65609.n0 VSS 1.47657f ; **FLOATING
C1212 a_31849_65609.t6 VSS 0.07085f ; **FLOATING
C1213 a_31849_65609.t4 VSS 0.08778f ; **FLOATING
C1214 a_31849_65609.n1 VSS 0.95253f ; **FLOATING
C1215 a_31849_65609.n2 VSS 3.37388f ; **FLOATING
C1216 a_31849_65609.t2 VSS 5.68624f ; **FLOATING
C1217 a_31849_65609.t1 VSS 1.49426f ; **FLOATING
C1218 a_31849_65609.t0 VSS 0.24835f ; **FLOATING
C1219 a_22825_56340.t2 VSS 0.05455f ; **FLOATING
C1220 a_22825_56340.t4 VSS 0.18203f ; **FLOATING
C1221 a_22825_56340.n0 VSS 1.5139f ; **FLOATING
C1222 a_22825_56340.t3 VSS 0.07219f ; **FLOATING
C1223 a_22825_56340.t5 VSS 0.16025f ; **FLOATING
C1224 a_22825_56340.n1 VSS 1.0269f ; **FLOATING
C1225 a_22825_56340.n2 VSS 3.58965f ; **FLOATING
C1226 a_22825_56340.t6 VSS 6.80708f ; **FLOATING
C1227 a_22825_56340.t1 VSS 1.50117f ; **FLOATING
C1228 a_22825_56340.t0 VSS 0.59002f ; **FLOATING
C1229 a_24365_56340.t4 VSS 0.09626f ; **FLOATING
C1230 a_24365_56340.t2 VSS 0.07937f ; **FLOATING
C1231 a_24365_56340.n0 VSS 1.29807f ; **FLOATING
C1232 a_24365_56340.t5 VSS 0.07086f ; **FLOATING
C1233 a_24365_56340.t3 VSS 0.08778f ; **FLOATING
C1234 a_24365_56340.n1 VSS 1.02394f ; **FLOATING
C1235 a_24365_56340.n2 VSS 3.10485f ; **FLOATING
C1236 a_24365_56340.t6 VSS 5.4036f ; **FLOATING
C1237 a_24365_56340.t1 VSS 1.84638f ; **FLOATING
C1238 a_24365_56340.t0 VSS 0.39334f ; **FLOATING
C1239 a_8707_27249.t3 VSS 0.05103f ; **FLOATING
C1240 a_8707_27249.t5 VSS 0.11328f ; **FLOATING
C1241 a_8707_27249.n0 VSS 1.07107f ; **FLOATING
C1242 a_8707_27249.t2 VSS 0.03856f ; **FLOATING
C1243 a_8707_27249.t4 VSS 0.12868f ; **FLOATING
C1244 a_8707_27249.n1 VSS 0.79994f ; **FLOATING
C1245 a_8707_27249.n2 VSS 2.35074f ; **FLOATING
C1246 a_8707_27249.t6 VSS 4.86295f ; **FLOATING
C1247 a_8707_27249.t1 VSS 1.37895f ; **FLOATING
C1248 a_8707_27249.t0 VSS 0.44059f ; **FLOATING
C1249 a_10387_27249.t4 VSS 0.09939f ; **FLOATING
C1250 a_10387_27249.t2 VSS 0.08195f ; **FLOATING
C1251 a_10387_27249.n0 VSS 0.88368f ; **FLOATING
C1252 a_10387_27249.t5 VSS 0.07316f ; **FLOATING
C1253 a_10387_27249.t3 VSS 0.09064f ; **FLOATING
C1254 a_10387_27249.n1 VSS 1.31991f ; **FLOATING
C1255 a_10387_27249.n2 VSS 3.64324f ; **FLOATING
C1256 a_10387_27249.t9 VSS 0.06586f ; **FLOATING
C1257 a_10387_27249.t8 VSS 0.07471f ; **FLOATING
C1258 a_10387_27249.n3 VSS 0.09264f ; **FLOATING
C1259 a_10387_27249.t10 VSS 0.06586f ; **FLOATING
C1260 a_10387_27249.t11 VSS 0.07471f ; **FLOATING
C1261 a_10387_27249.n4 VSS 0.09264f ; **FLOATING
C1262 a_10387_27249.n5 VSS 0.37626f ; **FLOATING
C1263 a_10387_27249.t6 VSS 0.06991f ; **FLOATING
C1264 a_10387_27249.t7 VSS 0.06991f ; **FLOATING
C1265 a_10387_27249.n6 VSS 0.39246f ; **FLOATING
C1266 a_10387_27249.n7 VSS 0.86851f ; **FLOATING
C1267 a_10387_27249.n8 VSS 4.50114f ; **FLOATING
C1268 a_10387_27249.t1 VSS 1.93732f ; **FLOATING
C1269 a_10387_27249.t0 VSS 0.57778f ; **FLOATING
C1270 a_35769_13109.t17 VSS 0.1692f ; **FLOATING
C1271 a_35769_13109.t16 VSS 0.1692f ; **FLOATING
C1272 a_35769_13109.t15 VSS 0.1692f ; **FLOATING
C1273 a_35769_13109.t14 VSS 0.1692f ; **FLOATING
C1274 a_35769_13109.t13 VSS 0.1692f ; **FLOATING
C1275 a_35769_13109.t12 VSS 0.1692f ; **FLOATING
C1276 a_35769_13109.t11 VSS 0.1692f ; **FLOATING
C1277 a_35769_13109.t10 VSS 0.1692f ; **FLOATING
C1278 a_35769_13109.t9 VSS 0.1692f ; **FLOATING
C1279 a_35769_13109.t8 VSS 0.1692f ; **FLOATING
C1280 a_35769_13109.t7 VSS 0.1692f ; **FLOATING
C1281 a_35769_13109.t6 VSS 0.1692f ; **FLOATING
C1282 a_35769_13109.t5 VSS 0.1692f ; **FLOATING
C1283 a_35769_13109.t4 VSS 0.1692f ; **FLOATING
C1284 a_35769_13109.t3 VSS 0.1692f ; **FLOATING
C1285 a_35769_13109.t2 VSS 0.1821f ; **FLOATING
C1286 a_35769_13109.n0 VSS 0.21264f ; **FLOATING
C1287 a_35769_13109.n1 VSS 0.11852f ; **FLOATING
C1288 a_35769_13109.n2 VSS 0.11852f ; **FLOATING
C1289 a_35769_13109.n3 VSS 0.11852f ; **FLOATING
C1290 a_35769_13109.n4 VSS 0.11852f ; **FLOATING
C1291 a_35769_13109.n5 VSS 0.11852f ; **FLOATING
C1292 a_35769_13109.n6 VSS 0.11852f ; **FLOATING
C1293 a_35769_13109.n7 VSS 0.11852f ; **FLOATING
C1294 a_35769_13109.n8 VSS 0.11852f ; **FLOATING
C1295 a_35769_13109.n9 VSS 0.11852f ; **FLOATING
C1296 a_35769_13109.n10 VSS 0.11852f ; **FLOATING
C1297 a_35769_13109.n11 VSS 0.11852f ; **FLOATING
C1298 a_35769_13109.n12 VSS 0.11852f ; **FLOATING
C1299 a_35769_13109.n13 VSS 0.11852f ; **FLOATING
C1300 a_35769_13109.n14 VSS 0.10441f ; **FLOATING
C1301 a_35769_13109.t18 VSS 0.1692f ; **FLOATING
C1302 a_35769_13109.t19 VSS 0.1692f ; **FLOATING
C1303 a_35769_13109.t20 VSS 0.1692f ; **FLOATING
C1304 a_35769_13109.t21 VSS 0.1692f ; **FLOATING
C1305 a_35769_13109.t22 VSS 0.1692f ; **FLOATING
C1306 a_35769_13109.t23 VSS 0.1692f ; **FLOATING
C1307 a_35769_13109.t24 VSS 0.1692f ; **FLOATING
C1308 a_35769_13109.t25 VSS 0.1692f ; **FLOATING
C1309 a_35769_13109.t26 VSS 0.1692f ; **FLOATING
C1310 a_35769_13109.t27 VSS 0.1692f ; **FLOATING
C1311 a_35769_13109.t28 VSS 0.1692f ; **FLOATING
C1312 a_35769_13109.t29 VSS 0.1692f ; **FLOATING
C1313 a_35769_13109.t30 VSS 0.1692f ; **FLOATING
C1314 a_35769_13109.t31 VSS 0.1692f ; **FLOATING
C1315 a_35769_13109.t32 VSS 0.1692f ; **FLOATING
C1316 a_35769_13109.t33 VSS 0.1821f ; **FLOATING
C1317 a_35769_13109.n15 VSS 0.21264f ; **FLOATING
C1318 a_35769_13109.n16 VSS 0.11852f ; **FLOATING
C1319 a_35769_13109.n17 VSS 0.11852f ; **FLOATING
C1320 a_35769_13109.n18 VSS 0.11852f ; **FLOATING
C1321 a_35769_13109.n19 VSS 0.11852f ; **FLOATING
C1322 a_35769_13109.n20 VSS 0.11852f ; **FLOATING
C1323 a_35769_13109.n21 VSS 0.11852f ; **FLOATING
C1324 a_35769_13109.n22 VSS 0.11852f ; **FLOATING
C1325 a_35769_13109.n23 VSS 0.11852f ; **FLOATING
C1326 a_35769_13109.n24 VSS 0.11852f ; **FLOATING
C1327 a_35769_13109.n25 VSS 0.11852f ; **FLOATING
C1328 a_35769_13109.n26 VSS 0.11852f ; **FLOATING
C1329 a_35769_13109.n27 VSS 0.11852f ; **FLOATING
C1330 a_35769_13109.n28 VSS 0.11852f ; **FLOATING
C1331 a_35769_13109.n29 VSS 0.10441f ; **FLOATING
C1332 a_35769_13109.n30 VSS 2.55899f ; **FLOATING
C1333 a_35769_13109.t49 VSS 0.17197f ; **FLOATING
C1334 a_35769_13109.t48 VSS 0.17197f ; **FLOATING
C1335 a_35769_13109.t47 VSS 0.17197f ; **FLOATING
C1336 a_35769_13109.t46 VSS 0.17197f ; **FLOATING
C1337 a_35769_13109.t45 VSS 0.17197f ; **FLOATING
C1338 a_35769_13109.t44 VSS 0.17197f ; **FLOATING
C1339 a_35769_13109.t43 VSS 0.17197f ; **FLOATING
C1340 a_35769_13109.t42 VSS 0.17197f ; **FLOATING
C1341 a_35769_13109.t41 VSS 0.17197f ; **FLOATING
C1342 a_35769_13109.t40 VSS 0.17197f ; **FLOATING
C1343 a_35769_13109.t39 VSS 0.17197f ; **FLOATING
C1344 a_35769_13109.t38 VSS 0.17197f ; **FLOATING
C1345 a_35769_13109.t37 VSS 0.17197f ; **FLOATING
C1346 a_35769_13109.t36 VSS 0.17197f ; **FLOATING
C1347 a_35769_13109.t35 VSS 0.17197f ; **FLOATING
C1348 a_35769_13109.t34 VSS 0.18471f ; **FLOATING
C1349 a_35769_13109.n31 VSS 0.21836f ; **FLOATING
C1350 a_35769_13109.n32 VSS 0.12129f ; **FLOATING
C1351 a_35769_13109.n33 VSS 0.12129f ; **FLOATING
C1352 a_35769_13109.n34 VSS 0.12129f ; **FLOATING
C1353 a_35769_13109.n35 VSS 0.12129f ; **FLOATING
C1354 a_35769_13109.n36 VSS 0.12129f ; **FLOATING
C1355 a_35769_13109.n37 VSS 0.12129f ; **FLOATING
C1356 a_35769_13109.n38 VSS 0.12129f ; **FLOATING
C1357 a_35769_13109.n39 VSS 0.12129f ; **FLOATING
C1358 a_35769_13109.n40 VSS 0.12129f ; **FLOATING
C1359 a_35769_13109.n41 VSS 0.12129f ; **FLOATING
C1360 a_35769_13109.n42 VSS 0.12129f ; **FLOATING
C1361 a_35769_13109.n43 VSS 0.12129f ; **FLOATING
C1362 a_35769_13109.n44 VSS 0.12129f ; **FLOATING
C1363 a_35769_13109.n45 VSS 0.10718f ; **FLOATING
C1364 a_35769_13109.t50 VSS 0.17197f ; **FLOATING
C1365 a_35769_13109.t51 VSS 0.17197f ; **FLOATING
C1366 a_35769_13109.t52 VSS 0.17197f ; **FLOATING
C1367 a_35769_13109.t53 VSS 0.17197f ; **FLOATING
C1368 a_35769_13109.t54 VSS 0.17197f ; **FLOATING
C1369 a_35769_13109.t55 VSS 0.17197f ; **FLOATING
C1370 a_35769_13109.t56 VSS 0.17197f ; **FLOATING
C1371 a_35769_13109.t57 VSS 0.17197f ; **FLOATING
C1372 a_35769_13109.t58 VSS 0.17197f ; **FLOATING
C1373 a_35769_13109.t59 VSS 0.17197f ; **FLOATING
C1374 a_35769_13109.t60 VSS 0.17197f ; **FLOATING
C1375 a_35769_13109.t61 VSS 0.17197f ; **FLOATING
C1376 a_35769_13109.t62 VSS 0.17197f ; **FLOATING
C1377 a_35769_13109.t63 VSS 0.17197f ; **FLOATING
C1378 a_35769_13109.t64 VSS 0.17197f ; **FLOATING
C1379 a_35769_13109.t65 VSS 0.18471f ; **FLOATING
C1380 a_35769_13109.n46 VSS 0.21836f ; **FLOATING
C1381 a_35769_13109.n47 VSS 0.12129f ; **FLOATING
C1382 a_35769_13109.n48 VSS 0.12129f ; **FLOATING
C1383 a_35769_13109.n49 VSS 0.12129f ; **FLOATING
C1384 a_35769_13109.n50 VSS 0.12129f ; **FLOATING
C1385 a_35769_13109.n51 VSS 0.12129f ; **FLOATING
C1386 a_35769_13109.n52 VSS 0.12129f ; **FLOATING
C1387 a_35769_13109.n53 VSS 0.12129f ; **FLOATING
C1388 a_35769_13109.n54 VSS 0.12129f ; **FLOATING
C1389 a_35769_13109.n55 VSS 0.12129f ; **FLOATING
C1390 a_35769_13109.n56 VSS 0.12129f ; **FLOATING
C1391 a_35769_13109.n57 VSS 0.12129f ; **FLOATING
C1392 a_35769_13109.n58 VSS 0.12129f ; **FLOATING
C1393 a_35769_13109.n59 VSS 0.12129f ; **FLOATING
C1394 a_35769_13109.n60 VSS 0.10718f ; **FLOATING
C1395 a_35769_13109.n61 VSS 2.47175f ; **FLOATING
C1396 a_35769_13109.n62 VSS 2.56582f ; **FLOATING
C1397 a_35769_13109.t0 VSS 3.67118f ; **FLOATING
C1398 a_35769_13109.t1 VSS 0.45947f ; **FLOATING
C1399 a_17709_13109.t9 VSS 0.57869f ; **FLOATING
C1400 a_17709_13109.t12 VSS 0.58265f ; **FLOATING
C1401 a_17709_13109.t11 VSS 0.57169f ; **FLOATING
C1402 a_17709_13109.t120 VSS 0.19671f ; **FLOATING
C1403 a_17709_13109.t119 VSS 0.19671f ; **FLOATING
C1404 a_17709_13109.t118 VSS 0.19671f ; **FLOATING
C1405 a_17709_13109.t117 VSS 0.19671f ; **FLOATING
C1406 a_17709_13109.t116 VSS 0.19671f ; **FLOATING
C1407 a_17709_13109.t115 VSS 0.19671f ; **FLOATING
C1408 a_17709_13109.t3 VSS 0.19671f ; **FLOATING
C1409 a_17709_13109.t4 VSS 0.19671f ; **FLOATING
C1410 a_17709_13109.t114 VSS 0.19671f ; **FLOATING
C1411 a_17709_13109.t113 VSS 0.19671f ; **FLOATING
C1412 a_17709_13109.t112 VSS 0.19671f ; **FLOATING
C1413 a_17709_13109.t111 VSS 0.19671f ; **FLOATING
C1414 a_17709_13109.t110 VSS 0.19671f ; **FLOATING
C1415 a_17709_13109.t109 VSS 0.19671f ; **FLOATING
C1416 a_17709_13109.t108 VSS 0.19671f ; **FLOATING
C1417 a_17709_13109.t107 VSS 0.19671f ; **FLOATING
C1418 a_17709_13109.t106 VSS 0.19671f ; **FLOATING
C1419 a_17709_13109.t105 VSS 0.19671f ; **FLOATING
C1420 a_17709_13109.t104 VSS 0.19671f ; **FLOATING
C1421 a_17709_13109.t103 VSS 0.19671f ; **FLOATING
C1422 a_17709_13109.t102 VSS 0.19671f ; **FLOATING
C1423 a_17709_13109.t101 VSS 0.19671f ; **FLOATING
C1424 a_17709_13109.t100 VSS 0.19671f ; **FLOATING
C1425 a_17709_13109.t99 VSS 0.19671f ; **FLOATING
C1426 a_17709_13109.t98 VSS 0.19671f ; **FLOATING
C1427 a_17709_13109.t97 VSS 0.19671f ; **FLOATING
C1428 a_17709_13109.t96 VSS 0.19671f ; **FLOATING
C1429 a_17709_13109.t95 VSS 0.19671f ; **FLOATING
C1430 a_17709_13109.t94 VSS 0.19671f ; **FLOATING
C1431 a_17709_13109.t93 VSS 0.19671f ; **FLOATING
C1432 a_17709_13109.t92 VSS 0.19671f ; **FLOATING
C1433 a_17709_13109.t91 VSS 0.19671f ; **FLOATING
C1434 a_17709_13109.t90 VSS 0.19671f ; **FLOATING
C1435 a_17709_13109.t89 VSS 0.19671f ; **FLOATING
C1436 a_17709_13109.t88 VSS 0.19671f ; **FLOATING
C1437 a_17709_13109.t87 VSS 0.19671f ; **FLOATING
C1438 a_17709_13109.t86 VSS 0.19671f ; **FLOATING
C1439 a_17709_13109.t85 VSS 0.21128f ; **FLOATING
C1440 a_17709_13109.n0 VSS 0.24977f ; **FLOATING
C1441 a_17709_13109.n1 VSS 0.13874f ; **FLOATING
C1442 a_17709_13109.n2 VSS 0.13874f ; **FLOATING
C1443 a_17709_13109.n3 VSS 0.13874f ; **FLOATING
C1444 a_17709_13109.n4 VSS 0.13874f ; **FLOATING
C1445 a_17709_13109.n5 VSS 0.13874f ; **FLOATING
C1446 a_17709_13109.n6 VSS 0.13874f ; **FLOATING
C1447 a_17709_13109.n7 VSS 0.13874f ; **FLOATING
C1448 a_17709_13109.n8 VSS 0.13874f ; **FLOATING
C1449 a_17709_13109.n9 VSS 0.13874f ; **FLOATING
C1450 a_17709_13109.n10 VSS 0.13874f ; **FLOATING
C1451 a_17709_13109.n11 VSS 0.13874f ; **FLOATING
C1452 a_17709_13109.n12 VSS 0.13874f ; **FLOATING
C1453 a_17709_13109.n13 VSS 0.13874f ; **FLOATING
C1454 a_17709_13109.n14 VSS 0.13874f ; **FLOATING
C1455 a_17709_13109.n15 VSS 0.13874f ; **FLOATING
C1456 a_17709_13109.n16 VSS 0.13874f ; **FLOATING
C1457 a_17709_13109.n17 VSS 0.13874f ; **FLOATING
C1458 a_17709_13109.n18 VSS 0.13874f ; **FLOATING
C1459 a_17709_13109.n19 VSS 0.13874f ; **FLOATING
C1460 a_17709_13109.n20 VSS 0.13874f ; **FLOATING
C1461 a_17709_13109.n21 VSS 0.13874f ; **FLOATING
C1462 a_17709_13109.n22 VSS 0.13874f ; **FLOATING
C1463 a_17709_13109.n23 VSS 0.13874f ; **FLOATING
C1464 a_17709_13109.n24 VSS 0.13874f ; **FLOATING
C1465 a_17709_13109.n25 VSS 0.13874f ; **FLOATING
C1466 a_17709_13109.n26 VSS 0.13874f ; **FLOATING
C1467 a_17709_13109.n27 VSS 0.13874f ; **FLOATING
C1468 a_17709_13109.n28 VSS 0.13874f ; **FLOATING
C1469 a_17709_13109.n29 VSS 0.13874f ; **FLOATING
C1470 a_17709_13109.n30 VSS 0.13874f ; **FLOATING
C1471 a_17709_13109.n31 VSS 0.13874f ; **FLOATING
C1472 a_17709_13109.n32 VSS 0.13874f ; **FLOATING
C1473 a_17709_13109.n33 VSS 0.13874f ; **FLOATING
C1474 a_17709_13109.n34 VSS 0.13874f ; **FLOATING
C1475 a_17709_13109.n35 VSS 0.13874f ; **FLOATING
C1476 a_17709_13109.n36 VSS 0.1226f ; **FLOATING
C1477 a_17709_13109.t121 VSS 0.19671f ; **FLOATING
C1478 a_17709_13109.t122 VSS 0.19671f ; **FLOATING
C1479 a_17709_13109.t123 VSS 0.19671f ; **FLOATING
C1480 a_17709_13109.t124 VSS 0.19671f ; **FLOATING
C1481 a_17709_13109.t125 VSS 0.19671f ; **FLOATING
C1482 a_17709_13109.t126 VSS 0.19671f ; **FLOATING
C1483 a_17709_13109.t2 VSS 0.19671f ; **FLOATING
C1484 a_17709_13109.t0 VSS 0.19671f ; **FLOATING
C1485 a_17709_13109.t127 VSS 0.19671f ; **FLOATING
C1486 a_17709_13109.t128 VSS 0.19671f ; **FLOATING
C1487 a_17709_13109.t129 VSS 0.19671f ; **FLOATING
C1488 a_17709_13109.t130 VSS 0.19671f ; **FLOATING
C1489 a_17709_13109.t131 VSS 0.19671f ; **FLOATING
C1490 a_17709_13109.t132 VSS 0.19671f ; **FLOATING
C1491 a_17709_13109.t133 VSS 0.19671f ; **FLOATING
C1492 a_17709_13109.t134 VSS 0.19671f ; **FLOATING
C1493 a_17709_13109.t135 VSS 0.19671f ; **FLOATING
C1494 a_17709_13109.t136 VSS 0.19671f ; **FLOATING
C1495 a_17709_13109.t137 VSS 0.19671f ; **FLOATING
C1496 a_17709_13109.t138 VSS 0.19671f ; **FLOATING
C1497 a_17709_13109.t139 VSS 0.19671f ; **FLOATING
C1498 a_17709_13109.t140 VSS 0.19671f ; **FLOATING
C1499 a_17709_13109.t141 VSS 0.19671f ; **FLOATING
C1500 a_17709_13109.t142 VSS 0.19671f ; **FLOATING
C1501 a_17709_13109.t143 VSS 0.19671f ; **FLOATING
C1502 a_17709_13109.t144 VSS 0.19671f ; **FLOATING
C1503 a_17709_13109.t145 VSS 0.19671f ; **FLOATING
C1504 a_17709_13109.t146 VSS 0.19671f ; **FLOATING
C1505 a_17709_13109.t147 VSS 0.19671f ; **FLOATING
C1506 a_17709_13109.t148 VSS 0.19671f ; **FLOATING
C1507 a_17709_13109.t149 VSS 0.19671f ; **FLOATING
C1508 a_17709_13109.t150 VSS 0.19671f ; **FLOATING
C1509 a_17709_13109.t151 VSS 0.19671f ; **FLOATING
C1510 a_17709_13109.t152 VSS 0.19671f ; **FLOATING
C1511 a_17709_13109.t153 VSS 0.19671f ; **FLOATING
C1512 a_17709_13109.t154 VSS 0.19671f ; **FLOATING
C1513 a_17709_13109.t155 VSS 0.19671f ; **FLOATING
C1514 a_17709_13109.t156 VSS 0.21128f ; **FLOATING
C1515 a_17709_13109.n37 VSS 0.24977f ; **FLOATING
C1516 a_17709_13109.n38 VSS 0.13874f ; **FLOATING
C1517 a_17709_13109.n39 VSS 0.13874f ; **FLOATING
C1518 a_17709_13109.n40 VSS 0.13874f ; **FLOATING
C1519 a_17709_13109.n41 VSS 0.13874f ; **FLOATING
C1520 a_17709_13109.n42 VSS 0.13874f ; **FLOATING
C1521 a_17709_13109.n43 VSS 0.13874f ; **FLOATING
C1522 a_17709_13109.n44 VSS 0.13874f ; **FLOATING
C1523 a_17709_13109.n45 VSS 0.13874f ; **FLOATING
C1524 a_17709_13109.n46 VSS 0.13874f ; **FLOATING
C1525 a_17709_13109.n47 VSS 0.13874f ; **FLOATING
C1526 a_17709_13109.n48 VSS 0.13874f ; **FLOATING
C1527 a_17709_13109.n49 VSS 0.13874f ; **FLOATING
C1528 a_17709_13109.n50 VSS 0.13874f ; **FLOATING
C1529 a_17709_13109.n51 VSS 0.13874f ; **FLOATING
C1530 a_17709_13109.n52 VSS 0.13874f ; **FLOATING
C1531 a_17709_13109.n53 VSS 0.13874f ; **FLOATING
C1532 a_17709_13109.n54 VSS 0.13874f ; **FLOATING
C1533 a_17709_13109.n55 VSS 0.13874f ; **FLOATING
C1534 a_17709_13109.n56 VSS 0.13874f ; **FLOATING
C1535 a_17709_13109.n57 VSS 0.13874f ; **FLOATING
C1536 a_17709_13109.n58 VSS 0.13874f ; **FLOATING
C1537 a_17709_13109.n59 VSS 0.13874f ; **FLOATING
C1538 a_17709_13109.n60 VSS 0.13874f ; **FLOATING
C1539 a_17709_13109.n61 VSS 0.13874f ; **FLOATING
C1540 a_17709_13109.n62 VSS 0.13874f ; **FLOATING
C1541 a_17709_13109.n63 VSS 0.13874f ; **FLOATING
C1542 a_17709_13109.n64 VSS 0.13874f ; **FLOATING
C1543 a_17709_13109.n65 VSS 0.13874f ; **FLOATING
C1544 a_17709_13109.n66 VSS 0.13874f ; **FLOATING
C1545 a_17709_13109.n67 VSS 0.13874f ; **FLOATING
C1546 a_17709_13109.n68 VSS 0.13874f ; **FLOATING
C1547 a_17709_13109.n69 VSS 0.13874f ; **FLOATING
C1548 a_17709_13109.n70 VSS 0.13874f ; **FLOATING
C1549 a_17709_13109.n71 VSS 0.13874f ; **FLOATING
C1550 a_17709_13109.n72 VSS 0.13874f ; **FLOATING
C1551 a_17709_13109.n73 VSS 0.1226f ; **FLOATING
C1552 a_17709_13109.n74 VSS 6.7183f ; **FLOATING
C1553 a_17709_13109.n75 VSS 2.58502f ; **FLOATING
C1554 a_17709_13109.t48 VSS 0.19354f ; **FLOATING
C1555 a_17709_13109.t47 VSS 0.19354f ; **FLOATING
C1556 a_17709_13109.t46 VSS 0.19354f ; **FLOATING
C1557 a_17709_13109.t45 VSS 0.19354f ; **FLOATING
C1558 a_17709_13109.t44 VSS 0.19354f ; **FLOATING
C1559 a_17709_13109.t43 VSS 0.19354f ; **FLOATING
C1560 a_17709_13109.t8 VSS 0.19354f ; **FLOATING
C1561 a_17709_13109.t10 VSS 0.19354f ; **FLOATING
C1562 a_17709_13109.t42 VSS 0.19354f ; **FLOATING
C1563 a_17709_13109.t41 VSS 0.19354f ; **FLOATING
C1564 a_17709_13109.t40 VSS 0.19354f ; **FLOATING
C1565 a_17709_13109.t39 VSS 0.19354f ; **FLOATING
C1566 a_17709_13109.t38 VSS 0.19354f ; **FLOATING
C1567 a_17709_13109.t37 VSS 0.19354f ; **FLOATING
C1568 a_17709_13109.t36 VSS 0.19354f ; **FLOATING
C1569 a_17709_13109.t35 VSS 0.19354f ; **FLOATING
C1570 a_17709_13109.t34 VSS 0.19354f ; **FLOATING
C1571 a_17709_13109.t33 VSS 0.19354f ; **FLOATING
C1572 a_17709_13109.t32 VSS 0.19354f ; **FLOATING
C1573 a_17709_13109.t31 VSS 0.19354f ; **FLOATING
C1574 a_17709_13109.t30 VSS 0.19354f ; **FLOATING
C1575 a_17709_13109.t29 VSS 0.19354f ; **FLOATING
C1576 a_17709_13109.t28 VSS 0.19354f ; **FLOATING
C1577 a_17709_13109.t27 VSS 0.19354f ; **FLOATING
C1578 a_17709_13109.t26 VSS 0.19354f ; **FLOATING
C1579 a_17709_13109.t25 VSS 0.19354f ; **FLOATING
C1580 a_17709_13109.t24 VSS 0.19354f ; **FLOATING
C1581 a_17709_13109.t23 VSS 0.19354f ; **FLOATING
C1582 a_17709_13109.t22 VSS 0.19354f ; **FLOATING
C1583 a_17709_13109.t21 VSS 0.19354f ; **FLOATING
C1584 a_17709_13109.t20 VSS 0.19354f ; **FLOATING
C1585 a_17709_13109.t19 VSS 0.19354f ; **FLOATING
C1586 a_17709_13109.t18 VSS 0.19354f ; **FLOATING
C1587 a_17709_13109.t17 VSS 0.19354f ; **FLOATING
C1588 a_17709_13109.t16 VSS 0.19354f ; **FLOATING
C1589 a_17709_13109.t15 VSS 0.19354f ; **FLOATING
C1590 a_17709_13109.t14 VSS 0.19354f ; **FLOATING
C1591 a_17709_13109.t13 VSS 0.20829f ; **FLOATING
C1592 a_17709_13109.n76 VSS 0.24323f ; **FLOATING
C1593 a_17709_13109.n77 VSS 0.13557f ; **FLOATING
C1594 a_17709_13109.n78 VSS 0.13557f ; **FLOATING
C1595 a_17709_13109.n79 VSS 0.13557f ; **FLOATING
C1596 a_17709_13109.n80 VSS 0.13557f ; **FLOATING
C1597 a_17709_13109.n81 VSS 0.13557f ; **FLOATING
C1598 a_17709_13109.n82 VSS 0.13557f ; **FLOATING
C1599 a_17709_13109.n83 VSS 0.13557f ; **FLOATING
C1600 a_17709_13109.n84 VSS 0.13557f ; **FLOATING
C1601 a_17709_13109.n85 VSS 0.13557f ; **FLOATING
C1602 a_17709_13109.n86 VSS 0.13557f ; **FLOATING
C1603 a_17709_13109.n87 VSS 0.13557f ; **FLOATING
C1604 a_17709_13109.n88 VSS 0.13557f ; **FLOATING
C1605 a_17709_13109.n89 VSS 0.13557f ; **FLOATING
C1606 a_17709_13109.n90 VSS 0.13557f ; **FLOATING
C1607 a_17709_13109.n91 VSS 0.13557f ; **FLOATING
C1608 a_17709_13109.n92 VSS 0.13557f ; **FLOATING
C1609 a_17709_13109.n93 VSS 0.13557f ; **FLOATING
C1610 a_17709_13109.n94 VSS 0.13557f ; **FLOATING
C1611 a_17709_13109.n95 VSS 0.13557f ; **FLOATING
C1612 a_17709_13109.n96 VSS 0.13557f ; **FLOATING
C1613 a_17709_13109.n97 VSS 0.13557f ; **FLOATING
C1614 a_17709_13109.n98 VSS 0.13557f ; **FLOATING
C1615 a_17709_13109.n99 VSS 0.13557f ; **FLOATING
C1616 a_17709_13109.n100 VSS 0.13557f ; **FLOATING
C1617 a_17709_13109.n101 VSS 0.13557f ; **FLOATING
C1618 a_17709_13109.n102 VSS 0.13557f ; **FLOATING
C1619 a_17709_13109.n103 VSS 0.13557f ; **FLOATING
C1620 a_17709_13109.n104 VSS 0.13557f ; **FLOATING
C1621 a_17709_13109.n105 VSS 0.13557f ; **FLOATING
C1622 a_17709_13109.n106 VSS 0.13557f ; **FLOATING
C1623 a_17709_13109.n107 VSS 0.13557f ; **FLOATING
C1624 a_17709_13109.n108 VSS 0.13557f ; **FLOATING
C1625 a_17709_13109.n109 VSS 0.13557f ; **FLOATING
C1626 a_17709_13109.n110 VSS 0.13557f ; **FLOATING
C1627 a_17709_13109.n111 VSS 0.13557f ; **FLOATING
C1628 a_17709_13109.n112 VSS 0.11943f ; **FLOATING
C1629 a_17709_13109.t49 VSS 0.19354f ; **FLOATING
C1630 a_17709_13109.t50 VSS 0.19354f ; **FLOATING
C1631 a_17709_13109.t51 VSS 0.19354f ; **FLOATING
C1632 a_17709_13109.t52 VSS 0.19354f ; **FLOATING
C1633 a_17709_13109.t53 VSS 0.19354f ; **FLOATING
C1634 a_17709_13109.t54 VSS 0.19354f ; **FLOATING
C1635 a_17709_13109.t7 VSS 0.19354f ; **FLOATING
C1636 a_17709_13109.t5 VSS 0.19354f ; **FLOATING
C1637 a_17709_13109.t55 VSS 0.19354f ; **FLOATING
C1638 a_17709_13109.t56 VSS 0.19354f ; **FLOATING
C1639 a_17709_13109.t57 VSS 0.19354f ; **FLOATING
C1640 a_17709_13109.t58 VSS 0.19354f ; **FLOATING
C1641 a_17709_13109.t59 VSS 0.19354f ; **FLOATING
C1642 a_17709_13109.t60 VSS 0.19354f ; **FLOATING
C1643 a_17709_13109.t61 VSS 0.19354f ; **FLOATING
C1644 a_17709_13109.t62 VSS 0.19354f ; **FLOATING
C1645 a_17709_13109.t63 VSS 0.19354f ; **FLOATING
C1646 a_17709_13109.t64 VSS 0.19354f ; **FLOATING
C1647 a_17709_13109.t65 VSS 0.19354f ; **FLOATING
C1648 a_17709_13109.t66 VSS 0.19354f ; **FLOATING
C1649 a_17709_13109.t67 VSS 0.19354f ; **FLOATING
C1650 a_17709_13109.t68 VSS 0.19354f ; **FLOATING
C1651 a_17709_13109.t69 VSS 0.19354f ; **FLOATING
C1652 a_17709_13109.t70 VSS 0.19354f ; **FLOATING
C1653 a_17709_13109.t71 VSS 0.19354f ; **FLOATING
C1654 a_17709_13109.t72 VSS 0.19354f ; **FLOATING
C1655 a_17709_13109.t73 VSS 0.19354f ; **FLOATING
C1656 a_17709_13109.t74 VSS 0.19354f ; **FLOATING
C1657 a_17709_13109.t75 VSS 0.19354f ; **FLOATING
C1658 a_17709_13109.t76 VSS 0.19354f ; **FLOATING
C1659 a_17709_13109.t77 VSS 0.19354f ; **FLOATING
C1660 a_17709_13109.t78 VSS 0.19354f ; **FLOATING
C1661 a_17709_13109.t79 VSS 0.19354f ; **FLOATING
C1662 a_17709_13109.t80 VSS 0.19354f ; **FLOATING
C1663 a_17709_13109.t81 VSS 0.19354f ; **FLOATING
C1664 a_17709_13109.t82 VSS 0.19354f ; **FLOATING
C1665 a_17709_13109.t83 VSS 0.19354f ; **FLOATING
C1666 a_17709_13109.t84 VSS 0.20829f ; **FLOATING
C1667 a_17709_13109.n113 VSS 0.24323f ; **FLOATING
C1668 a_17709_13109.n114 VSS 0.13557f ; **FLOATING
C1669 a_17709_13109.n115 VSS 0.13557f ; **FLOATING
C1670 a_17709_13109.n116 VSS 0.13557f ; **FLOATING
C1671 a_17709_13109.n117 VSS 0.13557f ; **FLOATING
C1672 a_17709_13109.n118 VSS 0.13557f ; **FLOATING
C1673 a_17709_13109.n119 VSS 0.13557f ; **FLOATING
C1674 a_17709_13109.n120 VSS 0.13557f ; **FLOATING
C1675 a_17709_13109.n121 VSS 0.13557f ; **FLOATING
C1676 a_17709_13109.n122 VSS 0.13557f ; **FLOATING
C1677 a_17709_13109.n123 VSS 0.13557f ; **FLOATING
C1678 a_17709_13109.n124 VSS 0.13557f ; **FLOATING
C1679 a_17709_13109.n125 VSS 0.13557f ; **FLOATING
C1680 a_17709_13109.n126 VSS 0.13557f ; **FLOATING
C1681 a_17709_13109.n127 VSS 0.13557f ; **FLOATING
C1682 a_17709_13109.n128 VSS 0.13557f ; **FLOATING
C1683 a_17709_13109.n129 VSS 0.13557f ; **FLOATING
C1684 a_17709_13109.n130 VSS 0.13557f ; **FLOATING
C1685 a_17709_13109.n131 VSS 0.13557f ; **FLOATING
C1686 a_17709_13109.n132 VSS 0.13557f ; **FLOATING
C1687 a_17709_13109.n133 VSS 0.13557f ; **FLOATING
C1688 a_17709_13109.n134 VSS 0.13557f ; **FLOATING
C1689 a_17709_13109.n135 VSS 0.13557f ; **FLOATING
C1690 a_17709_13109.n136 VSS 0.13557f ; **FLOATING
C1691 a_17709_13109.n137 VSS 0.13557f ; **FLOATING
C1692 a_17709_13109.n138 VSS 0.13557f ; **FLOATING
C1693 a_17709_13109.n139 VSS 0.13557f ; **FLOATING
C1694 a_17709_13109.n140 VSS 0.13557f ; **FLOATING
C1695 a_17709_13109.n141 VSS 0.13557f ; **FLOATING
C1696 a_17709_13109.n142 VSS 0.13557f ; **FLOATING
C1697 a_17709_13109.n143 VSS 0.13557f ; **FLOATING
C1698 a_17709_13109.n144 VSS 0.13557f ; **FLOATING
C1699 a_17709_13109.n145 VSS 0.13557f ; **FLOATING
C1700 a_17709_13109.n146 VSS 0.13557f ; **FLOATING
C1701 a_17709_13109.n147 VSS 0.13557f ; **FLOATING
C1702 a_17709_13109.n148 VSS 0.13557f ; **FLOATING
C1703 a_17709_13109.n149 VSS 0.11943f ; **FLOATING
C1704 a_17709_13109.n150 VSS 6.68507f ; **FLOATING
C1705 a_17709_13109.n151 VSS 2.65988f ; **FLOATING
C1706 a_17709_13109.n152 VSS 1.39798f ; **FLOATING
C1707 a_17709_13109.t1 VSS 2.86289f ; **FLOATING
C1708 a_17709_13109.t6 VSS 1.45287f ; **FLOATING
C1709 a_18109_11960.t1 VSS 16.1883f ; **FLOATING
C1710 a_18109_11960.n0 VSS 0.39553f ; **FLOATING
C1711 a_18109_11960.n1 VSS 0.83178f ; **FLOATING
C1712 a_18109_11960.n2 VSS 0.65517f ; **FLOATING
C1713 a_18109_11960.n3 VSS 0.51927f ; **FLOATING
C1714 a_18109_11960.n4 VSS 0.3967f ; **FLOATING
C1715 a_18109_11960.n5 VSS 0.78192f ; **FLOATING
C1716 a_18109_11960.n6 VSS 0.6569f ; **FLOATING
C1717 a_18109_11960.n7 VSS 0.52039f ; **FLOATING
C1718 a_18109_11960.n8 VSS 0.31964f ; **FLOATING
C1719 a_18109_11960.n9 VSS 0.31908f ; **FLOATING
C1720 a_18109_11960.t0 VSS 0.64509f ; **FLOATING
C1721 a_18109_11960.t3 VSS 0.67108f ; **FLOATING
C1722 a_18109_11960.t12 VSS 0.65228f ; **FLOATING
C1723 a_18109_11960.t9 VSS 0.65228f ; **FLOATING
C1724 a_18109_11960.t25 VSS 0.65228f ; **FLOATING
C1725 a_18109_11960.t8 VSS 0.65228f ; **FLOATING
C1726 a_18109_11960.t14 VSS 0.65228f ; **FLOATING
C1727 a_18109_11960.t18 VSS 0.65228f ; **FLOATING
C1728 a_18109_11960.t33 VSS 0.65228f ; **FLOATING
C1729 a_18109_11960.t27 VSS 0.65228f ; **FLOATING
C1730 a_18109_11960.t24 VSS 0.65228f ; **FLOATING
C1731 a_18109_11960.t30 VSS 0.65228f ; **FLOATING
C1732 a_18109_11960.t32 VSS 0.65228f ; **FLOATING
C1733 a_18109_11960.t26 VSS 0.65228f ; **FLOATING
C1734 a_18109_11960.t20 VSS 0.65228f ; **FLOATING
C1735 a_18109_11960.t29 VSS 0.65228f ; **FLOATING
C1736 a_18109_11960.t23 VSS 0.67108f ; **FLOATING
C1737 a_18109_11960.t19 VSS 0.67047f ; **FLOATING
C1738 a_18109_11960.t17 VSS 0.65172f ; **FLOATING
C1739 a_18109_11960.t4 VSS 0.65172f ; **FLOATING
C1740 a_18109_11960.t11 VSS 0.65172f ; **FLOATING
C1741 a_18109_11960.t5 VSS 0.65172f ; **FLOATING
C1742 a_18109_11960.t15 VSS 0.65172f ; **FLOATING
C1743 a_18109_11960.t34 VSS 0.65172f ; **FLOATING
C1744 a_18109_11960.t21 VSS 0.65172f ; **FLOATING
C1745 a_18109_11960.t13 VSS 0.65172f ; **FLOATING
C1746 a_18109_11960.t31 VSS 0.65172f ; **FLOATING
C1747 a_18109_11960.t6 VSS 0.65172f ; **FLOATING
C1748 a_18109_11960.t28 VSS 0.65172f ; **FLOATING
C1749 a_18109_11960.t16 VSS 0.65172f ; **FLOATING
C1750 a_18109_11960.t7 VSS 0.65172f ; **FLOATING
C1751 a_18109_11960.t22 VSS 0.65172f ; **FLOATING
C1752 a_18109_11960.t10 VSS 0.67047f ; **FLOATING
C1753 a_18109_11960.n10 VSS 0.63815f ; **FLOATING
C1754 a_18109_11960.n11 VSS 0.63927f ; **FLOATING
C1755 a_18109_11960.n12 VSS 0.31964f ; **FLOATING
C1756 a_18109_11960.n13 VSS 0.43852f ; **FLOATING
C1757 a_18109_11960.n14 VSS 0.43852f ; **FLOATING
C1758 a_18109_11960.n15 VSS 0.31908f ; **FLOATING
C1759 a_18109_11960.n16 VSS 0.43796f ; **FLOATING
C1760 a_18109_11960.n17 VSS 0.43796f ; **FLOATING
C1761 a_18109_11960.n18 VSS 2.38189f ; **FLOATING
C1762 a_18109_11960.t2 VSS 19.1387f ; **FLOATING
C1763 VR.n0 VSS 4.07615f ; **FLOATING
C1764 VR.n1 VSS 4.07615f ; **FLOATING
C1765 VR.n2 VSS 2.3317f ; **FLOATING
C1766 VR.n3 VSS 0.07529f ; **FLOATING
C1767 VR.n4 VSS 0.08746f ; **FLOATING
C1768 VR.n5 VSS 0.07529f ; **FLOATING
C1769 VR.n6 VSS 0.08746f ; **FLOATING
C1770 VR.n7 VSS 0.07529f ; **FLOATING
C1771 VR.n8 VSS 0.08746f ; **FLOATING
C1772 VR.n9 VSS 0.07529f ; **FLOATING
C1773 VR.n10 VSS 0.08746f ; **FLOATING
C1774 VR.n11 VSS 0.05098f ; **FLOATING
C1775 VR.n12 VSS 0.06899f ; **FLOATING
C1776 VR.n13 VSS 0.05098f ; **FLOATING
C1777 VR.n14 VSS 0.06899f ; **FLOATING
C1778 VR.n15 VSS 0.05098f ; **FLOATING
C1779 VR.n16 VSS 0.06899f ; **FLOATING
C1780 VR.n17 VSS 0.05098f ; **FLOATING
C1781 VR.n18 VSS 0.06899f ; **FLOATING
C1782 VR.n19 VSS 0.05098f ; **FLOATING
C1783 VR.n20 VSS 0.06899f ; **FLOATING
C1784 VR.n21 VSS 0.05098f ; **FLOATING
C1785 VR.n22 VSS 0.06899f ; **FLOATING
C1786 VR.n23 VSS 0.05098f ; **FLOATING
C1787 VR.n24 VSS 0.06899f ; **FLOATING
C1788 VR.n25 VSS 0.05098f ; **FLOATING
C1789 VR.n26 VSS 0.06899f ; **FLOATING
C1790 VR.n27 VSS 0.05098f ; **FLOATING
C1791 VR.n28 VSS 0.06899f ; **FLOATING
C1792 VR.n29 VSS 0.05098f ; **FLOATING
C1793 VR.n30 VSS 0.06899f ; **FLOATING
C1794 VR.n31 VSS 0.05098f ; **FLOATING
C1795 VR.n32 VSS 0.06899f ; **FLOATING
C1796 VR.n33 VSS 0.05098f ; **FLOATING
C1797 VR.n34 VSS 0.06899f ; **FLOATING
C1798 VR.t326 VSS 0.28148f ; **FLOATING
C1799 VR.t134 VSS 0.28148f ; **FLOATING
C1800 VR.n35 VSS 0.28137f ; **FLOATING
C1801 VR.n37 VSS 0.28137f ; **FLOATING
C1802 VR.n39 VSS 0.28137f ; **FLOATING
C1803 VR.n41 VSS 0.28137f ; **FLOATING
C1804 VR.n43 VSS 0.28137f ; **FLOATING
C1805 VR.n45 VSS 0.28137f ; **FLOATING
C1806 VR.n47 VSS 0.28137f ; **FLOATING
C1807 VR.n49 VSS 0.28137f ; **FLOATING
C1808 VR.n51 VSS 0.04713f ; **FLOATING
C1809 VR.n52 VSS 0.04713f ; **FLOATING
C1810 VR.n53 VSS 0.04713f ; **FLOATING
C1811 VR.n54 VSS 0.04713f ; **FLOATING
C1812 VR.n55 VSS 0.20319f ; **FLOATING
C1813 VR.n56 VSS 1.06267f ; **FLOATING
C1814 VR.t202 VSS 0.07861f ; **FLOATING
C1815 VR.t203 VSS 0.0774f ; **FLOATING
C1816 VR.t99 VSS 0.0774f ; **FLOATING
C1817 VR.t87 VSS 0.0774f ; **FLOATING
C1818 VR.t88 VSS 0.0774f ; **FLOATING
C1819 VR.t109 VSS 0.0774f ; **FLOATING
C1820 VR.t106 VSS 0.0774f ; **FLOATING
C1821 VR.t107 VSS 0.0774f ; **FLOATING
C1822 VR.t205 VSS 0.0774f ; **FLOATING
C1823 VR.t100 VSS 0.0774f ; **FLOATING
C1824 VR.t101 VSS 0.0774f ; **FLOATING
C1825 VR.t189 VSS 0.0774f ; **FLOATING
C1826 VR.t27 VSS 0.0774f ; **FLOATING
C1827 VR.t28 VSS 0.0774f ; **FLOATING
C1828 VR.t299 VSS 0.0774f ; **FLOATING
C1829 VR.t102 VSS 0.07756f ; **FLOATING
C1830 VR.t111 VSS 0.07876f ; **FLOATING
C1831 VR.t140 VSS 0.07753f ; **FLOATING
C1832 VR.t112 VSS 0.07753f ; **FLOATING
C1833 VR.t2 VSS 0.07753f ; **FLOATING
C1834 VR.t93 VSS 0.07753f ; **FLOATING
C1835 VR.t95 VSS 0.07753f ; **FLOATING
C1836 VR.t142 VSS 0.07753f ; **FLOATING
C1837 VR.t143 VSS 0.07753f ; **FLOATING
C1838 VR.t204 VSS 0.07753f ; **FLOATING
C1839 VR.t0 VSS 0.07753f ; **FLOATING
C1840 VR.t1 VSS 0.07753f ; **FLOATING
C1841 VR.t94 VSS 0.07753f ; **FLOATING
C1842 VR.t84 VSS 0.07753f ; **FLOATING
C1843 VR.t85 VSS 0.07753f ; **FLOATING
C1844 VR.t190 VSS 0.07753f ; **FLOATING
C1845 VR.t293 VSS 0.0777f ; **FLOATING
C1846 VR.t166 VSS 0.0802f ; **FLOATING
C1847 VR.t200 VSS 0.07798f ; **FLOATING
C1848 VR.t5 VSS 0.07798f ; **FLOATING
C1849 VR.t196 VSS 0.07798f ; **FLOATING
C1850 VR.t90 VSS 0.07798f ; **FLOATING
C1851 VR.t136 VSS 0.07798f ; **FLOATING
C1852 VR.t214 VSS 0.07798f ; **FLOATING
C1853 VR.t23 VSS 0.07798f ; **FLOATING
C1854 VR.t146 VSS 0.07798f ; **FLOATING
C1855 VR.t312 VSS 0.07798f ; **FLOATING
C1856 VR.t292 VSS 0.07798f ; **FLOATING
C1857 VR.t298 VSS 0.07798f ; **FLOATING
C1858 VR.t197 VSS 0.07798f ; **FLOATING
C1859 VR.t185 VSS 0.07798f ; **FLOATING
C1860 VR.t294 VSS 0.07798f ; **FLOATING
C1861 VR.t191 VSS 0.0802f ; **FLOATING
C1862 VR.t167 VSS 0.08029f ; **FLOATING
C1863 VR.t201 VSS 0.07806f ; **FLOATING
C1864 VR.t59 VSS 0.07806f ; **FLOATING
C1865 VR.t108 VSS 0.07806f ; **FLOATING
C1866 VR.t165 VSS 0.07806f ; **FLOATING
C1867 VR.t83 VSS 0.07806f ; **FLOATING
C1868 VR.t171 VSS 0.07806f ; **FLOATING
C1869 VR.t110 VSS 0.07806f ; **FLOATING
C1870 VR.t24 VSS 0.07806f ; **FLOATING
C1871 VR.t141 VSS 0.07806f ; **FLOATING
C1872 VR.t86 VSS 0.07806f ; **FLOATING
C1873 VR.t186 VSS 0.07806f ; **FLOATING
C1874 VR.t139 VSS 0.07806f ; **FLOATING
C1875 VR.t89 VSS 0.07806f ; **FLOATING
C1876 VR.t96 VSS 0.07806f ; **FLOATING
C1877 VR.t172 VSS 0.08029f ; **FLOATING
C1878 VR.t56 VSS 0.07876f ; **FLOATING
C1879 VR.t55 VSS 0.07753f ; **FLOATING
C1880 VR.t54 VSS 0.07753f ; **FLOATING
C1881 VR.t53 VSS 0.07753f ; **FLOATING
C1882 VR.t52 VSS 0.07753f ; **FLOATING
C1883 VR.t51 VSS 0.07753f ; **FLOATING
C1884 VR.t50 VSS 0.07753f ; **FLOATING
C1885 VR.t49 VSS 0.0777f ; **FLOATING
C1886 VR.n57 VSS 1.74446f ; **FLOATING
C1887 VR.n58 VSS 0.26942f ; **FLOATING
C1888 VR.n60 VSS 0.25494f ; **FLOATING
C1889 VR.n62 VSS 0.26942f ; **FLOATING
C1890 VR.n64 VSS 0.25494f ; **FLOATING
C1891 VR.n66 VSS 0.26942f ; **FLOATING
C1892 VR.n68 VSS 0.25494f ; **FLOATING
C1893 VR.n70 VSS 0.43819f ; **FLOATING
C1894 VR.n72 VSS 0.25494f ; **FLOATING
C1895 VR.n74 VSS 0.42429f ; **FLOATING
C1896 VR.n75 VSS 0.36728f ; **FLOATING
C1897 VR.n76 VSS 0.06204f ; **FLOATING
C1898 VR.n77 VSS 0.42429f ; **FLOATING
C1899 VR.n78 VSS 0.36728f ; **FLOATING
C1900 VR.n79 VSS 0.06204f ; **FLOATING
C1901 VR.n80 VSS 0.42429f ; **FLOATING
C1902 VR.n81 VSS 0.36728f ; **FLOATING
C1903 VR.n82 VSS 0.06204f ; **FLOATING
C1904 VR.n83 VSS 0.42429f ; **FLOATING
C1905 VR.n84 VSS 0.36728f ; **FLOATING
C1906 VR.n85 VSS 0.06204f ; **FLOATING
C1907 VR.n86 VSS 0.42429f ; **FLOATING
C1908 VR.n87 VSS 0.36728f ; **FLOATING
C1909 VR.n88 VSS 0.06204f ; **FLOATING
C1910 VR.n89 VSS 0.42429f ; **FLOATING
C1911 VR.n90 VSS 0.36728f ; **FLOATING
C1912 VR.n91 VSS 0.06204f ; **FLOATING
C1913 VR.n92 VSS 0.42429f ; **FLOATING
C1914 VR.n93 VSS 0.36728f ; **FLOATING
C1915 VR.n94 VSS 0.06204f ; **FLOATING
C1916 VR.n95 VSS 0.42429f ; **FLOATING
C1917 VR.n96 VSS 0.36728f ; **FLOATING
C1918 VR.n97 VSS 0.06204f ; **FLOATING
C1919 VR.n98 VSS 0.04001f ; **FLOATING
C1920 VR.n99 VSS 0.19188f ; **FLOATING
C1921 VR.n100 VSS 0.03943f ; **FLOATING
C1922 VR.n101 VSS 0.04651f ; **FLOATING
C1923 VR.n102 VSS 0.23561f ; **FLOATING
C1924 VR.n103 VSS 0.04532f ; **FLOATING
C1925 VR.n104 VSS 0.04001f ; **FLOATING
C1926 VR.n105 VSS 0.19188f ; **FLOATING
C1927 VR.n106 VSS 0.03943f ; **FLOATING
C1928 VR.n107 VSS 0.04001f ; **FLOATING
C1929 VR.n108 VSS 0.19188f ; **FLOATING
C1930 VR.n109 VSS 0.03943f ; **FLOATING
C1931 VR.n110 VSS 0.04001f ; **FLOATING
C1932 VR.n111 VSS 0.19188f ; **FLOATING
C1933 VR.n112 VSS 0.03943f ; **FLOATING
C1934 VR.n113 VSS 0.04001f ; **FLOATING
C1935 VR.n114 VSS 0.19188f ; **FLOATING
C1936 VR.n115 VSS 0.03943f ; **FLOATING
C1937 VR.n116 VSS 0.04001f ; **FLOATING
C1938 VR.n117 VSS 0.19188f ; **FLOATING
C1939 VR.n118 VSS 0.03943f ; **FLOATING
C1940 VR.n119 VSS 0.04651f ; **FLOATING
C1941 VR.n120 VSS 0.23561f ; **FLOATING
C1942 VR.n121 VSS 0.04532f ; **FLOATING
C1943 VR.n122 VSS 0.04651f ; **FLOATING
C1944 VR.n123 VSS 0.23561f ; **FLOATING
C1945 VR.n124 VSS 0.04532f ; **FLOATING
C1946 VR.n125 VSS 0.04001f ; **FLOATING
C1947 VR.n126 VSS 0.19188f ; **FLOATING
C1948 VR.n127 VSS 0.03943f ; **FLOATING
C1949 VR.n128 VSS 0.04001f ; **FLOATING
C1950 VR.n129 VSS 0.19188f ; **FLOATING
C1951 VR.n130 VSS 0.03943f ; **FLOATING
C1952 VR.n131 VSS 0.04651f ; **FLOATING
C1953 VR.n132 VSS 0.23561f ; **FLOATING
C1954 VR.n133 VSS 0.04532f ; **FLOATING
C1955 VR.n134 VSS 0.04651f ; **FLOATING
C1956 VR.n135 VSS 0.23561f ; **FLOATING
C1957 VR.n136 VSS 0.04532f ; **FLOATING
C1958 VR.n137 VSS 0.24135f ; **FLOATING
C1959 VR.n138 VSS 0.20464f ; **FLOATING
C1960 VR.n139 VSS 0.04106f ; **FLOATING
C1961 VR.n140 VSS 0.24135f ; **FLOATING
C1962 VR.n141 VSS 0.20464f ; **FLOATING
C1963 VR.n142 VSS 0.04106f ; **FLOATING
C1964 VR.n143 VSS 0.04651f ; **FLOATING
C1965 VR.n144 VSS 0.23561f ; **FLOATING
C1966 VR.n145 VSS 0.04532f ; **FLOATING
C1967 VR.n146 VSS 0.04651f ; **FLOATING
C1968 VR.n147 VSS 0.23561f ; **FLOATING
C1969 VR.n148 VSS 0.04532f ; **FLOATING
C1970 VR.n149 VSS 0.24135f ; **FLOATING
C1971 VR.n150 VSS 0.20464f ; **FLOATING
C1972 VR.n151 VSS 0.04106f ; **FLOATING
C1973 VR.n152 VSS 0.24135f ; **FLOATING
C1974 VR.n153 VSS 0.20464f ; **FLOATING
C1975 VR.n154 VSS 0.04106f ; **FLOATING
C1976 VR.n155 VSS 0.04651f ; **FLOATING
C1977 VR.n156 VSS 0.23561f ; **FLOATING
C1978 VR.n157 VSS 0.04532f ; **FLOATING
C1979 VR.n158 VSS 0.04651f ; **FLOATING
C1980 VR.n159 VSS 0.23561f ; **FLOATING
C1981 VR.n160 VSS 0.04532f ; **FLOATING
C1982 VR.n161 VSS 0.24135f ; **FLOATING
C1983 VR.n162 VSS 0.20464f ; **FLOATING
C1984 VR.n163 VSS 0.04106f ; **FLOATING
C1985 VR.n164 VSS 0.24135f ; **FLOATING
C1986 VR.n165 VSS 0.20464f ; **FLOATING
C1987 VR.n166 VSS 0.04106f ; **FLOATING
C1988 VR.n167 VSS 0.04651f ; **FLOATING
C1989 VR.n168 VSS 0.23561f ; **FLOATING
C1990 VR.n169 VSS 0.04532f ; **FLOATING
C1991 VR.n170 VSS 0.04651f ; **FLOATING
C1992 VR.n171 VSS 0.23561f ; **FLOATING
C1993 VR.n172 VSS 0.04532f ; **FLOATING
C1994 VR.n173 VSS 0.24135f ; **FLOATING
C1995 VR.n174 VSS 0.20464f ; **FLOATING
C1996 VR.n175 VSS 0.04106f ; **FLOATING
C1997 VR.n176 VSS 0.24135f ; **FLOATING
C1998 VR.n177 VSS 0.20464f ; **FLOATING
C1999 VR.n178 VSS 0.04106f ; **FLOATING
C2000 VR.n179 VSS 0.04001f ; **FLOATING
C2001 VR.n180 VSS 0.19188f ; **FLOATING
C2002 VR.n181 VSS 0.03943f ; **FLOATING
C2003 VR.n182 VSS 0.04001f ; **FLOATING
C2004 VR.n183 VSS 0.19188f ; **FLOATING
C2005 VR.n184 VSS 0.03943f ; **FLOATING
C2006 VR.n185 VSS 0.04651f ; **FLOATING
C2007 VR.n186 VSS 0.23561f ; **FLOATING
C2008 VR.n187 VSS 0.04532f ; **FLOATING
C2009 VR.n188 VSS 0.04001f ; **FLOATING
C2010 VR.n189 VSS 0.19188f ; **FLOATING
C2011 VR.n190 VSS 0.03943f ; **FLOATING
C2012 VR.n191 VSS 0.04001f ; **FLOATING
C2013 VR.n192 VSS 0.19188f ; **FLOATING
C2014 VR.n193 VSS 0.03943f ; **FLOATING
C2015 VR.n194 VSS 0.04651f ; **FLOATING
C2016 VR.n195 VSS 0.23561f ; **FLOATING
C2017 VR.n196 VSS 0.04532f ; **FLOATING
C2018 VR.n197 VSS 0.20319f ; **FLOATING
C2019 VR.n198 VSS 0.20388f ; **FLOATING
C2020 VR.n199 VSS 0.17575f ; **FLOATING
C2021 VR.n200 VSS 0.17575f ; **FLOATING
C2022 VR.n201 VSS 2.6793f ; **FLOATING
C2023 VR.n202 VSS 2.6793f ; **FLOATING
C2024 VR.n203 VSS 2.6793f ; **FLOATING
C2025 VR.n204 VSS 2.6793f ; **FLOATING
C2026 VR.t295 VSS 0.25552f ; **FLOATING
C2027 VR.n205 VSS 0.05384f ; **FLOATING
C2028 VR.t187 VSS 0.25552f ; **FLOATING
C2029 VR.n206 VSS 0.05384f ; **FLOATING
C2030 VR.t289 VSS 0.25552f ; **FLOATING
C2031 VR.n207 VSS 0.05384f ; **FLOATING
C2032 VR.t137 VSS 0.25552f ; **FLOATING
C2033 VR.n208 VSS 0.05384f ; **FLOATING
C2034 VR.t29 VSS 0.25552f ; **FLOATING
C2035 VR.n209 VSS 0.05384f ; **FLOATING
C2036 VR.t32 VSS 0.25552f ; **FLOATING
C2037 VR.n210 VSS 0.05384f ; **FLOATING
C2038 VR.t266 VSS 0.25552f ; **FLOATING
C2039 VR.n211 VSS 0.05384f ; **FLOATING
C2040 VR.t20 VSS 0.25552f ; **FLOATING
C2041 VR.n212 VSS 0.05384f ; **FLOATING
C2042 VR.t75 VSS 0.25552f ; **FLOATING
C2043 VR.n213 VSS 0.05384f ; **FLOATING
C2044 VR.t277 VSS 0.25552f ; **FLOATING
C2045 VR.n214 VSS 0.05384f ; **FLOATING
C2046 VR.t132 VSS 0.25552f ; **FLOATING
C2047 VR.n215 VSS 0.05384f ; **FLOATING
C2048 VR.t310 VSS 0.25552f ; **FLOATING
C2049 VR.n216 VSS 0.05384f ; **FLOATING
C2050 VR.t173 VSS 0.25552f ; **FLOATING
C2051 VR.n217 VSS 0.05384f ; **FLOATING
C2052 VR.t217 VSS 0.25552f ; **FLOATING
C2053 VR.n218 VSS 0.05384f ; **FLOATING
C2054 VR.t247 VSS 0.25552f ; **FLOATING
C2055 VR.n219 VSS 0.05384f ; **FLOATING
C2056 VR.t317 VSS 0.25552f ; **FLOATING
C2057 VR.n220 VSS 0.05384f ; **FLOATING
C2058 VR.t7 VSS 0.25552f ; **FLOATING
C2059 VR.n221 VSS 0.05384f ; **FLOATING
C2060 VR.t243 VSS 0.25552f ; **FLOATING
C2061 VR.n222 VSS 0.05384f ; **FLOATING
C2062 VR.n223 VSS 0.07167f ; **FLOATING
C2063 VR.n224 VSS 0.05378f ; **FLOATING
C2064 VR.n225 VSS 0.05378f ; **FLOATING
C2065 VR.n226 VSS 0.07167f ; **FLOATING
C2066 VR.n227 VSS 0.05378f ; **FLOATING
C2067 VR.n228 VSS 0.05378f ; **FLOATING
C2068 VR.n229 VSS 0.07167f ; **FLOATING
C2069 VR.n230 VSS 0.05378f ; **FLOATING
C2070 VR.n231 VSS 0.05378f ; **FLOATING
C2071 VR.n232 VSS 0.05378f ; **FLOATING
C2072 VR.n233 VSS 0.05378f ; **FLOATING
C2073 VR.n234 VSS 0.05378f ; **FLOATING
C2074 VR.n235 VSS 0.05378f ; **FLOATING
C2075 VR.n236 VSS 0.05378f ; **FLOATING
C2076 VR.n237 VSS 0.05378f ; **FLOATING
C2077 VR.n238 VSS 0.05378f ; **FLOATING
C2078 VR.n239 VSS 0.05378f ; **FLOATING
C2079 VR.n240 VSS 0.07167f ; **FLOATING
C2080 VR.n241 VSS 0.05378f ; **FLOATING
C2081 VR.n242 VSS 0.05378f ; **FLOATING
C2082 VR.n243 VSS 0.07167f ; **FLOATING
C2083 VR.n244 VSS 0.05378f ; **FLOATING
C2084 VR.n245 VSS 0.05378f ; **FLOATING
C2085 VR.n246 VSS 2.05054f ; **FLOATING
C2086 VR.n247 VSS 2.44193f ; **FLOATING
C2087 VR.n248 VSS 0.12157f ; **FLOATING
C2088 VR.n249 VSS 0.1273f ; **FLOATING
C2089 VR.n250 VSS 0.05098f ; **FLOATING
C2090 VR.n251 VSS 0.22774f ; **FLOATING
C2091 VR.n252 VSS 0.05098f ; **FLOATING
C2092 VR.n253 VSS 0.22774f ; **FLOATING
C2093 VR.n254 VSS 0.05098f ; **FLOATING
C2094 VR.n255 VSS 0.22774f ; **FLOATING
C2095 VR.n256 VSS 0.05098f ; **FLOATING
C2096 VR.n257 VSS 0.22774f ; **FLOATING
C2097 VR.n258 VSS 0.07529f ; **FLOATING
C2098 VR.n259 VSS 0.2723f ; **FLOATING
C2099 VR.n260 VSS 0.07529f ; **FLOATING
C2100 VR.n261 VSS 0.2723f ; **FLOATING
C2101 VR.n262 VSS 0.07529f ; **FLOATING
C2102 VR.n263 VSS 0.2723f ; **FLOATING
C2103 VR.n264 VSS 0.07529f ; **FLOATING
C2104 VR.n265 VSS 0.2723f ; **FLOATING
C2105 VR.n266 VSS 0.05098f ; **FLOATING
C2106 VR.n267 VSS 0.22774f ; **FLOATING
C2107 VR.n268 VSS 0.05098f ; **FLOATING
C2108 VR.n269 VSS 0.22774f ; **FLOATING
C2109 VR.n270 VSS 0.05098f ; **FLOATING
C2110 VR.n271 VSS 0.22774f ; **FLOATING
C2111 VR.n272 VSS 0.05098f ; **FLOATING
C2112 VR.n273 VSS 0.22774f ; **FLOATING
C2113 VR.n274 VSS 0.05098f ; **FLOATING
C2114 VR.n275 VSS 0.22774f ; **FLOATING
C2115 VR.n276 VSS 0.05098f ; **FLOATING
C2116 VR.n277 VSS 0.22774f ; **FLOATING
C2117 VR.n278 VSS 0.05098f ; **FLOATING
C2118 VR.n279 VSS 0.22774f ; **FLOATING
C2119 VR.n280 VSS 0.05098f ; **FLOATING
C2120 VR.n281 VSS 0.22774f ; **FLOATING
C2121 VR.t57 VSS 0.20468f ; **FLOATING
C2122 VR.n282 VSS 0.04581f ; **FLOATING
C2123 VR.t296 VSS 0.20468f ; **FLOATING
C2124 VR.n283 VSS 0.04581f ; **FLOATING
C2125 VR.t3 VSS 0.20468f ; **FLOATING
C2126 VR.n284 VSS 0.04581f ; **FLOATING
C2127 VR.t25 VSS 0.20468f ; **FLOATING
C2128 VR.n285 VSS 0.04581f ; **FLOATING
C2129 VR.t91 VSS 0.20468f ; **FLOATING
C2130 VR.n286 VSS 0.04581f ; **FLOATING
C2131 VR.t46 VSS 0.20468f ; **FLOATING
C2132 VR.n287 VSS 0.04581f ; **FLOATING
C2133 VR.t30 VSS 0.20468f ; **FLOATING
C2134 VR.n288 VSS 0.04581f ; **FLOATING
C2135 VR.t36 VSS 0.20468f ; **FLOATING
C2136 VR.n289 VSS 0.04581f ; **FLOATING
C2137 VR.t245 VSS 0.20468f ; **FLOATING
C2138 VR.n290 VSS 0.04581f ; **FLOATING
C2139 VR.t313 VSS 0.20468f ; **FLOATING
C2140 VR.n291 VSS 0.04581f ; **FLOATING
C2141 VR.t8 VSS 0.20468f ; **FLOATING
C2142 VR.n292 VSS 0.04581f ; **FLOATING
C2143 VR.t198 VSS 0.20468f ; **FLOATING
C2144 VR.n293 VSS 0.04581f ; **FLOATING
C2145 VR.n294 VSS 0.04575f ; **FLOATING
C2146 VR.n295 VSS 0.04575f ; **FLOATING
C2147 VR.n296 VSS 0.04575f ; **FLOATING
C2148 VR.n297 VSS 0.04575f ; **FLOATING
C2149 VR.n298 VSS 0.04575f ; **FLOATING
C2150 VR.n299 VSS 0.04575f ; **FLOATING
C2151 VR.n300 VSS 0.04575f ; **FLOATING
C2152 VR.n301 VSS 0.04575f ; **FLOATING
C2153 VR.n302 VSS 0.04575f ; **FLOATING
C2154 VR.n303 VSS 0.04575f ; **FLOATING
C2155 VR.n304 VSS 0.04575f ; **FLOATING
C2156 VR.n305 VSS 0.04575f ; **FLOATING
C2157 VR.n306 VSS 5.11471f ; **FLOATING
C2158 VR.n307 VSS 0.93643f ; **FLOATING
C2159 VR.n308 VSS 6.40324f ; **FLOATING
C2160 VR.t256 VSS 0.16063f ; **FLOATING
C2161 VR.t18 VSS 0.16063f ; **FLOATING
C2162 VR.t73 VSS 0.16063f ; **FLOATING
C2163 VR.t279 VSS 0.16063f ; **FLOATING
C2164 VR.t130 VSS 0.16063f ; **FLOATING
C2165 VR.t300 VSS 0.16063f ; **FLOATING
C2166 VR.t175 VSS 0.16063f ; **FLOATING
C2167 VR.t219 VSS 0.16063f ; **FLOATING
C2168 VR.n309 VSS 0.16055f ; **FLOATING
C2169 VR.n311 VSS 0.16055f ; **FLOATING
C2170 VR.n313 VSS 0.16055f ; **FLOATING
C2171 VR.n315 VSS 0.16055f ; **FLOATING
C2172 VR.n317 VSS 0.16055f ; **FLOATING
C2173 VR.n319 VSS 0.16055f ; **FLOATING
C2174 VR.n321 VSS 0.16055f ; **FLOATING
C2175 VR.n323 VSS 0.16055f ; **FLOATING
C2176 VR.t329 VSS 35.822f ; **FLOATING
C2177 VR.t328 VSS 4.54808f ; **FLOATING
C2178 VR.n325 VSS 0.07291f ; **FLOATING
C2179 VR.t22 VSS 2.09117f ; **FLOATING
C2180 VR.n326 VSS 0.07744f ; **FLOATING
C2181 VR.t168 VSS 0.20404f ; **FLOATING
C2182 VR.t169 VSS 0.10374f ; **FLOATING
C2183 VR.n327 VSS 0.10041f ; **FLOATING
C2184 VR.n328 VSS 0.07944f ; **FLOATING
C2185 VR.n329 VSS 0.19807f ; **FLOATING
C2186 VR.n330 VSS 0.07744f ; **FLOATING
C2187 VR.t194 VSS 0.20404f ; **FLOATING
C2188 VR.t195 VSS 0.10374f ; **FLOATING
C2189 VR.n331 VSS 0.10041f ; **FLOATING
C2190 VR.n332 VSS 0.07944f ; **FLOATING
C2191 VR.n333 VSS 0.10494f ; **FLOATING
C2192 VR.t48 VSS 1.26066f ; **FLOATING
C2193 VR.n334 VSS 10.9067f ; **FLOATING
C2194 VR.t70 VSS 2.09117f ; **FLOATING
C2195 VR.n335 VSS 0.07744f ; **FLOATING
C2196 VR.t144 VSS 0.20404f ; **FLOATING
C2197 VR.t145 VSS 0.10374f ; **FLOATING
C2198 VR.n336 VSS 0.10041f ; **FLOATING
C2199 VR.n337 VSS 0.07944f ; **FLOATING
C2200 VR.n338 VSS 0.19807f ; **FLOATING
C2201 VR.n339 VSS 0.07744f ; **FLOATING
C2202 VR.t147 VSS 0.20404f ; **FLOATING
C2203 VR.t148 VSS 0.10374f ; **FLOATING
C2204 VR.n340 VSS 0.10041f ; **FLOATING
C2205 VR.n341 VSS 0.07944f ; **FLOATING
C2206 VR.n342 VSS 0.10494f ; **FLOATING
C2207 VR.t276 VSS 1.26066f ; **FLOATING
C2208 VR.n343 VSS 10.1933f ; **FLOATING
C2209 VR.n344 VSS 3.32367f ; **FLOATING
C2210 VR.t325 VSS 2.09117f ; **FLOATING
C2211 VR.n345 VSS 0.07744f ; **FLOATING
C2212 VR.t68 VSS 0.20404f ; **FLOATING
C2213 VR.t69 VSS 0.10374f ; **FLOATING
C2214 VR.n346 VSS 0.10041f ; **FLOATING
C2215 VR.n347 VSS 0.07944f ; **FLOATING
C2216 VR.n348 VSS 0.19807f ; **FLOATING
C2217 VR.n349 VSS 0.07744f ; **FLOATING
C2218 VR.t104 VSS 0.20404f ; **FLOATING
C2219 VR.t105 VSS 0.10374f ; **FLOATING
C2220 VR.n350 VSS 0.10041f ; **FLOATING
C2221 VR.n351 VSS 0.07944f ; **FLOATING
C2222 VR.n352 VSS 0.10494f ; **FLOATING
C2223 VR.t170 VSS 1.26066f ; **FLOATING
C2224 VR.n353 VSS 10.1933f ; **FLOATING
C2225 VR.n354 VSS 2.24397f ; **FLOATING
C2226 VR.n355 VSS 0.06236f ; **FLOATING
C2227 VR.t154 VSS 0.03779f ; **FLOATING
C2228 VR.t150 VSS 0.03811f ; **FLOATING
C2229 VR.t152 VSS 0.03779f ; **FLOATING
C2230 VR.n356 VSS 0.09108f ; **FLOATING
C2231 VR.n357 VSS 0.0623f ; **FLOATING
C2232 VR.n358 VSS 0.22774f ; **FLOATING
C2233 VR.t151 VSS 0.16894f ; **FLOATING
C2234 VR.t149 VSS 0.08082f ; **FLOATING
C2235 VR.n359 VSS 0.05388f ; **FLOATING
C2236 VR.t155 VSS 0.08082f ; **FLOATING
C2237 VR.t153 VSS 0.16894f ; **FLOATING
C2238 VR.n360 VSS 3.62334f ; **FLOATING
C2239 VR.t6 VSS 0.60461f ; **FLOATING
C2240 VR.n361 VSS 0.25099f ; **FLOATING
C2241 VR.n362 VSS 0.04824f ; **FLOATING
C2242 VR.n363 VSS 0.03154f ; **FLOATING
C2243 VR.n364 VSS 0.03154f ; **FLOATING
C2244 VR.n365 VSS 0.03154f ; **FLOATING
C2245 VR.n366 VSS 0.03154f ; **FLOATING
C2246 VR.n367 VSS 0.04583f ; **FLOATING
C2247 VR.n368 VSS 0.06726f ; **FLOATING
C2248 VR.n369 VSS 0.04931f ; **FLOATING
C2249 VR.n370 VSS 0.04824f ; **FLOATING
C2250 VR.n371 VSS 0.03154f ; **FLOATING
C2251 VR.n372 VSS 0.03154f ; **FLOATING
C2252 VR.n373 VSS 0.03154f ; **FLOATING
C2253 VR.n374 VSS 0.03154f ; **FLOATING
C2254 VR.n375 VSS 0.0352f ; **FLOATING
C2255 VR.n376 VSS 0.03546f ; **FLOATING
C2256 VR.n377 VSS 0.04842f ; **FLOATING
C2257 VR.n378 VSS 0.03162f ; **FLOATING
C2258 VR.n379 VSS 0.03162f ; **FLOATING
C2259 VR.n380 VSS 0.03162f ; **FLOATING
C2260 VR.n381 VSS 0.03162f ; **FLOATING
C2261 VR.n382 VSS 0.04591f ; **FLOATING
C2262 VR.n383 VSS 0.06735f ; **FLOATING
C2263 VR.n384 VSS 0.0494f ; **FLOATING
C2264 VR.n385 VSS 0.04842f ; **FLOATING
C2265 VR.n386 VSS 0.03162f ; **FLOATING
C2266 VR.n387 VSS 0.03162f ; **FLOATING
C2267 VR.n388 VSS 0.03162f ; **FLOATING
C2268 VR.n389 VSS 0.03162f ; **FLOATING
C2269 VR.n390 VSS 0.03528f ; **FLOATING
C2270 VR.n391 VSS 0.02858f ; **FLOATING
C2271 VR.n392 VSS 0.67889f ; **FLOATING
C2272 VR.n393 VSS 0.90412f ; **FLOATING
C2273 VR.n394 VSS 0.23561f ; **FLOATING
C2274 VR.t188 VSS 0.04901f ; **FLOATING
C2275 VR.n395 VSS 0.09844f ; **FLOATING
C2276 VR.n396 VSS 0.06165f ; **FLOATING
C2277 VR.n397 VSS 0.18051f ; **FLOATING
C2278 VR.n398 VSS 0.03941f ; **FLOATING
C2279 VR.n399 VSS 0.23561f ; **FLOATING
C2280 VR.n400 VSS 0.23561f ; **FLOATING
C2281 VR.n401 VSS 0.03941f ; **FLOATING
C2282 VR.n402 VSS 0.08737f ; **FLOATING
C2283 VR.n403 VSS 5.21835f ; **FLOATING
C2284 VR.n404 VSS 0.19188f ; **FLOATING
C2285 VR.t4 VSS 0.02418f ; **FLOATING
C2286 VR.n405 VSS 0.03779f ; **FLOATING
C2287 VR.n406 VSS 0.05552f ; **FLOATING
C2288 VR.n407 VSS 0.17457f ; **FLOATING
C2289 VR.n408 VSS 0.19188f ; **FLOATING
C2290 VR.t297 VSS 0.02418f ; **FLOATING
C2291 VR.n409 VSS 0.03779f ; **FLOATING
C2292 VR.n410 VSS 0.05552f ; **FLOATING
C2293 VR.n411 VSS 0.08143f ; **FLOATING
C2294 VR.n412 VSS 4.08362f ; **FLOATING
C2295 VR.n413 VSS 2.92445f ; **FLOATING
C2296 VR.n414 VSS 0.19188f ; **FLOATING
C2297 VR.t26 VSS 0.02418f ; **FLOATING
C2298 VR.n415 VSS 0.03779f ; **FLOATING
C2299 VR.n416 VSS 0.05552f ; **FLOATING
C2300 VR.n417 VSS 1.72031f ; **FLOATING
C2301 VR.n418 VSS 3.40146f ; **FLOATING
C2302 VR.n419 VSS 0.19188f ; **FLOATING
C2303 VR.t47 VSS 0.02418f ; **FLOATING
C2304 VR.n420 VSS 0.03779f ; **FLOATING
C2305 VR.n421 VSS 0.05552f ; **FLOATING
C2306 VR.n422 VSS 0.17457f ; **FLOATING
C2307 VR.n423 VSS 0.19188f ; **FLOATING
C2308 VR.t92 VSS 0.02418f ; **FLOATING
C2309 VR.n424 VSS 0.03779f ; **FLOATING
C2310 VR.n425 VSS 0.05552f ; **FLOATING
C2311 VR.n426 VSS 0.08143f ; **FLOATING
C2312 VR.n427 VSS 4.08362f ; **FLOATING
C2313 VR.n428 VSS 2.07879f ; **FLOATING
C2314 VR.n429 VSS 0.19188f ; **FLOATING
C2315 VR.t37 VSS 0.02418f ; **FLOATING
C2316 VR.n430 VSS 0.03779f ; **FLOATING
C2317 VR.n431 VSS 0.05552f ; **FLOATING
C2318 VR.n432 VSS 0.17457f ; **FLOATING
C2319 VR.n433 VSS 0.19188f ; **FLOATING
C2320 VR.t31 VSS 0.02418f ; **FLOATING
C2321 VR.n434 VSS 0.03779f ; **FLOATING
C2322 VR.n435 VSS 0.05552f ; **FLOATING
C2323 VR.n436 VSS 0.08143f ; **FLOATING
C2324 VR.n437 VSS 5.22844f ; **FLOATING
C2325 VR.n438 VSS 0.23561f ; **FLOATING
C2326 VR.t33 VSS 0.04901f ; **FLOATING
C2327 VR.n439 VSS 0.09844f ; **FLOATING
C2328 VR.n440 VSS 0.06165f ; **FLOATING
C2329 VR.n441 VSS 0.18051f ; **FLOATING
C2330 VR.n442 VSS 0.03941f ; **FLOATING
C2331 VR.n443 VSS 0.23561f ; **FLOATING
C2332 VR.n444 VSS 0.23561f ; **FLOATING
C2333 VR.n445 VSS 0.03941f ; **FLOATING
C2334 VR.n446 VSS 0.08737f ; **FLOATING
C2335 VR.n447 VSS 4.95698f ; **FLOATING
C2336 VR.n448 VSS 2.0301f ; **FLOATING
C2337 VR.n449 VSS 0.23561f ; **FLOATING
C2338 VR.t138 VSS 0.04901f ; **FLOATING
C2339 VR.n450 VSS 0.09844f ; **FLOATING
C2340 VR.n451 VSS 0.06165f ; **FLOATING
C2341 VR.n452 VSS 0.18051f ; **FLOATING
C2342 VR.n453 VSS 0.03941f ; **FLOATING
C2343 VR.n454 VSS 0.23561f ; **FLOATING
C2344 VR.n455 VSS 0.23561f ; **FLOATING
C2345 VR.n456 VSS 0.03941f ; **FLOATING
C2346 VR.n457 VSS 0.08737f ; **FLOATING
C2347 VR.n458 VSS 4.95698f ; **FLOATING
C2348 VR.n459 VSS 1.31011f ; **FLOATING
C2349 VR.n460 VSS 0.72052f ; **FLOATING
C2350 VR.n461 VSS 2.65878f ; **FLOATING
C2351 VR.n462 VSS 0.19188f ; **FLOATING
C2352 VR.t58 VSS 0.02418f ; **FLOATING
C2353 VR.n463 VSS 0.03779f ; **FLOATING
C2354 VR.n464 VSS 0.05552f ; **FLOATING
C2355 VR.n465 VSS 0.21018f ; **FLOATING
C2356 VR.n466 VSS 3.19301f ; **FLOATING
C2357 VR.n467 VSS 0.06236f ; **FLOATING
C2358 VR.t39 VSS 0.03779f ; **FLOATING
C2359 VR.t43 VSS 0.03811f ; **FLOATING
C2360 VR.t45 VSS 0.03779f ; **FLOATING
C2361 VR.n468 VSS 0.09108f ; **FLOATING
C2362 VR.n469 VSS 0.0623f ; **FLOATING
C2363 VR.n470 VSS 0.22774f ; **FLOATING
C2364 VR.t44 VSS 0.16894f ; **FLOATING
C2365 VR.t42 VSS 0.08082f ; **FLOATING
C2366 VR.n471 VSS 0.05388f ; **FLOATING
C2367 VR.t40 VSS 0.08082f ; **FLOATING
C2368 VR.t38 VSS 0.16894f ; **FLOATING
C2369 VR.n472 VSS 1.9445f ; **FLOATING
C2370 VR.n473 VSS 0.06236f ; **FLOATING
C2371 VR.t61 VSS 0.03779f ; **FLOATING
C2372 VR.t65 VSS 0.03811f ; **FLOATING
C2373 VR.t67 VSS 0.03779f ; **FLOATING
C2374 VR.n474 VSS 0.09108f ; **FLOATING
C2375 VR.n475 VSS 0.0623f ; **FLOATING
C2376 VR.n476 VSS 0.22774f ; **FLOATING
C2377 VR.t66 VSS 0.16894f ; **FLOATING
C2378 VR.t64 VSS 0.08082f ; **FLOATING
C2379 VR.n477 VSS 0.05388f ; **FLOATING
C2380 VR.t62 VSS 0.08082f ; **FLOATING
C2381 VR.t60 VSS 0.16894f ; **FLOATING
C2382 VR.n478 VSS 1.9445f ; **FLOATING
C2383 VR.n479 VSS 3.53056f ; **FLOATING
C2384 VR.n480 VSS 0.06236f ; **FLOATING
C2385 VR.t193 VSS 0.03779f ; **FLOATING
C2386 VR.t98 VSS 0.03811f ; **FLOATING
C2387 VR.t291 VSS 0.03779f ; **FLOATING
C2388 VR.n481 VSS 0.09108f ; **FLOATING
C2389 VR.n482 VSS 0.0623f ; **FLOATING
C2390 VR.n483 VSS 0.22774f ; **FLOATING
C2391 VR.t290 VSS 0.16894f ; **FLOATING
C2392 VR.t97 VSS 0.08082f ; **FLOATING
C2393 VR.n484 VSS 0.05388f ; **FLOATING
C2394 VR.t34 VSS 0.08082f ; **FLOATING
C2395 VR.t192 VSS 0.16894f ; **FLOATING
C2396 VR.n485 VSS 1.9445f ; **FLOATING
C2397 VR.n486 VSS 5.06552f ; **FLOATING
C2398 VR.t123 VSS 0.03779f ; **FLOATING
C2399 VR.t127 VSS 0.03811f ; **FLOATING
C2400 VR.t129 VSS 0.03779f ; **FLOATING
C2401 VR.t303 VSS 0.03779f ; **FLOATING
C2402 VR.t307 VSS 0.03811f ; **FLOATING
C2403 VR.t309 VSS 0.03779f ; **FLOATING
C2404 VR.n487 VSS 0.2723f ; **FLOATING
C2405 VR.t308 VSS 0.18889f ; **FLOATING
C2406 VR.t306 VSS 0.12372f ; **FLOATING
C2407 VR.t304 VSS 0.12372f ; **FLOATING
C2408 VR.t302 VSS 0.13802f ; **FLOATING
C2409 VR.n488 VSS 0.15232f ; **FLOATING
C2410 VR.t128 VSS 0.13802f ; **FLOATING
C2411 VR.t126 VSS 0.12372f ; **FLOATING
C2412 VR.t124 VSS 0.12372f ; **FLOATING
C2413 VR.t122 VSS 0.18889f ; **FLOATING
C2414 VR.t220 VSS 0.02418f ; **FLOATING
C2415 VR.n489 VSS 0.04069f ; **FLOATING
C2416 VR.n490 VSS 0.05987f ; **FLOATING
C2417 VR.n491 VSS 0.09641f ; **FLOATING
C2418 VR.t176 VSS 0.02418f ; **FLOATING
C2419 VR.n492 VSS 0.04069f ; **FLOATING
C2420 VR.n493 VSS 0.05987f ; **FLOATING
C2421 VR.n494 VSS 0.09641f ; **FLOATING
C2422 VR.n495 VSS 0.23561f ; **FLOATING
C2423 VR.t218 VSS 0.04901f ; **FLOATING
C2424 VR.n496 VSS 0.09844f ; **FLOATING
C2425 VR.n497 VSS 0.06165f ; **FLOATING
C2426 VR.n498 VSS 0.08737f ; **FLOATING
C2427 VR.n499 VSS 0.23561f ; **FLOATING
C2428 VR.t174 VSS 0.04901f ; **FLOATING
C2429 VR.n500 VSS 0.09844f ; **FLOATING
C2430 VR.n501 VSS 0.06165f ; **FLOATING
C2431 VR.n502 VSS 0.08737f ; **FLOATING
C2432 VR.t11 VSS 0.03779f ; **FLOATING
C2433 VR.t15 VSS 0.03811f ; **FLOATING
C2434 VR.t17 VSS 0.03779f ; **FLOATING
C2435 VR.t259 VSS 0.03779f ; **FLOATING
C2436 VR.t263 VSS 0.03811f ; **FLOATING
C2437 VR.t265 VSS 0.03779f ; **FLOATING
C2438 VR.n503 VSS 0.2723f ; **FLOATING
C2439 VR.t264 VSS 0.18889f ; **FLOATING
C2440 VR.t262 VSS 0.12372f ; **FLOATING
C2441 VR.t260 VSS 0.12372f ; **FLOATING
C2442 VR.t258 VSS 0.13802f ; **FLOATING
C2443 VR.n504 VSS 0.15232f ; **FLOATING
C2444 VR.t16 VSS 0.13802f ; **FLOATING
C2445 VR.t14 VSS 0.12372f ; **FLOATING
C2446 VR.t12 VSS 0.12372f ; **FLOATING
C2447 VR.t10 VSS 0.18889f ; **FLOATING
C2448 VR.t301 VSS 0.02418f ; **FLOATING
C2449 VR.n505 VSS 0.04069f ; **FLOATING
C2450 VR.n506 VSS 0.05987f ; **FLOATING
C2451 VR.n507 VSS 0.09641f ; **FLOATING
C2452 VR.t131 VSS 0.02418f ; **FLOATING
C2453 VR.n508 VSS 0.04069f ; **FLOATING
C2454 VR.n509 VSS 0.05987f ; **FLOATING
C2455 VR.n510 VSS 0.09641f ; **FLOATING
C2456 VR.n511 VSS 0.23561f ; **FLOATING
C2457 VR.t311 VSS 0.04901f ; **FLOATING
C2458 VR.n512 VSS 0.09844f ; **FLOATING
C2459 VR.n513 VSS 0.06165f ; **FLOATING
C2460 VR.n514 VSS 0.08737f ; **FLOATING
C2461 VR.n515 VSS 0.23561f ; **FLOATING
C2462 VR.t133 VSS 0.04901f ; **FLOATING
C2463 VR.n516 VSS 0.09844f ; **FLOATING
C2464 VR.n517 VSS 0.06165f ; **FLOATING
C2465 VR.n518 VSS 0.08737f ; **FLOATING
C2466 VR.t216 VSS 0.03779f ; **FLOATING
C2467 VR.t224 VSS 0.03811f ; **FLOATING
C2468 VR.t226 VSS 0.03779f ; **FLOATING
C2469 VR.t178 VSS 0.03779f ; **FLOATING
C2470 VR.t182 VSS 0.03811f ; **FLOATING
C2471 VR.t184 VSS 0.03779f ; **FLOATING
C2472 VR.n519 VSS 0.2723f ; **FLOATING
C2473 VR.t183 VSS 0.18889f ; **FLOATING
C2474 VR.t181 VSS 0.12372f ; **FLOATING
C2475 VR.t179 VSS 0.12372f ; **FLOATING
C2476 VR.t177 VSS 0.13802f ; **FLOATING
C2477 VR.n520 VSS 0.15232f ; **FLOATING
C2478 VR.t225 VSS 0.13802f ; **FLOATING
C2479 VR.t223 VSS 0.12372f ; **FLOATING
C2480 VR.t221 VSS 0.12372f ; **FLOATING
C2481 VR.t215 VSS 0.18889f ; **FLOATING
C2482 VR.t280 VSS 0.02418f ; **FLOATING
C2483 VR.n521 VSS 0.04069f ; **FLOATING
C2484 VR.n522 VSS 0.05987f ; **FLOATING
C2485 VR.n523 VSS 0.09641f ; **FLOATING
C2486 VR.t74 VSS 0.02418f ; **FLOATING
C2487 VR.n524 VSS 0.04069f ; **FLOATING
C2488 VR.n525 VSS 0.05987f ; **FLOATING
C2489 VR.n526 VSS 0.09641f ; **FLOATING
C2490 VR.n527 VSS 0.23561f ; **FLOATING
C2491 VR.t278 VSS 0.04901f ; **FLOATING
C2492 VR.n528 VSS 0.09844f ; **FLOATING
C2493 VR.n529 VSS 0.06165f ; **FLOATING
C2494 VR.n530 VSS 0.08737f ; **FLOATING
C2495 VR.n531 VSS 0.23561f ; **FLOATING
C2496 VR.t76 VSS 0.04901f ; **FLOATING
C2497 VR.n532 VSS 0.09844f ; **FLOATING
C2498 VR.n533 VSS 0.06165f ; **FLOATING
C2499 VR.n534 VSS 0.08737f ; **FLOATING
C2500 VR.t282 VSS 0.03779f ; **FLOATING
C2501 VR.t286 VSS 0.03811f ; **FLOATING
C2502 VR.t288 VSS 0.03779f ; **FLOATING
C2503 VR.t72 VSS 0.03779f ; **FLOATING
C2504 VR.t80 VSS 0.03811f ; **FLOATING
C2505 VR.t82 VSS 0.03779f ; **FLOATING
C2506 VR.n535 VSS 0.2723f ; **FLOATING
C2507 VR.t81 VSS 0.18889f ; **FLOATING
C2508 VR.t79 VSS 0.12372f ; **FLOATING
C2509 VR.t77 VSS 0.12372f ; **FLOATING
C2510 VR.t71 VSS 0.13802f ; **FLOATING
C2511 VR.n536 VSS 0.15232f ; **FLOATING
C2512 VR.t287 VSS 0.13802f ; **FLOATING
C2513 VR.t285 VSS 0.12372f ; **FLOATING
C2514 VR.t283 VSS 0.12372f ; **FLOATING
C2515 VR.t281 VSS 0.18889f ; **FLOATING
C2516 VR.t19 VSS 0.02418f ; **FLOATING
C2517 VR.n537 VSS 0.04069f ; **FLOATING
C2518 VR.n538 VSS 0.05987f ; **FLOATING
C2519 VR.n539 VSS 0.09641f ; **FLOATING
C2520 VR.t257 VSS 0.02418f ; **FLOATING
C2521 VR.n540 VSS 0.04069f ; **FLOATING
C2522 VR.n541 VSS 0.05987f ; **FLOATING
C2523 VR.n542 VSS 0.09641f ; **FLOATING
C2524 VR.n543 VSS 0.23561f ; **FLOATING
C2525 VR.t21 VSS 0.04901f ; **FLOATING
C2526 VR.n544 VSS 0.09844f ; **FLOATING
C2527 VR.n545 VSS 0.06165f ; **FLOATING
C2528 VR.n546 VSS 0.08737f ; **FLOATING
C2529 VR.n547 VSS 0.23561f ; **FLOATING
C2530 VR.t267 VSS 0.04901f ; **FLOATING
C2531 VR.n548 VSS 0.09844f ; **FLOATING
C2532 VR.n549 VSS 0.06165f ; **FLOATING
C2533 VR.n550 VSS 0.08737f ; **FLOATING
C2534 VR.n551 VSS 17.0445f ; **FLOATING
C2535 VR.n552 VSS 0.06236f ; **FLOATING
C2536 VR.t249 VSS 0.03779f ; **FLOATING
C2537 VR.t251 VSS 0.03811f ; **FLOATING
C2538 VR.t255 VSS 0.03779f ; **FLOATING
C2539 VR.n553 VSS 0.09108f ; **FLOATING
C2540 VR.n554 VSS 0.0623f ; **FLOATING
C2541 VR.n555 VSS 0.22774f ; **FLOATING
C2542 VR.t254 VSS 0.16894f ; **FLOATING
C2543 VR.t250 VSS 0.08082f ; **FLOATING
C2544 VR.n556 VSS 0.05388f ; **FLOATING
C2545 VR.t252 VSS 0.08082f ; **FLOATING
C2546 VR.t248 VSS 0.16894f ; **FLOATING
C2547 VR.n557 VSS 3.13095f ; **FLOATING
C2548 VR.n558 VSS 2.74603f ; **FLOATING
C2549 VR.n559 VSS 0.06236f ; **FLOATING
C2550 VR.t316 VSS 0.03779f ; **FLOATING
C2551 VR.t322 VSS 0.03811f ; **FLOATING
C2552 VR.t324 VSS 0.03779f ; **FLOATING
C2553 VR.n560 VSS 0.09108f ; **FLOATING
C2554 VR.n561 VSS 0.0623f ; **FLOATING
C2555 VR.n562 VSS 0.22774f ; **FLOATING
C2556 VR.t323 VSS 0.16894f ; **FLOATING
C2557 VR.t321 VSS 0.08082f ; **FLOATING
C2558 VR.n563 VSS 0.05388f ; **FLOATING
C2559 VR.t319 VSS 0.08082f ; **FLOATING
C2560 VR.t315 VSS 0.16894f ; **FLOATING
C2561 VR.n564 VSS 3.13095f ; **FLOATING
C2562 VR.n565 VSS 2.19888f ; **FLOATING
C2563 VR.n566 VSS 0.06236f ; **FLOATING
C2564 VR.t236 VSS 0.03779f ; **FLOATING
C2565 VR.t240 VSS 0.03811f ; **FLOATING
C2566 VR.t242 VSS 0.03779f ; **FLOATING
C2567 VR.n567 VSS 0.09108f ; **FLOATING
C2568 VR.n568 VSS 0.0623f ; **FLOATING
C2569 VR.n569 VSS 0.22774f ; **FLOATING
C2570 VR.t241 VSS 0.16894f ; **FLOATING
C2571 VR.t239 VSS 0.08082f ; **FLOATING
C2572 VR.n570 VSS 0.05388f ; **FLOATING
C2573 VR.t237 VSS 0.08082f ; **FLOATING
C2574 VR.t235 VSS 0.16894f ; **FLOATING
C2575 VR.n571 VSS 3.675f ; **FLOATING
C2576 VR.n572 VSS 0.06236f ; **FLOATING
C2577 VR.t269 VSS 0.03779f ; **FLOATING
C2578 VR.t273 VSS 0.03811f ; **FLOATING
C2579 VR.t275 VSS 0.03779f ; **FLOATING
C2580 VR.n573 VSS 0.09108f ; **FLOATING
C2581 VR.n574 VSS 0.0623f ; **FLOATING
C2582 VR.n575 VSS 0.22774f ; **FLOATING
C2583 VR.t274 VSS 0.16894f ; **FLOATING
C2584 VR.t272 VSS 0.08082f ; **FLOATING
C2585 VR.n576 VSS 0.05388f ; **FLOATING
C2586 VR.t270 VSS 0.08082f ; **FLOATING
C2587 VR.t268 VSS 0.16894f ; **FLOATING
C2588 VR.n577 VSS 3.13095f ; **FLOATING
C2589 VR.n578 VSS 3.58194f ; **FLOATING
C2590 VR.n579 VSS 0.94435f ; **FLOATING
C2591 VR.t103 VSS 2.09117f ; **FLOATING
C2592 VR.t135 VSS 0.10374f ; **FLOATING
C2593 VR.n580 VSS 0.10041f ; **FLOATING
C2594 VR.n581 VSS 0.07944f ; **FLOATING
C2595 VR.n582 VSS 0.19807f ; **FLOATING
C2596 VR.t327 VSS 0.10374f ; **FLOATING
C2597 VR.n583 VSS 0.10041f ; **FLOATING
C2598 VR.n584 VSS 0.07944f ; **FLOATING
C2599 VR.n585 VSS 0.10494f ; **FLOATING
C2600 VR.t121 VSS 1.26066f ; **FLOATING
C2601 VR.n586 VSS 7.08388f ; **FLOATING
C2602 VR.n587 VSS 5.11192f ; **FLOATING
C2603 VR.n588 VSS 0.65436f ; **FLOATING
C2604 VR.n589 VSS 0.06236f ; **FLOATING
C2605 VR.t114 VSS 0.03779f ; **FLOATING
C2606 VR.t118 VSS 0.03811f ; **FLOATING
C2607 VR.t120 VSS 0.03779f ; **FLOATING
C2608 VR.n590 VSS 0.09108f ; **FLOATING
C2609 VR.n591 VSS 0.0623f ; **FLOATING
C2610 VR.n592 VSS 0.22774f ; **FLOATING
C2611 VR.t119 VSS 0.16894f ; **FLOATING
C2612 VR.t117 VSS 0.08082f ; **FLOATING
C2613 VR.n593 VSS 0.05388f ; **FLOATING
C2614 VR.t115 VSS 0.08082f ; **FLOATING
C2615 VR.t113 VSS 0.16894f ; **FLOATING
C2616 VR.n594 VSS 3.19615f ; **FLOATING
C2617 VR.n595 VSS 0.06236f ; **FLOATING
C2618 VR.t158 VSS 0.03779f ; **FLOATING
C2619 VR.t162 VSS 0.03811f ; **FLOATING
C2620 VR.t164 VSS 0.03779f ; **FLOATING
C2621 VR.n596 VSS 0.09108f ; **FLOATING
C2622 VR.n597 VSS 0.0623f ; **FLOATING
C2623 VR.n598 VSS 0.22774f ; **FLOATING
C2624 VR.t163 VSS 0.16894f ; **FLOATING
C2625 VR.t161 VSS 0.08082f ; **FLOATING
C2626 VR.n599 VSS 0.05388f ; **FLOATING
C2627 VR.t159 VSS 0.08082f ; **FLOATING
C2628 VR.t157 VSS 0.16894f ; **FLOATING
C2629 VR.n600 VSS 1.9445f ; **FLOATING
C2630 VR.n601 VSS 0.06236f ; **FLOATING
C2631 VR.t228 VSS 0.03779f ; **FLOATING
C2632 VR.t232 VSS 0.03811f ; **FLOATING
C2633 VR.t234 VSS 0.03779f ; **FLOATING
C2634 VR.n602 VSS 0.09108f ; **FLOATING
C2635 VR.n603 VSS 0.0623f ; **FLOATING
C2636 VR.n604 VSS 0.22774f ; **FLOATING
C2637 VR.t233 VSS 0.16894f ; **FLOATING
C2638 VR.t231 VSS 0.08082f ; **FLOATING
C2639 VR.n605 VSS 0.05388f ; **FLOATING
C2640 VR.t229 VSS 0.08082f ; **FLOATING
C2641 VR.t227 VSS 0.16894f ; **FLOATING
C2642 VR.n606 VSS 3.675f ; **FLOATING
C2643 VR.n607 VSS 0.06236f ; **FLOATING
C2644 VR.t207 VSS 0.03779f ; **FLOATING
C2645 VR.t211 VSS 0.03811f ; **FLOATING
C2646 VR.t213 VSS 0.03779f ; **FLOATING
C2647 VR.n608 VSS 0.09108f ; **FLOATING
C2648 VR.n609 VSS 0.0623f ; **FLOATING
C2649 VR.n610 VSS 0.22774f ; **FLOATING
C2650 VR.t212 VSS 0.16894f ; **FLOATING
C2651 VR.t210 VSS 0.08082f ; **FLOATING
C2652 VR.n611 VSS 0.05388f ; **FLOATING
C2653 VR.t208 VSS 0.08082f ; **FLOATING
C2654 VR.t206 VSS 0.16894f ; **FLOATING
C2655 VR.n612 VSS 3.13095f ; **FLOATING
C2656 VR.n613 VSS 3.75506f ; **FLOATING
C2657 VR.n614 VSS 1.91142f ; **FLOATING
C2658 VR.n615 VSS 0.19188f ; **FLOATING
C2659 VR.t314 VSS 0.02418f ; **FLOATING
C2660 VR.n616 VSS 0.03779f ; **FLOATING
C2661 VR.n617 VSS 0.05552f ; **FLOATING
C2662 VR.n618 VSS 0.17457f ; **FLOATING
C2663 VR.n619 VSS 0.19188f ; **FLOATING
C2664 VR.t246 VSS 0.02418f ; **FLOATING
C2665 VR.n620 VSS 0.03779f ; **FLOATING
C2666 VR.n621 VSS 0.05552f ; **FLOATING
C2667 VR.n622 VSS 0.08143f ; **FLOATING
C2668 VR.n623 VSS 4.08362f ; **FLOATING
C2669 VR.n624 VSS 1.99452f ; **FLOATING
C2670 VR.n625 VSS 0.23561f ; **FLOATING
C2671 VR.t318 VSS 0.04901f ; **FLOATING
C2672 VR.n626 VSS 0.09844f ; **FLOATING
C2673 VR.n627 VSS 0.06165f ; **FLOATING
C2674 VR.n628 VSS 0.18051f ; **FLOATING
C2675 VR.n629 VSS 0.03941f ; **FLOATING
C2676 VR.n630 VSS 0.23561f ; **FLOATING
C2677 VR.n631 VSS 0.23561f ; **FLOATING
C2678 VR.n632 VSS 0.03941f ; **FLOATING
C2679 VR.n633 VSS 0.08737f ; **FLOATING
C2680 VR.n634 VSS 4.1521f ; **FLOATING
C2681 VR.n635 VSS 2.22739f ; **FLOATING
C2682 VR.n636 VSS 0.19188f ; **FLOATING
C2683 VR.t199 VSS 0.02418f ; **FLOATING
C2684 VR.n637 VSS 0.03779f ; **FLOATING
C2685 VR.n638 VSS 0.05552f ; **FLOATING
C2686 VR.n639 VSS 0.17457f ; **FLOATING
C2687 VR.n640 VSS 0.19188f ; **FLOATING
C2688 VR.t9 VSS 0.02418f ; **FLOATING
C2689 VR.n641 VSS 0.03779f ; **FLOATING
C2690 VR.n642 VSS 0.05552f ; **FLOATING
C2691 VR.n643 VSS 0.08143f ; **FLOATING
C2692 VR.n644 VSS 4.08362f ; **FLOATING
C2693 VR.n645 VSS 2.16357f ; **FLOATING
C2694 VR.n646 VSS 0.23561f ; **FLOATING
C2695 VR.t244 VSS 0.04901f ; **FLOATING
C2696 VR.n647 VSS 0.09844f ; **FLOATING
C2697 VR.n648 VSS 0.06165f ; **FLOATING
C2698 VR.n649 VSS 0.18051f ; **FLOATING
C2699 VR.n650 VSS 0.03941f ; **FLOATING
C2700 VR.n651 VSS 0.23561f ; **FLOATING
C2701 VR.n652 VSS 0.23561f ; **FLOATING
C2702 VR.n653 VSS 0.03941f ; **FLOATING
C2703 VR.n654 VSS 0.08737f ; **FLOATING
C2704 VR.n655 VSS 4.1521f ; **FLOATING
C2705 VR.n656 VSS 2.87639f ; **FLOATING
C2706 LOIP.t0 VSS 0.11726f ; **FLOATING
C2707 LOIP.t1 VSS 0.11662f ; **FLOATING
C2708 LOIP.t2 VSS 0.15787f ; **FLOATING
C2709 LOIP.n0 VSS 0.09174f ; **FLOATING
C2710 LOIP.n1 VSS 5.60453f ; **FLOATING
C2711 LOIN.t1 VSS 0.14037f ; **FLOATING
C2712 LOIN.t0 VSS 0.13961f ; **FLOATING
C2713 LOIN.t2 VSS 0.189f ; **FLOATING
C2714 LOIN.n0 VSS 0.10983f ; **FLOATING
C2715 LOIN.n1 VSS 5.40853f ; **FLOATING
C2716 B1.t0 VSS 0.0369f ; **FLOATING
C2717 B1.t1 VSS 0.10574f ; **FLOATING
C2718 B1.n0 VSS 5.95062f ; **FLOATING
.ends

.subckt vco_ring4 VCTRL B0 B1 LOIP LOIN LOQP LOQN VR VDD VSS
XPEX VSS VDD VCTRL B0 B1 LOIP LOIN LOQP LOQN VR vco_ring4_flat
.ends
.end
