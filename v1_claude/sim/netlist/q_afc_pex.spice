** sch_path: /home/noritsuna/GPS/xschem/tb_afc.sch
**.subckt tb_afc
VDD vdd 0 3.3
VD0 d0 0 0
VD1 d1 0 0
VD2 d2 0 0
VD3 d3 0 0
VD4 d4 0 0
VD5 d5 0 0
VD6 d6 0 0
VD7 d7 0 0
XDAC d0 d1 d2 d3 d4 d5 d6 d7 out vdd 0 afc_dac
RLOAD out 0 100k
**** begin user architecture code
 .include /home/noritsuna/pdk/gf180mcuD/libs.tech/ngspice/design.ngspice
.lib /home/noritsuna/pdk/gf180mcuD/libs.tech/ngspice/sm141064.ngspice typical
.lib /home/noritsuna/pdk/gf180mcuD/libs.tech/ngspice/sm141064.ngspice res_typical
.lib /home/noritsuna/pdk/gf180mcuD/libs.tech/ngspice/sm141064.ngspice mimcap_typical

.control
set num_threads=1
alter VD0 dc = 0
alter VD1 dc = 0
alter VD2 dc = 0
alter VD3 dc = 0
alter VD4 dc = 0
alter VD5 dc = 0
alter VD6 dc = 0
alter VD7 dc = 0
op
echo DAC 0 $&v(out)
alter VD0 dc = 3.3
alter VD1 dc = 0
alter VD2 dc = 0
alter VD3 dc = 0
alter VD4 dc = 0
alter VD5 dc = 0
alter VD6 dc = 0
alter VD7 dc = 0
op
echo DAC 1 $&v(out)
alter VD0 dc = 0
alter VD1 dc = 3.3
alter VD2 dc = 0
alter VD3 dc = 0
alter VD4 dc = 0
alter VD5 dc = 0
alter VD6 dc = 0
alter VD7 dc = 0
op
echo DAC 2 $&v(out)
alter VD0 dc = 3.3
alter VD1 dc = 3.3
alter VD2 dc = 0
alter VD3 dc = 0
alter VD4 dc = 0
alter VD5 dc = 0
alter VD6 dc = 0
alter VD7 dc = 0
op
echo DAC 3 $&v(out)
alter VD0 dc = 0
alter VD1 dc = 0
alter VD2 dc = 3.3
alter VD3 dc = 0
alter VD4 dc = 0
alter VD5 dc = 0
alter VD6 dc = 0
alter VD7 dc = 0
op
echo DAC 4 $&v(out)
alter VD0 dc = 3.3
alter VD1 dc = 0
alter VD2 dc = 3.3
alter VD3 dc = 0
alter VD4 dc = 0
alter VD5 dc = 0
alter VD6 dc = 0
alter VD7 dc = 0
op
echo DAC 5 $&v(out)
alter VD0 dc = 0
alter VD1 dc = 3.3
alter VD2 dc = 3.3
alter VD3 dc = 0
alter VD4 dc = 0
alter VD5 dc = 0
alter VD6 dc = 0
alter VD7 dc = 0
op
echo DAC 6 $&v(out)
alter VD0 dc = 3.3
alter VD1 dc = 3.3
alter VD2 dc = 3.3
alter VD3 dc = 0
alter VD4 dc = 0
alter VD5 dc = 0
alter VD6 dc = 0
alter VD7 dc = 0
op
echo DAC 7 $&v(out)
alter VD0 dc = 0
alter VD1 dc = 0
alter VD2 dc = 0
alter VD3 dc = 3.3
alter VD4 dc = 0
alter VD5 dc = 0
alter VD6 dc = 0
alter VD7 dc = 0
op
echo DAC 8 $&v(out)
alter VD0 dc = 3.3
alter VD1 dc = 0
alter VD2 dc = 0
alter VD3 dc = 3.3
alter VD4 dc = 0
alter VD5 dc = 0
alter VD6 dc = 0
alter VD7 dc = 0
op
echo DAC 9 $&v(out)
alter VD0 dc = 0
alter VD1 dc = 3.3
alter VD2 dc = 0
alter VD3 dc = 3.3
alter VD4 dc = 0
alter VD5 dc = 0
alter VD6 dc = 0
alter VD7 dc = 0
op
echo DAC 10 $&v(out)
alter VD0 dc = 3.3
alter VD1 dc = 3.3
alter VD2 dc = 0
alter VD3 dc = 3.3
alter VD4 dc = 0
alter VD5 dc = 0
alter VD6 dc = 0
alter VD7 dc = 0
op
echo DAC 11 $&v(out)
alter VD0 dc = 0
alter VD1 dc = 0
alter VD2 dc = 3.3
alter VD3 dc = 3.3
alter VD4 dc = 0
alter VD5 dc = 0
alter VD6 dc = 0
alter VD7 dc = 0
op
echo DAC 12 $&v(out)
alter VD0 dc = 3.3
alter VD1 dc = 0
alter VD2 dc = 3.3
alter VD3 dc = 3.3
alter VD4 dc = 0
alter VD5 dc = 0
alter VD6 dc = 0
alter VD7 dc = 0
op
echo DAC 13 $&v(out)
alter VD0 dc = 0
alter VD1 dc = 3.3
alter VD2 dc = 3.3
alter VD3 dc = 3.3
alter VD4 dc = 0
alter VD5 dc = 0
alter VD6 dc = 0
alter VD7 dc = 0
op
echo DAC 14 $&v(out)
alter VD0 dc = 3.3
alter VD1 dc = 3.3
alter VD2 dc = 3.3
alter VD3 dc = 3.3
alter VD4 dc = 0
alter VD5 dc = 0
alter VD6 dc = 0
alter VD7 dc = 0
op
echo DAC 15 $&v(out)
alter VD0 dc = 0
alter VD1 dc = 0
alter VD2 dc = 0
alter VD3 dc = 0
alter VD4 dc = 3.3
alter VD5 dc = 0
alter VD6 dc = 0
alter VD7 dc = 0
op
echo DAC 16 $&v(out)
alter VD0 dc = 3.3
alter VD1 dc = 0
alter VD2 dc = 0
alter VD3 dc = 0
alter VD4 dc = 3.3
alter VD5 dc = 0
alter VD6 dc = 0
alter VD7 dc = 0
op
echo DAC 17 $&v(out)
alter VD0 dc = 0
alter VD1 dc = 3.3
alter VD2 dc = 0
alter VD3 dc = 0
alter VD4 dc = 3.3
alter VD5 dc = 0
alter VD6 dc = 0
alter VD7 dc = 0
op
echo DAC 18 $&v(out)
alter VD0 dc = 3.3
alter VD1 dc = 3.3
alter VD2 dc = 0
alter VD3 dc = 0
alter VD4 dc = 3.3
alter VD5 dc = 0
alter VD6 dc = 0
alter VD7 dc = 0
op
echo DAC 19 $&v(out)
alter VD0 dc = 0
alter VD1 dc = 0
alter VD2 dc = 3.3
alter VD3 dc = 0
alter VD4 dc = 3.3
alter VD5 dc = 0
alter VD6 dc = 0
alter VD7 dc = 0
op
echo DAC 20 $&v(out)
alter VD0 dc = 3.3
alter VD1 dc = 0
alter VD2 dc = 3.3
alter VD3 dc = 0
alter VD4 dc = 3.3
alter VD5 dc = 0
alter VD6 dc = 0
alter VD7 dc = 0
op
echo DAC 21 $&v(out)
alter VD0 dc = 0
alter VD1 dc = 3.3
alter VD2 dc = 3.3
alter VD3 dc = 0
alter VD4 dc = 3.3
alter VD5 dc = 0
alter VD6 dc = 0
alter VD7 dc = 0
op
echo DAC 22 $&v(out)
alter VD0 dc = 3.3
alter VD1 dc = 3.3
alter VD2 dc = 3.3
alter VD3 dc = 0
alter VD4 dc = 3.3
alter VD5 dc = 0
alter VD6 dc = 0
alter VD7 dc = 0
op
echo DAC 23 $&v(out)
alter VD0 dc = 0
alter VD1 dc = 0
alter VD2 dc = 0
alter VD3 dc = 3.3
alter VD4 dc = 3.3
alter VD5 dc = 0
alter VD6 dc = 0
alter VD7 dc = 0
op
echo DAC 24 $&v(out)
alter VD0 dc = 3.3
alter VD1 dc = 0
alter VD2 dc = 0
alter VD3 dc = 3.3
alter VD4 dc = 3.3
alter VD5 dc = 0
alter VD6 dc = 0
alter VD7 dc = 0
op
echo DAC 25 $&v(out)
alter VD0 dc = 0
alter VD1 dc = 3.3
alter VD2 dc = 0
alter VD3 dc = 3.3
alter VD4 dc = 3.3
alter VD5 dc = 0
alter VD6 dc = 0
alter VD7 dc = 0
op
echo DAC 26 $&v(out)
alter VD0 dc = 3.3
alter VD1 dc = 3.3
alter VD2 dc = 0
alter VD3 dc = 3.3
alter VD4 dc = 3.3
alter VD5 dc = 0
alter VD6 dc = 0
alter VD7 dc = 0
op
echo DAC 27 $&v(out)
alter VD0 dc = 0
alter VD1 dc = 0
alter VD2 dc = 3.3
alter VD3 dc = 3.3
alter VD4 dc = 3.3
alter VD5 dc = 0
alter VD6 dc = 0
alter VD7 dc = 0
op
echo DAC 28 $&v(out)
alter VD0 dc = 3.3
alter VD1 dc = 0
alter VD2 dc = 3.3
alter VD3 dc = 3.3
alter VD4 dc = 3.3
alter VD5 dc = 0
alter VD6 dc = 0
alter VD7 dc = 0
op
echo DAC 29 $&v(out)
alter VD0 dc = 0
alter VD1 dc = 3.3
alter VD2 dc = 3.3
alter VD3 dc = 3.3
alter VD4 dc = 3.3
alter VD5 dc = 0
alter VD6 dc = 0
alter VD7 dc = 0
op
echo DAC 30 $&v(out)
alter VD0 dc = 3.3
alter VD1 dc = 3.3
alter VD2 dc = 3.3
alter VD3 dc = 3.3
alter VD4 dc = 3.3
alter VD5 dc = 0
alter VD6 dc = 0
alter VD7 dc = 0
op
echo DAC 31 $&v(out)
alter VD0 dc = 0
alter VD1 dc = 0
alter VD2 dc = 0
alter VD3 dc = 0
alter VD4 dc = 0
alter VD5 dc = 3.3
alter VD6 dc = 0
alter VD7 dc = 0
op
echo DAC 32 $&v(out)
alter VD0 dc = 3.3
alter VD1 dc = 0
alter VD2 dc = 0
alter VD3 dc = 0
alter VD4 dc = 0
alter VD5 dc = 3.3
alter VD6 dc = 0
alter VD7 dc = 0
op
echo DAC 33 $&v(out)
alter VD0 dc = 0
alter VD1 dc = 3.3
alter VD2 dc = 0
alter VD3 dc = 0
alter VD4 dc = 0
alter VD5 dc = 3.3
alter VD6 dc = 0
alter VD7 dc = 0
op
echo DAC 34 $&v(out)
alter VD0 dc = 3.3
alter VD1 dc = 3.3
alter VD2 dc = 0
alter VD3 dc = 0
alter VD4 dc = 0
alter VD5 dc = 3.3
alter VD6 dc = 0
alter VD7 dc = 0
op
echo DAC 35 $&v(out)
alter VD0 dc = 0
alter VD1 dc = 0
alter VD2 dc = 3.3
alter VD3 dc = 0
alter VD4 dc = 0
alter VD5 dc = 3.3
alter VD6 dc = 0
alter VD7 dc = 0
op
echo DAC 36 $&v(out)
alter VD0 dc = 3.3
alter VD1 dc = 0
alter VD2 dc = 3.3
alter VD3 dc = 0
alter VD4 dc = 0
alter VD5 dc = 3.3
alter VD6 dc = 0
alter VD7 dc = 0
op
echo DAC 37 $&v(out)
alter VD0 dc = 0
alter VD1 dc = 3.3
alter VD2 dc = 3.3
alter VD3 dc = 0
alter VD4 dc = 0
alter VD5 dc = 3.3
alter VD6 dc = 0
alter VD7 dc = 0
op
echo DAC 38 $&v(out)
alter VD0 dc = 3.3
alter VD1 dc = 3.3
alter VD2 dc = 3.3
alter VD3 dc = 0
alter VD4 dc = 0
alter VD5 dc = 3.3
alter VD6 dc = 0
alter VD7 dc = 0
op
echo DAC 39 $&v(out)
alter VD0 dc = 0
alter VD1 dc = 0
alter VD2 dc = 0
alter VD3 dc = 3.3
alter VD4 dc = 0
alter VD5 dc = 3.3
alter VD6 dc = 0
alter VD7 dc = 0
op
echo DAC 40 $&v(out)
alter VD0 dc = 3.3
alter VD1 dc = 0
alter VD2 dc = 0
alter VD3 dc = 3.3
alter VD4 dc = 0
alter VD5 dc = 3.3
alter VD6 dc = 0
alter VD7 dc = 0
op
echo DAC 41 $&v(out)
alter VD0 dc = 0
alter VD1 dc = 3.3
alter VD2 dc = 0
alter VD3 dc = 3.3
alter VD4 dc = 0
alter VD5 dc = 3.3
alter VD6 dc = 0
alter VD7 dc = 0
op
echo DAC 42 $&v(out)
alter VD0 dc = 3.3
alter VD1 dc = 3.3
alter VD2 dc = 0
alter VD3 dc = 3.3
alter VD4 dc = 0
alter VD5 dc = 3.3
alter VD6 dc = 0
alter VD7 dc = 0
op
echo DAC 43 $&v(out)
alter VD0 dc = 0
alter VD1 dc = 0
alter VD2 dc = 3.3
alter VD3 dc = 3.3
alter VD4 dc = 0
alter VD5 dc = 3.3
alter VD6 dc = 0
alter VD7 dc = 0
op
echo DAC 44 $&v(out)
alter VD0 dc = 3.3
alter VD1 dc = 0
alter VD2 dc = 3.3
alter VD3 dc = 3.3
alter VD4 dc = 0
alter VD5 dc = 3.3
alter VD6 dc = 0
alter VD7 dc = 0
op
echo DAC 45 $&v(out)
alter VD0 dc = 0
alter VD1 dc = 3.3
alter VD2 dc = 3.3
alter VD3 dc = 3.3
alter VD4 dc = 0
alter VD5 dc = 3.3
alter VD6 dc = 0
alter VD7 dc = 0
op
echo DAC 46 $&v(out)
alter VD0 dc = 3.3
alter VD1 dc = 3.3
alter VD2 dc = 3.3
alter VD3 dc = 3.3
alter VD4 dc = 0
alter VD5 dc = 3.3
alter VD6 dc = 0
alter VD7 dc = 0
op
echo DAC 47 $&v(out)
alter VD0 dc = 0
alter VD1 dc = 0
alter VD2 dc = 0
alter VD3 dc = 0
alter VD4 dc = 3.3
alter VD5 dc = 3.3
alter VD6 dc = 0
alter VD7 dc = 0
op
echo DAC 48 $&v(out)
alter VD0 dc = 3.3
alter VD1 dc = 0
alter VD2 dc = 0
alter VD3 dc = 0
alter VD4 dc = 3.3
alter VD5 dc = 3.3
alter VD6 dc = 0
alter VD7 dc = 0
op
echo DAC 49 $&v(out)
alter VD0 dc = 0
alter VD1 dc = 3.3
alter VD2 dc = 0
alter VD3 dc = 0
alter VD4 dc = 3.3
alter VD5 dc = 3.3
alter VD6 dc = 0
alter VD7 dc = 0
op
echo DAC 50 $&v(out)
alter VD0 dc = 3.3
alter VD1 dc = 3.3
alter VD2 dc = 0
alter VD3 dc = 0
alter VD4 dc = 3.3
alter VD5 dc = 3.3
alter VD6 dc = 0
alter VD7 dc = 0
op
echo DAC 51 $&v(out)
alter VD0 dc = 0
alter VD1 dc = 0
alter VD2 dc = 3.3
alter VD3 dc = 0
alter VD4 dc = 3.3
alter VD5 dc = 3.3
alter VD6 dc = 0
alter VD7 dc = 0
op
echo DAC 52 $&v(out)
alter VD0 dc = 3.3
alter VD1 dc = 0
alter VD2 dc = 3.3
alter VD3 dc = 0
alter VD4 dc = 3.3
alter VD5 dc = 3.3
alter VD6 dc = 0
alter VD7 dc = 0
op
echo DAC 53 $&v(out)
alter VD0 dc = 0
alter VD1 dc = 3.3
alter VD2 dc = 3.3
alter VD3 dc = 0
alter VD4 dc = 3.3
alter VD5 dc = 3.3
alter VD6 dc = 0
alter VD7 dc = 0
op
echo DAC 54 $&v(out)
alter VD0 dc = 3.3
alter VD1 dc = 3.3
alter VD2 dc = 3.3
alter VD3 dc = 0
alter VD4 dc = 3.3
alter VD5 dc = 3.3
alter VD6 dc = 0
alter VD7 dc = 0
op
echo DAC 55 $&v(out)
alter VD0 dc = 0
alter VD1 dc = 0
alter VD2 dc = 0
alter VD3 dc = 3.3
alter VD4 dc = 3.3
alter VD5 dc = 3.3
alter VD6 dc = 0
alter VD7 dc = 0
op
echo DAC 56 $&v(out)
alter VD0 dc = 3.3
alter VD1 dc = 0
alter VD2 dc = 0
alter VD3 dc = 3.3
alter VD4 dc = 3.3
alter VD5 dc = 3.3
alter VD6 dc = 0
alter VD7 dc = 0
op
echo DAC 57 $&v(out)
alter VD0 dc = 0
alter VD1 dc = 3.3
alter VD2 dc = 0
alter VD3 dc = 3.3
alter VD4 dc = 3.3
alter VD5 dc = 3.3
alter VD6 dc = 0
alter VD7 dc = 0
op
echo DAC 58 $&v(out)
alter VD0 dc = 3.3
alter VD1 dc = 3.3
alter VD2 dc = 0
alter VD3 dc = 3.3
alter VD4 dc = 3.3
alter VD5 dc = 3.3
alter VD6 dc = 0
alter VD7 dc = 0
op
echo DAC 59 $&v(out)
alter VD0 dc = 0
alter VD1 dc = 0
alter VD2 dc = 3.3
alter VD3 dc = 3.3
alter VD4 dc = 3.3
alter VD5 dc = 3.3
alter VD6 dc = 0
alter VD7 dc = 0
op
echo DAC 60 $&v(out)
alter VD0 dc = 3.3
alter VD1 dc = 0
alter VD2 dc = 3.3
alter VD3 dc = 3.3
alter VD4 dc = 3.3
alter VD5 dc = 3.3
alter VD6 dc = 0
alter VD7 dc = 0
op
echo DAC 61 $&v(out)
alter VD0 dc = 0
alter VD1 dc = 3.3
alter VD2 dc = 3.3
alter VD3 dc = 3.3
alter VD4 dc = 3.3
alter VD5 dc = 3.3
alter VD6 dc = 0
alter VD7 dc = 0
op
echo DAC 62 $&v(out)
alter VD0 dc = 3.3
alter VD1 dc = 3.3
alter VD2 dc = 3.3
alter VD3 dc = 3.3
alter VD4 dc = 3.3
alter VD5 dc = 3.3
alter VD6 dc = 0
alter VD7 dc = 0
op
echo DAC 63 $&v(out)
alter VD0 dc = 0
alter VD1 dc = 0
alter VD2 dc = 0
alter VD3 dc = 0
alter VD4 dc = 0
alter VD5 dc = 0
alter VD6 dc = 3.3
alter VD7 dc = 0
op
echo DAC 64 $&v(out)
alter VD0 dc = 3.3
alter VD1 dc = 0
alter VD2 dc = 0
alter VD3 dc = 0
alter VD4 dc = 0
alter VD5 dc = 0
alter VD6 dc = 3.3
alter VD7 dc = 0
op
echo DAC 65 $&v(out)
alter VD0 dc = 0
alter VD1 dc = 3.3
alter VD2 dc = 0
alter VD3 dc = 0
alter VD4 dc = 0
alter VD5 dc = 0
alter VD6 dc = 3.3
alter VD7 dc = 0
op
echo DAC 66 $&v(out)
alter VD0 dc = 3.3
alter VD1 dc = 3.3
alter VD2 dc = 0
alter VD3 dc = 0
alter VD4 dc = 0
alter VD5 dc = 0
alter VD6 dc = 3.3
alter VD7 dc = 0
op
echo DAC 67 $&v(out)
alter VD0 dc = 0
alter VD1 dc = 0
alter VD2 dc = 3.3
alter VD3 dc = 0
alter VD4 dc = 0
alter VD5 dc = 0
alter VD6 dc = 3.3
alter VD7 dc = 0
op
echo DAC 68 $&v(out)
alter VD0 dc = 3.3
alter VD1 dc = 0
alter VD2 dc = 3.3
alter VD3 dc = 0
alter VD4 dc = 0
alter VD5 dc = 0
alter VD6 dc = 3.3
alter VD7 dc = 0
op
echo DAC 69 $&v(out)
alter VD0 dc = 0
alter VD1 dc = 3.3
alter VD2 dc = 3.3
alter VD3 dc = 0
alter VD4 dc = 0
alter VD5 dc = 0
alter VD6 dc = 3.3
alter VD7 dc = 0
op
echo DAC 70 $&v(out)
alter VD0 dc = 3.3
alter VD1 dc = 3.3
alter VD2 dc = 3.3
alter VD3 dc = 0
alter VD4 dc = 0
alter VD5 dc = 0
alter VD6 dc = 3.3
alter VD7 dc = 0
op
echo DAC 71 $&v(out)
alter VD0 dc = 0
alter VD1 dc = 0
alter VD2 dc = 0
alter VD3 dc = 3.3
alter VD4 dc = 0
alter VD5 dc = 0
alter VD6 dc = 3.3
alter VD7 dc = 0
op
echo DAC 72 $&v(out)
alter VD0 dc = 3.3
alter VD1 dc = 0
alter VD2 dc = 0
alter VD3 dc = 3.3
alter VD4 dc = 0
alter VD5 dc = 0
alter VD6 dc = 3.3
alter VD7 dc = 0
op
echo DAC 73 $&v(out)
alter VD0 dc = 0
alter VD1 dc = 3.3
alter VD2 dc = 0
alter VD3 dc = 3.3
alter VD4 dc = 0
alter VD5 dc = 0
alter VD6 dc = 3.3
alter VD7 dc = 0
op
echo DAC 74 $&v(out)
alter VD0 dc = 3.3
alter VD1 dc = 3.3
alter VD2 dc = 0
alter VD3 dc = 3.3
alter VD4 dc = 0
alter VD5 dc = 0
alter VD6 dc = 3.3
alter VD7 dc = 0
op
echo DAC 75 $&v(out)
alter VD0 dc = 0
alter VD1 dc = 0
alter VD2 dc = 3.3
alter VD3 dc = 3.3
alter VD4 dc = 0
alter VD5 dc = 0
alter VD6 dc = 3.3
alter VD7 dc = 0
op
echo DAC 76 $&v(out)
alter VD0 dc = 3.3
alter VD1 dc = 0
alter VD2 dc = 3.3
alter VD3 dc = 3.3
alter VD4 dc = 0
alter VD5 dc = 0
alter VD6 dc = 3.3
alter VD7 dc = 0
op
echo DAC 77 $&v(out)
alter VD0 dc = 0
alter VD1 dc = 3.3
alter VD2 dc = 3.3
alter VD3 dc = 3.3
alter VD4 dc = 0
alter VD5 dc = 0
alter VD6 dc = 3.3
alter VD7 dc = 0
op
echo DAC 78 $&v(out)
alter VD0 dc = 3.3
alter VD1 dc = 3.3
alter VD2 dc = 3.3
alter VD3 dc = 3.3
alter VD4 dc = 0
alter VD5 dc = 0
alter VD6 dc = 3.3
alter VD7 dc = 0
op
echo DAC 79 $&v(out)
alter VD0 dc = 0
alter VD1 dc = 0
alter VD2 dc = 0
alter VD3 dc = 0
alter VD4 dc = 3.3
alter VD5 dc = 0
alter VD6 dc = 3.3
alter VD7 dc = 0
op
echo DAC 80 $&v(out)
alter VD0 dc = 3.3
alter VD1 dc = 0
alter VD2 dc = 0
alter VD3 dc = 0
alter VD4 dc = 3.3
alter VD5 dc = 0
alter VD6 dc = 3.3
alter VD7 dc = 0
op
echo DAC 81 $&v(out)
alter VD0 dc = 0
alter VD1 dc = 3.3
alter VD2 dc = 0
alter VD3 dc = 0
alter VD4 dc = 3.3
alter VD5 dc = 0
alter VD6 dc = 3.3
alter VD7 dc = 0
op
echo DAC 82 $&v(out)
alter VD0 dc = 3.3
alter VD1 dc = 3.3
alter VD2 dc = 0
alter VD3 dc = 0
alter VD4 dc = 3.3
alter VD5 dc = 0
alter VD6 dc = 3.3
alter VD7 dc = 0
op
echo DAC 83 $&v(out)
alter VD0 dc = 0
alter VD1 dc = 0
alter VD2 dc = 3.3
alter VD3 dc = 0
alter VD4 dc = 3.3
alter VD5 dc = 0
alter VD6 dc = 3.3
alter VD7 dc = 0
op
echo DAC 84 $&v(out)
alter VD0 dc = 3.3
alter VD1 dc = 0
alter VD2 dc = 3.3
alter VD3 dc = 0
alter VD4 dc = 3.3
alter VD5 dc = 0
alter VD6 dc = 3.3
alter VD7 dc = 0
op
echo DAC 85 $&v(out)
alter VD0 dc = 0
alter VD1 dc = 3.3
alter VD2 dc = 3.3
alter VD3 dc = 0
alter VD4 dc = 3.3
alter VD5 dc = 0
alter VD6 dc = 3.3
alter VD7 dc = 0
op
echo DAC 86 $&v(out)
alter VD0 dc = 3.3
alter VD1 dc = 3.3
alter VD2 dc = 3.3
alter VD3 dc = 0
alter VD4 dc = 3.3
alter VD5 dc = 0
alter VD6 dc = 3.3
alter VD7 dc = 0
op
echo DAC 87 $&v(out)
alter VD0 dc = 0
alter VD1 dc = 0
alter VD2 dc = 0
alter VD3 dc = 3.3
alter VD4 dc = 3.3
alter VD5 dc = 0
alter VD6 dc = 3.3
alter VD7 dc = 0
op
echo DAC 88 $&v(out)
alter VD0 dc = 3.3
alter VD1 dc = 0
alter VD2 dc = 0
alter VD3 dc = 3.3
alter VD4 dc = 3.3
alter VD5 dc = 0
alter VD6 dc = 3.3
alter VD7 dc = 0
op
echo DAC 89 $&v(out)
alter VD0 dc = 0
alter VD1 dc = 3.3
alter VD2 dc = 0
alter VD3 dc = 3.3
alter VD4 dc = 3.3
alter VD5 dc = 0
alter VD6 dc = 3.3
alter VD7 dc = 0
op
echo DAC 90 $&v(out)
alter VD0 dc = 3.3
alter VD1 dc = 3.3
alter VD2 dc = 0
alter VD3 dc = 3.3
alter VD4 dc = 3.3
alter VD5 dc = 0
alter VD6 dc = 3.3
alter VD7 dc = 0
op
echo DAC 91 $&v(out)
alter VD0 dc = 0
alter VD1 dc = 0
alter VD2 dc = 3.3
alter VD3 dc = 3.3
alter VD4 dc = 3.3
alter VD5 dc = 0
alter VD6 dc = 3.3
alter VD7 dc = 0
op
echo DAC 92 $&v(out)
alter VD0 dc = 3.3
alter VD1 dc = 0
alter VD2 dc = 3.3
alter VD3 dc = 3.3
alter VD4 dc = 3.3
alter VD5 dc = 0
alter VD6 dc = 3.3
alter VD7 dc = 0
op
echo DAC 93 $&v(out)
alter VD0 dc = 0
alter VD1 dc = 3.3
alter VD2 dc = 3.3
alter VD3 dc = 3.3
alter VD4 dc = 3.3
alter VD5 dc = 0
alter VD6 dc = 3.3
alter VD7 dc = 0
op
echo DAC 94 $&v(out)
alter VD0 dc = 3.3
alter VD1 dc = 3.3
alter VD2 dc = 3.3
alter VD3 dc = 3.3
alter VD4 dc = 3.3
alter VD5 dc = 0
alter VD6 dc = 3.3
alter VD7 dc = 0
op
echo DAC 95 $&v(out)
alter VD0 dc = 0
alter VD1 dc = 0
alter VD2 dc = 0
alter VD3 dc = 0
alter VD4 dc = 0
alter VD5 dc = 3.3
alter VD6 dc = 3.3
alter VD7 dc = 0
op
echo DAC 96 $&v(out)
alter VD0 dc = 3.3
alter VD1 dc = 0
alter VD2 dc = 0
alter VD3 dc = 0
alter VD4 dc = 0
alter VD5 dc = 3.3
alter VD6 dc = 3.3
alter VD7 dc = 0
op
echo DAC 97 $&v(out)
alter VD0 dc = 0
alter VD1 dc = 3.3
alter VD2 dc = 0
alter VD3 dc = 0
alter VD4 dc = 0
alter VD5 dc = 3.3
alter VD6 dc = 3.3
alter VD7 dc = 0
op
echo DAC 98 $&v(out)
alter VD0 dc = 3.3
alter VD1 dc = 3.3
alter VD2 dc = 0
alter VD3 dc = 0
alter VD4 dc = 0
alter VD5 dc = 3.3
alter VD6 dc = 3.3
alter VD7 dc = 0
op
echo DAC 99 $&v(out)
alter VD0 dc = 0
alter VD1 dc = 0
alter VD2 dc = 3.3
alter VD3 dc = 0
alter VD4 dc = 0
alter VD5 dc = 3.3
alter VD6 dc = 3.3
alter VD7 dc = 0
op
echo DAC 100 $&v(out)
alter VD0 dc = 3.3
alter VD1 dc = 0
alter VD2 dc = 3.3
alter VD3 dc = 0
alter VD4 dc = 0
alter VD5 dc = 3.3
alter VD6 dc = 3.3
alter VD7 dc = 0
op
echo DAC 101 $&v(out)
alter VD0 dc = 0
alter VD1 dc = 3.3
alter VD2 dc = 3.3
alter VD3 dc = 0
alter VD4 dc = 0
alter VD5 dc = 3.3
alter VD6 dc = 3.3
alter VD7 dc = 0
op
echo DAC 102 $&v(out)
alter VD0 dc = 3.3
alter VD1 dc = 3.3
alter VD2 dc = 3.3
alter VD3 dc = 0
alter VD4 dc = 0
alter VD5 dc = 3.3
alter VD6 dc = 3.3
alter VD7 dc = 0
op
echo DAC 103 $&v(out)
alter VD0 dc = 0
alter VD1 dc = 0
alter VD2 dc = 0
alter VD3 dc = 3.3
alter VD4 dc = 0
alter VD5 dc = 3.3
alter VD6 dc = 3.3
alter VD7 dc = 0
op
echo DAC 104 $&v(out)
alter VD0 dc = 3.3
alter VD1 dc = 0
alter VD2 dc = 0
alter VD3 dc = 3.3
alter VD4 dc = 0
alter VD5 dc = 3.3
alter VD6 dc = 3.3
alter VD7 dc = 0
op
echo DAC 105 $&v(out)
alter VD0 dc = 0
alter VD1 dc = 3.3
alter VD2 dc = 0
alter VD3 dc = 3.3
alter VD4 dc = 0
alter VD5 dc = 3.3
alter VD6 dc = 3.3
alter VD7 dc = 0
op
echo DAC 106 $&v(out)
alter VD0 dc = 3.3
alter VD1 dc = 3.3
alter VD2 dc = 0
alter VD3 dc = 3.3
alter VD4 dc = 0
alter VD5 dc = 3.3
alter VD6 dc = 3.3
alter VD7 dc = 0
op
echo DAC 107 $&v(out)
alter VD0 dc = 0
alter VD1 dc = 0
alter VD2 dc = 3.3
alter VD3 dc = 3.3
alter VD4 dc = 0
alter VD5 dc = 3.3
alter VD6 dc = 3.3
alter VD7 dc = 0
op
echo DAC 108 $&v(out)
alter VD0 dc = 3.3
alter VD1 dc = 0
alter VD2 dc = 3.3
alter VD3 dc = 3.3
alter VD4 dc = 0
alter VD5 dc = 3.3
alter VD6 dc = 3.3
alter VD7 dc = 0
op
echo DAC 109 $&v(out)
alter VD0 dc = 0
alter VD1 dc = 3.3
alter VD2 dc = 3.3
alter VD3 dc = 3.3
alter VD4 dc = 0
alter VD5 dc = 3.3
alter VD6 dc = 3.3
alter VD7 dc = 0
op
echo DAC 110 $&v(out)
alter VD0 dc = 3.3
alter VD1 dc = 3.3
alter VD2 dc = 3.3
alter VD3 dc = 3.3
alter VD4 dc = 0
alter VD5 dc = 3.3
alter VD6 dc = 3.3
alter VD7 dc = 0
op
echo DAC 111 $&v(out)
alter VD0 dc = 0
alter VD1 dc = 0
alter VD2 dc = 0
alter VD3 dc = 0
alter VD4 dc = 3.3
alter VD5 dc = 3.3
alter VD6 dc = 3.3
alter VD7 dc = 0
op
echo DAC 112 $&v(out)
alter VD0 dc = 3.3
alter VD1 dc = 0
alter VD2 dc = 0
alter VD3 dc = 0
alter VD4 dc = 3.3
alter VD5 dc = 3.3
alter VD6 dc = 3.3
alter VD7 dc = 0
op
echo DAC 113 $&v(out)
alter VD0 dc = 0
alter VD1 dc = 3.3
alter VD2 dc = 0
alter VD3 dc = 0
alter VD4 dc = 3.3
alter VD5 dc = 3.3
alter VD6 dc = 3.3
alter VD7 dc = 0
op
echo DAC 114 $&v(out)
alter VD0 dc = 3.3
alter VD1 dc = 3.3
alter VD2 dc = 0
alter VD3 dc = 0
alter VD4 dc = 3.3
alter VD5 dc = 3.3
alter VD6 dc = 3.3
alter VD7 dc = 0
op
echo DAC 115 $&v(out)
alter VD0 dc = 0
alter VD1 dc = 0
alter VD2 dc = 3.3
alter VD3 dc = 0
alter VD4 dc = 3.3
alter VD5 dc = 3.3
alter VD6 dc = 3.3
alter VD7 dc = 0
op
echo DAC 116 $&v(out)
alter VD0 dc = 3.3
alter VD1 dc = 0
alter VD2 dc = 3.3
alter VD3 dc = 0
alter VD4 dc = 3.3
alter VD5 dc = 3.3
alter VD6 dc = 3.3
alter VD7 dc = 0
op
echo DAC 117 $&v(out)
alter VD0 dc = 0
alter VD1 dc = 3.3
alter VD2 dc = 3.3
alter VD3 dc = 0
alter VD4 dc = 3.3
alter VD5 dc = 3.3
alter VD6 dc = 3.3
alter VD7 dc = 0
op
echo DAC 118 $&v(out)
alter VD0 dc = 3.3
alter VD1 dc = 3.3
alter VD2 dc = 3.3
alter VD3 dc = 0
alter VD4 dc = 3.3
alter VD5 dc = 3.3
alter VD6 dc = 3.3
alter VD7 dc = 0
op
echo DAC 119 $&v(out)
alter VD0 dc = 0
alter VD1 dc = 0
alter VD2 dc = 0
alter VD3 dc = 3.3
alter VD4 dc = 3.3
alter VD5 dc = 3.3
alter VD6 dc = 3.3
alter VD7 dc = 0
op
echo DAC 120 $&v(out)
alter VD0 dc = 3.3
alter VD1 dc = 0
alter VD2 dc = 0
alter VD3 dc = 3.3
alter VD4 dc = 3.3
alter VD5 dc = 3.3
alter VD6 dc = 3.3
alter VD7 dc = 0
op
echo DAC 121 $&v(out)
alter VD0 dc = 0
alter VD1 dc = 3.3
alter VD2 dc = 0
alter VD3 dc = 3.3
alter VD4 dc = 3.3
alter VD5 dc = 3.3
alter VD6 dc = 3.3
alter VD7 dc = 0
op
echo DAC 122 $&v(out)
alter VD0 dc = 3.3
alter VD1 dc = 3.3
alter VD2 dc = 0
alter VD3 dc = 3.3
alter VD4 dc = 3.3
alter VD5 dc = 3.3
alter VD6 dc = 3.3
alter VD7 dc = 0
op
echo DAC 123 $&v(out)
alter VD0 dc = 0
alter VD1 dc = 0
alter VD2 dc = 3.3
alter VD3 dc = 3.3
alter VD4 dc = 3.3
alter VD5 dc = 3.3
alter VD6 dc = 3.3
alter VD7 dc = 0
op
echo DAC 124 $&v(out)
alter VD0 dc = 3.3
alter VD1 dc = 0
alter VD2 dc = 3.3
alter VD3 dc = 3.3
alter VD4 dc = 3.3
alter VD5 dc = 3.3
alter VD6 dc = 3.3
alter VD7 dc = 0
op
echo DAC 125 $&v(out)
alter VD0 dc = 0
alter VD1 dc = 3.3
alter VD2 dc = 3.3
alter VD3 dc = 3.3
alter VD4 dc = 3.3
alter VD5 dc = 3.3
alter VD6 dc = 3.3
alter VD7 dc = 0
op
echo DAC 126 $&v(out)
alter VD0 dc = 3.3
alter VD1 dc = 3.3
alter VD2 dc = 3.3
alter VD3 dc = 3.3
alter VD4 dc = 3.3
alter VD5 dc = 3.3
alter VD6 dc = 3.3
alter VD7 dc = 0
op
echo DAC 127 $&v(out)
alter VD0 dc = 0
alter VD1 dc = 0
alter VD2 dc = 0
alter VD3 dc = 0
alter VD4 dc = 0
alter VD5 dc = 0
alter VD6 dc = 0
alter VD7 dc = 3.3
op
echo DAC 128 $&v(out)
alter VD0 dc = 3.3
alter VD1 dc = 0
alter VD2 dc = 0
alter VD3 dc = 0
alter VD4 dc = 0
alter VD5 dc = 0
alter VD6 dc = 0
alter VD7 dc = 3.3
op
echo DAC 129 $&v(out)
alter VD0 dc = 0
alter VD1 dc = 3.3
alter VD2 dc = 0
alter VD3 dc = 0
alter VD4 dc = 0
alter VD5 dc = 0
alter VD6 dc = 0
alter VD7 dc = 3.3
op
echo DAC 130 $&v(out)
alter VD0 dc = 3.3
alter VD1 dc = 3.3
alter VD2 dc = 0
alter VD3 dc = 0
alter VD4 dc = 0
alter VD5 dc = 0
alter VD6 dc = 0
alter VD7 dc = 3.3
op
echo DAC 131 $&v(out)
alter VD0 dc = 0
alter VD1 dc = 0
alter VD2 dc = 3.3
alter VD3 dc = 0
alter VD4 dc = 0
alter VD5 dc = 0
alter VD6 dc = 0
alter VD7 dc = 3.3
op
echo DAC 132 $&v(out)
alter VD0 dc = 3.3
alter VD1 dc = 0
alter VD2 dc = 3.3
alter VD3 dc = 0
alter VD4 dc = 0
alter VD5 dc = 0
alter VD6 dc = 0
alter VD7 dc = 3.3
op
echo DAC 133 $&v(out)
alter VD0 dc = 0
alter VD1 dc = 3.3
alter VD2 dc = 3.3
alter VD3 dc = 0
alter VD4 dc = 0
alter VD5 dc = 0
alter VD6 dc = 0
alter VD7 dc = 3.3
op
echo DAC 134 $&v(out)
alter VD0 dc = 3.3
alter VD1 dc = 3.3
alter VD2 dc = 3.3
alter VD3 dc = 0
alter VD4 dc = 0
alter VD5 dc = 0
alter VD6 dc = 0
alter VD7 dc = 3.3
op
echo DAC 135 $&v(out)
alter VD0 dc = 0
alter VD1 dc = 0
alter VD2 dc = 0
alter VD3 dc = 3.3
alter VD4 dc = 0
alter VD5 dc = 0
alter VD6 dc = 0
alter VD7 dc = 3.3
op
echo DAC 136 $&v(out)
alter VD0 dc = 3.3
alter VD1 dc = 0
alter VD2 dc = 0
alter VD3 dc = 3.3
alter VD4 dc = 0
alter VD5 dc = 0
alter VD6 dc = 0
alter VD7 dc = 3.3
op
echo DAC 137 $&v(out)
alter VD0 dc = 0
alter VD1 dc = 3.3
alter VD2 dc = 0
alter VD3 dc = 3.3
alter VD4 dc = 0
alter VD5 dc = 0
alter VD6 dc = 0
alter VD7 dc = 3.3
op
echo DAC 138 $&v(out)
alter VD0 dc = 3.3
alter VD1 dc = 3.3
alter VD2 dc = 0
alter VD3 dc = 3.3
alter VD4 dc = 0
alter VD5 dc = 0
alter VD6 dc = 0
alter VD7 dc = 3.3
op
echo DAC 139 $&v(out)
alter VD0 dc = 0
alter VD1 dc = 0
alter VD2 dc = 3.3
alter VD3 dc = 3.3
alter VD4 dc = 0
alter VD5 dc = 0
alter VD6 dc = 0
alter VD7 dc = 3.3
op
echo DAC 140 $&v(out)
alter VD0 dc = 3.3
alter VD1 dc = 0
alter VD2 dc = 3.3
alter VD3 dc = 3.3
alter VD4 dc = 0
alter VD5 dc = 0
alter VD6 dc = 0
alter VD7 dc = 3.3
op
echo DAC 141 $&v(out)
alter VD0 dc = 0
alter VD1 dc = 3.3
alter VD2 dc = 3.3
alter VD3 dc = 3.3
alter VD4 dc = 0
alter VD5 dc = 0
alter VD6 dc = 0
alter VD7 dc = 3.3
op
echo DAC 142 $&v(out)
alter VD0 dc = 3.3
alter VD1 dc = 3.3
alter VD2 dc = 3.3
alter VD3 dc = 3.3
alter VD4 dc = 0
alter VD5 dc = 0
alter VD6 dc = 0
alter VD7 dc = 3.3
op
echo DAC 143 $&v(out)
alter VD0 dc = 0
alter VD1 dc = 0
alter VD2 dc = 0
alter VD3 dc = 0
alter VD4 dc = 3.3
alter VD5 dc = 0
alter VD6 dc = 0
alter VD7 dc = 3.3
op
echo DAC 144 $&v(out)
alter VD0 dc = 3.3
alter VD1 dc = 0
alter VD2 dc = 0
alter VD3 dc = 0
alter VD4 dc = 3.3
alter VD5 dc = 0
alter VD6 dc = 0
alter VD7 dc = 3.3
op
echo DAC 145 $&v(out)
alter VD0 dc = 0
alter VD1 dc = 3.3
alter VD2 dc = 0
alter VD3 dc = 0
alter VD4 dc = 3.3
alter VD5 dc = 0
alter VD6 dc = 0
alter VD7 dc = 3.3
op
echo DAC 146 $&v(out)
alter VD0 dc = 3.3
alter VD1 dc = 3.3
alter VD2 dc = 0
alter VD3 dc = 0
alter VD4 dc = 3.3
alter VD5 dc = 0
alter VD6 dc = 0
alter VD7 dc = 3.3
op
echo DAC 147 $&v(out)
alter VD0 dc = 0
alter VD1 dc = 0
alter VD2 dc = 3.3
alter VD3 dc = 0
alter VD4 dc = 3.3
alter VD5 dc = 0
alter VD6 dc = 0
alter VD7 dc = 3.3
op
echo DAC 148 $&v(out)
alter VD0 dc = 3.3
alter VD1 dc = 0
alter VD2 dc = 3.3
alter VD3 dc = 0
alter VD4 dc = 3.3
alter VD5 dc = 0
alter VD6 dc = 0
alter VD7 dc = 3.3
op
echo DAC 149 $&v(out)
alter VD0 dc = 0
alter VD1 dc = 3.3
alter VD2 dc = 3.3
alter VD3 dc = 0
alter VD4 dc = 3.3
alter VD5 dc = 0
alter VD6 dc = 0
alter VD7 dc = 3.3
op
echo DAC 150 $&v(out)
alter VD0 dc = 3.3
alter VD1 dc = 3.3
alter VD2 dc = 3.3
alter VD3 dc = 0
alter VD4 dc = 3.3
alter VD5 dc = 0
alter VD6 dc = 0
alter VD7 dc = 3.3
op
echo DAC 151 $&v(out)
alter VD0 dc = 0
alter VD1 dc = 0
alter VD2 dc = 0
alter VD3 dc = 3.3
alter VD4 dc = 3.3
alter VD5 dc = 0
alter VD6 dc = 0
alter VD7 dc = 3.3
op
echo DAC 152 $&v(out)
alter VD0 dc = 3.3
alter VD1 dc = 0
alter VD2 dc = 0
alter VD3 dc = 3.3
alter VD4 dc = 3.3
alter VD5 dc = 0
alter VD6 dc = 0
alter VD7 dc = 3.3
op
echo DAC 153 $&v(out)
alter VD0 dc = 0
alter VD1 dc = 3.3
alter VD2 dc = 0
alter VD3 dc = 3.3
alter VD4 dc = 3.3
alter VD5 dc = 0
alter VD6 dc = 0
alter VD7 dc = 3.3
op
echo DAC 154 $&v(out)
alter VD0 dc = 3.3
alter VD1 dc = 3.3
alter VD2 dc = 0
alter VD3 dc = 3.3
alter VD4 dc = 3.3
alter VD5 dc = 0
alter VD6 dc = 0
alter VD7 dc = 3.3
op
echo DAC 155 $&v(out)
alter VD0 dc = 0
alter VD1 dc = 0
alter VD2 dc = 3.3
alter VD3 dc = 3.3
alter VD4 dc = 3.3
alter VD5 dc = 0
alter VD6 dc = 0
alter VD7 dc = 3.3
op
echo DAC 156 $&v(out)
alter VD0 dc = 3.3
alter VD1 dc = 0
alter VD2 dc = 3.3
alter VD3 dc = 3.3
alter VD4 dc = 3.3
alter VD5 dc = 0
alter VD6 dc = 0
alter VD7 dc = 3.3
op
echo DAC 157 $&v(out)
alter VD0 dc = 0
alter VD1 dc = 3.3
alter VD2 dc = 3.3
alter VD3 dc = 3.3
alter VD4 dc = 3.3
alter VD5 dc = 0
alter VD6 dc = 0
alter VD7 dc = 3.3
op
echo DAC 158 $&v(out)
alter VD0 dc = 3.3
alter VD1 dc = 3.3
alter VD2 dc = 3.3
alter VD3 dc = 3.3
alter VD4 dc = 3.3
alter VD5 dc = 0
alter VD6 dc = 0
alter VD7 dc = 3.3
op
echo DAC 159 $&v(out)
alter VD0 dc = 0
alter VD1 dc = 0
alter VD2 dc = 0
alter VD3 dc = 0
alter VD4 dc = 0
alter VD5 dc = 3.3
alter VD6 dc = 0
alter VD7 dc = 3.3
op
echo DAC 160 $&v(out)
alter VD0 dc = 3.3
alter VD1 dc = 0
alter VD2 dc = 0
alter VD3 dc = 0
alter VD4 dc = 0
alter VD5 dc = 3.3
alter VD6 dc = 0
alter VD7 dc = 3.3
op
echo DAC 161 $&v(out)
alter VD0 dc = 0
alter VD1 dc = 3.3
alter VD2 dc = 0
alter VD3 dc = 0
alter VD4 dc = 0
alter VD5 dc = 3.3
alter VD6 dc = 0
alter VD7 dc = 3.3
op
echo DAC 162 $&v(out)
alter VD0 dc = 3.3
alter VD1 dc = 3.3
alter VD2 dc = 0
alter VD3 dc = 0
alter VD4 dc = 0
alter VD5 dc = 3.3
alter VD6 dc = 0
alter VD7 dc = 3.3
op
echo DAC 163 $&v(out)
alter VD0 dc = 0
alter VD1 dc = 0
alter VD2 dc = 3.3
alter VD3 dc = 0
alter VD4 dc = 0
alter VD5 dc = 3.3
alter VD6 dc = 0
alter VD7 dc = 3.3
op
echo DAC 164 $&v(out)
alter VD0 dc = 3.3
alter VD1 dc = 0
alter VD2 dc = 3.3
alter VD3 dc = 0
alter VD4 dc = 0
alter VD5 dc = 3.3
alter VD6 dc = 0
alter VD7 dc = 3.3
op
echo DAC 165 $&v(out)
alter VD0 dc = 0
alter VD1 dc = 3.3
alter VD2 dc = 3.3
alter VD3 dc = 0
alter VD4 dc = 0
alter VD5 dc = 3.3
alter VD6 dc = 0
alter VD7 dc = 3.3
op
echo DAC 166 $&v(out)
alter VD0 dc = 3.3
alter VD1 dc = 3.3
alter VD2 dc = 3.3
alter VD3 dc = 0
alter VD4 dc = 0
alter VD5 dc = 3.3
alter VD6 dc = 0
alter VD7 dc = 3.3
op
echo DAC 167 $&v(out)
alter VD0 dc = 0
alter VD1 dc = 0
alter VD2 dc = 0
alter VD3 dc = 3.3
alter VD4 dc = 0
alter VD5 dc = 3.3
alter VD6 dc = 0
alter VD7 dc = 3.3
op
echo DAC 168 $&v(out)
alter VD0 dc = 3.3
alter VD1 dc = 0
alter VD2 dc = 0
alter VD3 dc = 3.3
alter VD4 dc = 0
alter VD5 dc = 3.3
alter VD6 dc = 0
alter VD7 dc = 3.3
op
echo DAC 169 $&v(out)
alter VD0 dc = 0
alter VD1 dc = 3.3
alter VD2 dc = 0
alter VD3 dc = 3.3
alter VD4 dc = 0
alter VD5 dc = 3.3
alter VD6 dc = 0
alter VD7 dc = 3.3
op
echo DAC 170 $&v(out)
alter VD0 dc = 3.3
alter VD1 dc = 3.3
alter VD2 dc = 0
alter VD3 dc = 3.3
alter VD4 dc = 0
alter VD5 dc = 3.3
alter VD6 dc = 0
alter VD7 dc = 3.3
op
echo DAC 171 $&v(out)
alter VD0 dc = 0
alter VD1 dc = 0
alter VD2 dc = 3.3
alter VD3 dc = 3.3
alter VD4 dc = 0
alter VD5 dc = 3.3
alter VD6 dc = 0
alter VD7 dc = 3.3
op
echo DAC 172 $&v(out)
alter VD0 dc = 3.3
alter VD1 dc = 0
alter VD2 dc = 3.3
alter VD3 dc = 3.3
alter VD4 dc = 0
alter VD5 dc = 3.3
alter VD6 dc = 0
alter VD7 dc = 3.3
op
echo DAC 173 $&v(out)
alter VD0 dc = 0
alter VD1 dc = 3.3
alter VD2 dc = 3.3
alter VD3 dc = 3.3
alter VD4 dc = 0
alter VD5 dc = 3.3
alter VD6 dc = 0
alter VD7 dc = 3.3
op
echo DAC 174 $&v(out)
alter VD0 dc = 3.3
alter VD1 dc = 3.3
alter VD2 dc = 3.3
alter VD3 dc = 3.3
alter VD4 dc = 0
alter VD5 dc = 3.3
alter VD6 dc = 0
alter VD7 dc = 3.3
op
echo DAC 175 $&v(out)
alter VD0 dc = 0
alter VD1 dc = 0
alter VD2 dc = 0
alter VD3 dc = 0
alter VD4 dc = 3.3
alter VD5 dc = 3.3
alter VD6 dc = 0
alter VD7 dc = 3.3
op
echo DAC 176 $&v(out)
alter VD0 dc = 3.3
alter VD1 dc = 0
alter VD2 dc = 0
alter VD3 dc = 0
alter VD4 dc = 3.3
alter VD5 dc = 3.3
alter VD6 dc = 0
alter VD7 dc = 3.3
op
echo DAC 177 $&v(out)
alter VD0 dc = 0
alter VD1 dc = 3.3
alter VD2 dc = 0
alter VD3 dc = 0
alter VD4 dc = 3.3
alter VD5 dc = 3.3
alter VD6 dc = 0
alter VD7 dc = 3.3
op
echo DAC 178 $&v(out)
alter VD0 dc = 3.3
alter VD1 dc = 3.3
alter VD2 dc = 0
alter VD3 dc = 0
alter VD4 dc = 3.3
alter VD5 dc = 3.3
alter VD6 dc = 0
alter VD7 dc = 3.3
op
echo DAC 179 $&v(out)
alter VD0 dc = 0
alter VD1 dc = 0
alter VD2 dc = 3.3
alter VD3 dc = 0
alter VD4 dc = 3.3
alter VD5 dc = 3.3
alter VD6 dc = 0
alter VD7 dc = 3.3
op
echo DAC 180 $&v(out)
alter VD0 dc = 3.3
alter VD1 dc = 0
alter VD2 dc = 3.3
alter VD3 dc = 0
alter VD4 dc = 3.3
alter VD5 dc = 3.3
alter VD6 dc = 0
alter VD7 dc = 3.3
op
echo DAC 181 $&v(out)
alter VD0 dc = 0
alter VD1 dc = 3.3
alter VD2 dc = 3.3
alter VD3 dc = 0
alter VD4 dc = 3.3
alter VD5 dc = 3.3
alter VD6 dc = 0
alter VD7 dc = 3.3
op
echo DAC 182 $&v(out)
alter VD0 dc = 3.3
alter VD1 dc = 3.3
alter VD2 dc = 3.3
alter VD3 dc = 0
alter VD4 dc = 3.3
alter VD5 dc = 3.3
alter VD6 dc = 0
alter VD7 dc = 3.3
op
echo DAC 183 $&v(out)
alter VD0 dc = 0
alter VD1 dc = 0
alter VD2 dc = 0
alter VD3 dc = 3.3
alter VD4 dc = 3.3
alter VD5 dc = 3.3
alter VD6 dc = 0
alter VD7 dc = 3.3
op
echo DAC 184 $&v(out)
alter VD0 dc = 3.3
alter VD1 dc = 0
alter VD2 dc = 0
alter VD3 dc = 3.3
alter VD4 dc = 3.3
alter VD5 dc = 3.3
alter VD6 dc = 0
alter VD7 dc = 3.3
op
echo DAC 185 $&v(out)
alter VD0 dc = 0
alter VD1 dc = 3.3
alter VD2 dc = 0
alter VD3 dc = 3.3
alter VD4 dc = 3.3
alter VD5 dc = 3.3
alter VD6 dc = 0
alter VD7 dc = 3.3
op
echo DAC 186 $&v(out)
alter VD0 dc = 3.3
alter VD1 dc = 3.3
alter VD2 dc = 0
alter VD3 dc = 3.3
alter VD4 dc = 3.3
alter VD5 dc = 3.3
alter VD6 dc = 0
alter VD7 dc = 3.3
op
echo DAC 187 $&v(out)
alter VD0 dc = 0
alter VD1 dc = 0
alter VD2 dc = 3.3
alter VD3 dc = 3.3
alter VD4 dc = 3.3
alter VD5 dc = 3.3
alter VD6 dc = 0
alter VD7 dc = 3.3
op
echo DAC 188 $&v(out)
alter VD0 dc = 3.3
alter VD1 dc = 0
alter VD2 dc = 3.3
alter VD3 dc = 3.3
alter VD4 dc = 3.3
alter VD5 dc = 3.3
alter VD6 dc = 0
alter VD7 dc = 3.3
op
echo DAC 189 $&v(out)
alter VD0 dc = 0
alter VD1 dc = 3.3
alter VD2 dc = 3.3
alter VD3 dc = 3.3
alter VD4 dc = 3.3
alter VD5 dc = 3.3
alter VD6 dc = 0
alter VD7 dc = 3.3
op
echo DAC 190 $&v(out)
alter VD0 dc = 3.3
alter VD1 dc = 3.3
alter VD2 dc = 3.3
alter VD3 dc = 3.3
alter VD4 dc = 3.3
alter VD5 dc = 3.3
alter VD6 dc = 0
alter VD7 dc = 3.3
op
echo DAC 191 $&v(out)
alter VD0 dc = 0
alter VD1 dc = 0
alter VD2 dc = 0
alter VD3 dc = 0
alter VD4 dc = 0
alter VD5 dc = 0
alter VD6 dc = 3.3
alter VD7 dc = 3.3
op
echo DAC 192 $&v(out)
alter VD0 dc = 3.3
alter VD1 dc = 0
alter VD2 dc = 0
alter VD3 dc = 0
alter VD4 dc = 0
alter VD5 dc = 0
alter VD6 dc = 3.3
alter VD7 dc = 3.3
op
echo DAC 193 $&v(out)
alter VD0 dc = 0
alter VD1 dc = 3.3
alter VD2 dc = 0
alter VD3 dc = 0
alter VD4 dc = 0
alter VD5 dc = 0
alter VD6 dc = 3.3
alter VD7 dc = 3.3
op
echo DAC 194 $&v(out)
alter VD0 dc = 3.3
alter VD1 dc = 3.3
alter VD2 dc = 0
alter VD3 dc = 0
alter VD4 dc = 0
alter VD5 dc = 0
alter VD6 dc = 3.3
alter VD7 dc = 3.3
op
echo DAC 195 $&v(out)
alter VD0 dc = 0
alter VD1 dc = 0
alter VD2 dc = 3.3
alter VD3 dc = 0
alter VD4 dc = 0
alter VD5 dc = 0
alter VD6 dc = 3.3
alter VD7 dc = 3.3
op
echo DAC 196 $&v(out)
alter VD0 dc = 3.3
alter VD1 dc = 0
alter VD2 dc = 3.3
alter VD3 dc = 0
alter VD4 dc = 0
alter VD5 dc = 0
alter VD6 dc = 3.3
alter VD7 dc = 3.3
op
echo DAC 197 $&v(out)
alter VD0 dc = 0
alter VD1 dc = 3.3
alter VD2 dc = 3.3
alter VD3 dc = 0
alter VD4 dc = 0
alter VD5 dc = 0
alter VD6 dc = 3.3
alter VD7 dc = 3.3
op
echo DAC 198 $&v(out)
alter VD0 dc = 3.3
alter VD1 dc = 3.3
alter VD2 dc = 3.3
alter VD3 dc = 0
alter VD4 dc = 0
alter VD5 dc = 0
alter VD6 dc = 3.3
alter VD7 dc = 3.3
op
echo DAC 199 $&v(out)
alter VD0 dc = 0
alter VD1 dc = 0
alter VD2 dc = 0
alter VD3 dc = 3.3
alter VD4 dc = 0
alter VD5 dc = 0
alter VD6 dc = 3.3
alter VD7 dc = 3.3
op
echo DAC 200 $&v(out)
alter VD0 dc = 3.3
alter VD1 dc = 0
alter VD2 dc = 0
alter VD3 dc = 3.3
alter VD4 dc = 0
alter VD5 dc = 0
alter VD6 dc = 3.3
alter VD7 dc = 3.3
op
echo DAC 201 $&v(out)
alter VD0 dc = 0
alter VD1 dc = 3.3
alter VD2 dc = 0
alter VD3 dc = 3.3
alter VD4 dc = 0
alter VD5 dc = 0
alter VD6 dc = 3.3
alter VD7 dc = 3.3
op
echo DAC 202 $&v(out)
alter VD0 dc = 3.3
alter VD1 dc = 3.3
alter VD2 dc = 0
alter VD3 dc = 3.3
alter VD4 dc = 0
alter VD5 dc = 0
alter VD6 dc = 3.3
alter VD7 dc = 3.3
op
echo DAC 203 $&v(out)
alter VD0 dc = 0
alter VD1 dc = 0
alter VD2 dc = 3.3
alter VD3 dc = 3.3
alter VD4 dc = 0
alter VD5 dc = 0
alter VD6 dc = 3.3
alter VD7 dc = 3.3
op
echo DAC 204 $&v(out)
alter VD0 dc = 3.3
alter VD1 dc = 0
alter VD2 dc = 3.3
alter VD3 dc = 3.3
alter VD4 dc = 0
alter VD5 dc = 0
alter VD6 dc = 3.3
alter VD7 dc = 3.3
op
echo DAC 205 $&v(out)
alter VD0 dc = 0
alter VD1 dc = 3.3
alter VD2 dc = 3.3
alter VD3 dc = 3.3
alter VD4 dc = 0
alter VD5 dc = 0
alter VD6 dc = 3.3
alter VD7 dc = 3.3
op
echo DAC 206 $&v(out)
alter VD0 dc = 3.3
alter VD1 dc = 3.3
alter VD2 dc = 3.3
alter VD3 dc = 3.3
alter VD4 dc = 0
alter VD5 dc = 0
alter VD6 dc = 3.3
alter VD7 dc = 3.3
op
echo DAC 207 $&v(out)
alter VD0 dc = 0
alter VD1 dc = 0
alter VD2 dc = 0
alter VD3 dc = 0
alter VD4 dc = 3.3
alter VD5 dc = 0
alter VD6 dc = 3.3
alter VD7 dc = 3.3
op
echo DAC 208 $&v(out)
alter VD0 dc = 3.3
alter VD1 dc = 0
alter VD2 dc = 0
alter VD3 dc = 0
alter VD4 dc = 3.3
alter VD5 dc = 0
alter VD6 dc = 3.3
alter VD7 dc = 3.3
op
echo DAC 209 $&v(out)
alter VD0 dc = 0
alter VD1 dc = 3.3
alter VD2 dc = 0
alter VD3 dc = 0
alter VD4 dc = 3.3
alter VD5 dc = 0
alter VD6 dc = 3.3
alter VD7 dc = 3.3
op
echo DAC 210 $&v(out)
alter VD0 dc = 3.3
alter VD1 dc = 3.3
alter VD2 dc = 0
alter VD3 dc = 0
alter VD4 dc = 3.3
alter VD5 dc = 0
alter VD6 dc = 3.3
alter VD7 dc = 3.3
op
echo DAC 211 $&v(out)
alter VD0 dc = 0
alter VD1 dc = 0
alter VD2 dc = 3.3
alter VD3 dc = 0
alter VD4 dc = 3.3
alter VD5 dc = 0
alter VD6 dc = 3.3
alter VD7 dc = 3.3
op
echo DAC 212 $&v(out)
alter VD0 dc = 3.3
alter VD1 dc = 0
alter VD2 dc = 3.3
alter VD3 dc = 0
alter VD4 dc = 3.3
alter VD5 dc = 0
alter VD6 dc = 3.3
alter VD7 dc = 3.3
op
echo DAC 213 $&v(out)
alter VD0 dc = 0
alter VD1 dc = 3.3
alter VD2 dc = 3.3
alter VD3 dc = 0
alter VD4 dc = 3.3
alter VD5 dc = 0
alter VD6 dc = 3.3
alter VD7 dc = 3.3
op
echo DAC 214 $&v(out)
alter VD0 dc = 3.3
alter VD1 dc = 3.3
alter VD2 dc = 3.3
alter VD3 dc = 0
alter VD4 dc = 3.3
alter VD5 dc = 0
alter VD6 dc = 3.3
alter VD7 dc = 3.3
op
echo DAC 215 $&v(out)
alter VD0 dc = 0
alter VD1 dc = 0
alter VD2 dc = 0
alter VD3 dc = 3.3
alter VD4 dc = 3.3
alter VD5 dc = 0
alter VD6 dc = 3.3
alter VD7 dc = 3.3
op
echo DAC 216 $&v(out)
alter VD0 dc = 3.3
alter VD1 dc = 0
alter VD2 dc = 0
alter VD3 dc = 3.3
alter VD4 dc = 3.3
alter VD5 dc = 0
alter VD6 dc = 3.3
alter VD7 dc = 3.3
op
echo DAC 217 $&v(out)
alter VD0 dc = 0
alter VD1 dc = 3.3
alter VD2 dc = 0
alter VD3 dc = 3.3
alter VD4 dc = 3.3
alter VD5 dc = 0
alter VD6 dc = 3.3
alter VD7 dc = 3.3
op
echo DAC 218 $&v(out)
alter VD0 dc = 3.3
alter VD1 dc = 3.3
alter VD2 dc = 0
alter VD3 dc = 3.3
alter VD4 dc = 3.3
alter VD5 dc = 0
alter VD6 dc = 3.3
alter VD7 dc = 3.3
op
echo DAC 219 $&v(out)
alter VD0 dc = 0
alter VD1 dc = 0
alter VD2 dc = 3.3
alter VD3 dc = 3.3
alter VD4 dc = 3.3
alter VD5 dc = 0
alter VD6 dc = 3.3
alter VD7 dc = 3.3
op
echo DAC 220 $&v(out)
alter VD0 dc = 3.3
alter VD1 dc = 0
alter VD2 dc = 3.3
alter VD3 dc = 3.3
alter VD4 dc = 3.3
alter VD5 dc = 0
alter VD6 dc = 3.3
alter VD7 dc = 3.3
op
echo DAC 221 $&v(out)
alter VD0 dc = 0
alter VD1 dc = 3.3
alter VD2 dc = 3.3
alter VD3 dc = 3.3
alter VD4 dc = 3.3
alter VD5 dc = 0
alter VD6 dc = 3.3
alter VD7 dc = 3.3
op
echo DAC 222 $&v(out)
alter VD0 dc = 3.3
alter VD1 dc = 3.3
alter VD2 dc = 3.3
alter VD3 dc = 3.3
alter VD4 dc = 3.3
alter VD5 dc = 0
alter VD6 dc = 3.3
alter VD7 dc = 3.3
op
echo DAC 223 $&v(out)
alter VD0 dc = 0
alter VD1 dc = 0
alter VD2 dc = 0
alter VD3 dc = 0
alter VD4 dc = 0
alter VD5 dc = 3.3
alter VD6 dc = 3.3
alter VD7 dc = 3.3
op
echo DAC 224 $&v(out)
alter VD0 dc = 3.3
alter VD1 dc = 0
alter VD2 dc = 0
alter VD3 dc = 0
alter VD4 dc = 0
alter VD5 dc = 3.3
alter VD6 dc = 3.3
alter VD7 dc = 3.3
op
echo DAC 225 $&v(out)
alter VD0 dc = 0
alter VD1 dc = 3.3
alter VD2 dc = 0
alter VD3 dc = 0
alter VD4 dc = 0
alter VD5 dc = 3.3
alter VD6 dc = 3.3
alter VD7 dc = 3.3
op
echo DAC 226 $&v(out)
alter VD0 dc = 3.3
alter VD1 dc = 3.3
alter VD2 dc = 0
alter VD3 dc = 0
alter VD4 dc = 0
alter VD5 dc = 3.3
alter VD6 dc = 3.3
alter VD7 dc = 3.3
op
echo DAC 227 $&v(out)
alter VD0 dc = 0
alter VD1 dc = 0
alter VD2 dc = 3.3
alter VD3 dc = 0
alter VD4 dc = 0
alter VD5 dc = 3.3
alter VD6 dc = 3.3
alter VD7 dc = 3.3
op
echo DAC 228 $&v(out)
alter VD0 dc = 3.3
alter VD1 dc = 0
alter VD2 dc = 3.3
alter VD3 dc = 0
alter VD4 dc = 0
alter VD5 dc = 3.3
alter VD6 dc = 3.3
alter VD7 dc = 3.3
op
echo DAC 229 $&v(out)
alter VD0 dc = 0
alter VD1 dc = 3.3
alter VD2 dc = 3.3
alter VD3 dc = 0
alter VD4 dc = 0
alter VD5 dc = 3.3
alter VD6 dc = 3.3
alter VD7 dc = 3.3
op
echo DAC 230 $&v(out)
alter VD0 dc = 3.3
alter VD1 dc = 3.3
alter VD2 dc = 3.3
alter VD3 dc = 0
alter VD4 dc = 0
alter VD5 dc = 3.3
alter VD6 dc = 3.3
alter VD7 dc = 3.3
op
echo DAC 231 $&v(out)
alter VD0 dc = 0
alter VD1 dc = 0
alter VD2 dc = 0
alter VD3 dc = 3.3
alter VD4 dc = 0
alter VD5 dc = 3.3
alter VD6 dc = 3.3
alter VD7 dc = 3.3
op
echo DAC 232 $&v(out)
alter VD0 dc = 3.3
alter VD1 dc = 0
alter VD2 dc = 0
alter VD3 dc = 3.3
alter VD4 dc = 0
alter VD5 dc = 3.3
alter VD6 dc = 3.3
alter VD7 dc = 3.3
op
echo DAC 233 $&v(out)
alter VD0 dc = 0
alter VD1 dc = 3.3
alter VD2 dc = 0
alter VD3 dc = 3.3
alter VD4 dc = 0
alter VD5 dc = 3.3
alter VD6 dc = 3.3
alter VD7 dc = 3.3
op
echo DAC 234 $&v(out)
alter VD0 dc = 3.3
alter VD1 dc = 3.3
alter VD2 dc = 0
alter VD3 dc = 3.3
alter VD4 dc = 0
alter VD5 dc = 3.3
alter VD6 dc = 3.3
alter VD7 dc = 3.3
op
echo DAC 235 $&v(out)
alter VD0 dc = 0
alter VD1 dc = 0
alter VD2 dc = 3.3
alter VD3 dc = 3.3
alter VD4 dc = 0
alter VD5 dc = 3.3
alter VD6 dc = 3.3
alter VD7 dc = 3.3
op
echo DAC 236 $&v(out)
alter VD0 dc = 3.3
alter VD1 dc = 0
alter VD2 dc = 3.3
alter VD3 dc = 3.3
alter VD4 dc = 0
alter VD5 dc = 3.3
alter VD6 dc = 3.3
alter VD7 dc = 3.3
op
echo DAC 237 $&v(out)
alter VD0 dc = 0
alter VD1 dc = 3.3
alter VD2 dc = 3.3
alter VD3 dc = 3.3
alter VD4 dc = 0
alter VD5 dc = 3.3
alter VD6 dc = 3.3
alter VD7 dc = 3.3
op
echo DAC 238 $&v(out)
alter VD0 dc = 3.3
alter VD1 dc = 3.3
alter VD2 dc = 3.3
alter VD3 dc = 3.3
alter VD4 dc = 0
alter VD5 dc = 3.3
alter VD6 dc = 3.3
alter VD7 dc = 3.3
op
echo DAC 239 $&v(out)
alter VD0 dc = 0
alter VD1 dc = 0
alter VD2 dc = 0
alter VD3 dc = 0
alter VD4 dc = 3.3
alter VD5 dc = 3.3
alter VD6 dc = 3.3
alter VD7 dc = 3.3
op
echo DAC 240 $&v(out)
alter VD0 dc = 3.3
alter VD1 dc = 0
alter VD2 dc = 0
alter VD3 dc = 0
alter VD4 dc = 3.3
alter VD5 dc = 3.3
alter VD6 dc = 3.3
alter VD7 dc = 3.3
op
echo DAC 241 $&v(out)
alter VD0 dc = 0
alter VD1 dc = 3.3
alter VD2 dc = 0
alter VD3 dc = 0
alter VD4 dc = 3.3
alter VD5 dc = 3.3
alter VD6 dc = 3.3
alter VD7 dc = 3.3
op
echo DAC 242 $&v(out)
alter VD0 dc = 3.3
alter VD1 dc = 3.3
alter VD2 dc = 0
alter VD3 dc = 0
alter VD4 dc = 3.3
alter VD5 dc = 3.3
alter VD6 dc = 3.3
alter VD7 dc = 3.3
op
echo DAC 243 $&v(out)
alter VD0 dc = 0
alter VD1 dc = 0
alter VD2 dc = 3.3
alter VD3 dc = 0
alter VD4 dc = 3.3
alter VD5 dc = 3.3
alter VD6 dc = 3.3
alter VD7 dc = 3.3
op
echo DAC 244 $&v(out)
alter VD0 dc = 3.3
alter VD1 dc = 0
alter VD2 dc = 3.3
alter VD3 dc = 0
alter VD4 dc = 3.3
alter VD5 dc = 3.3
alter VD6 dc = 3.3
alter VD7 dc = 3.3
op
echo DAC 245 $&v(out)
alter VD0 dc = 0
alter VD1 dc = 3.3
alter VD2 dc = 3.3
alter VD3 dc = 0
alter VD4 dc = 3.3
alter VD5 dc = 3.3
alter VD6 dc = 3.3
alter VD7 dc = 3.3
op
echo DAC 246 $&v(out)
alter VD0 dc = 3.3
alter VD1 dc = 3.3
alter VD2 dc = 3.3
alter VD3 dc = 0
alter VD4 dc = 3.3
alter VD5 dc = 3.3
alter VD6 dc = 3.3
alter VD7 dc = 3.3
op
echo DAC 247 $&v(out)
alter VD0 dc = 0
alter VD1 dc = 0
alter VD2 dc = 0
alter VD3 dc = 3.3
alter VD4 dc = 3.3
alter VD5 dc = 3.3
alter VD6 dc = 3.3
alter VD7 dc = 3.3
op
echo DAC 248 $&v(out)
alter VD0 dc = 3.3
alter VD1 dc = 0
alter VD2 dc = 0
alter VD3 dc = 3.3
alter VD4 dc = 3.3
alter VD5 dc = 3.3
alter VD6 dc = 3.3
alter VD7 dc = 3.3
op
echo DAC 249 $&v(out)
alter VD0 dc = 0
alter VD1 dc = 3.3
alter VD2 dc = 0
alter VD3 dc = 3.3
alter VD4 dc = 3.3
alter VD5 dc = 3.3
alter VD6 dc = 3.3
alter VD7 dc = 3.3
op
echo DAC 250 $&v(out)
alter VD0 dc = 3.3
alter VD1 dc = 3.3
alter VD2 dc = 0
alter VD3 dc = 3.3
alter VD4 dc = 3.3
alter VD5 dc = 3.3
alter VD6 dc = 3.3
alter VD7 dc = 3.3
op
echo DAC 251 $&v(out)
alter VD0 dc = 0
alter VD1 dc = 0
alter VD2 dc = 3.3
alter VD3 dc = 3.3
alter VD4 dc = 3.3
alter VD5 dc = 3.3
alter VD6 dc = 3.3
alter VD7 dc = 3.3
op
echo DAC 252 $&v(out)
alter VD0 dc = 3.3
alter VD1 dc = 0
alter VD2 dc = 3.3
alter VD3 dc = 3.3
alter VD4 dc = 3.3
alter VD5 dc = 3.3
alter VD6 dc = 3.3
alter VD7 dc = 3.3
op
echo DAC 253 $&v(out)
alter VD0 dc = 0
alter VD1 dc = 3.3
alter VD2 dc = 3.3
alter VD3 dc = 3.3
alter VD4 dc = 3.3
alter VD5 dc = 3.3
alter VD6 dc = 3.3
alter VD7 dc = 3.3
op
echo DAC 254 $&v(out)
alter VD0 dc = 3.3
alter VD1 dc = 3.3
alter VD2 dc = 3.3
alter VD3 dc = 3.3
alter VD4 dc = 3.3
alter VD5 dc = 3.3
alter VD6 dc = 3.3
alter VD7 dc = 3.3
op
echo DAC 255 $&v(out)
.endc

**** end user architecture code
**.ends

* expanding   symbol:  afc_dac.sym # of pins=11
** sym_path: /home/noritsuna/GPS/xschem/afc_dac.sym
** sch_path: /home/noritsuna/GPS/xschem/afc_dac.sch

* expanding   symbol:  inv_dig.sym # of pins=4
** sym_path: /home/noritsuna/GPS/xschem/inv_dig.sym
** sch_path: /home/noritsuna/GPS/xschem/inv_dig.sch
.subckt inv_dig A Y VDD VSS
*.ipin A
*.opin Y
*.iopin VDD
*.iopin VSS
XMN Y A VSS VSS nfet_03v3 L=0.28u W=1u nf=1 ad='int((nf+1)/2) * W/nf * 0.18u' as='int((nf+2)/2) * W/nf * 0.18u' pd='2*int((nf+1)/2) * (W/nf + 0.18u)'
+ ps='2*int((nf+2)/2) * (W/nf + 0.18u)' nrd='0.18u / W' nrs='0.18u / W' sa=0 sb=0 sd=0 m=1 par=1
XMP Y A VDD VDD pfet_03v3 L=0.28u W=2u nf=1 ad='int((nf+1)/2) * W/nf * 0.18u' as='int((nf+2)/2) * W/nf * 0.18u' pd='2*int((nf+1)/2) * (W/nf + 0.18u)'
+ ps='2*int((nf+2)/2) * (W/nf + 0.18u)' nrd='0.18u / W' nrs='0.18u / W' sa=0 sb=0 sd=0 m=1 par=1
.ends

* expanding   symbol:  inv_dac.sym # of pins=4
** sym_path: /home/noritsuna/GPS/xschem/inv_dac.sym
** sch_path: /home/noritsuna/GPS/xschem/inv_dac.sch
.subckt inv_dac A Y VDD VSS
*.ipin A
*.opin Y
*.iopin VDD
*.iopin VSS
XMN Y A VSS VSS nfet_03v3 L=0.28u W=8u nf=2 ad='int((nf+1)/2) * W/nf * 0.18u' as='int((nf+2)/2) * W/nf * 0.18u' pd='2*int((nf+1)/2) * (W/nf + 0.18u)'
+ ps='2*int((nf+2)/2) * (W/nf + 0.18u)' nrd='0.18u / W' nrs='0.18u / W' sa=0 sb=0 sd=0 m=1 par=1
XMP Y A VDD VDD pfet_03v3 L=0.28u W=24u nf=4 ad='int((nf+1)/2) * W/nf * 0.18u' as='int((nf+2)/2) * W/nf * 0.18u' pd='2*int((nf+1)/2) * (W/nf + 0.18u)'
+ ps='2*int((nf+2)/2) * (W/nf + 0.18u)' nrd='0.18u / W' nrs='0.18u / W' sa=0 sb=0 sd=0 m=1 par=1
.ends
* NGSPICE file created from afc_dac_flat.ext - technology: gf180mcuD

.subckt afc_dac_flat VSS VDD D0 D1 D2 D3 D4 D5 D6 D7 OUT
X0 a_1545_5582# D5 VSS VSS nfet_03v3 ad=0.445p pd=2.89u as=0.445p ps=2.89u w=1u l=0.28u
X1 VDD a_1469_11009# a_1545_9679# VDD pfet_03v3 ad=2.67p pd=12.89u as=1.59p ps=6.53u w=6u l=0.28u
X2 VDD a_6509_10589# a_6585_9679# VDD pfet_03v3 ad=2.67p pd=12.89u as=1.59p ps=6.53u w=6u l=0.28u
X3 a_5540_19984# a_1545_5582# VDD VDD pfet_03v3 ad=1.59p pd=6.53u as=1.59p ps=6.53u w=6u l=0.28u
X4 a_12540_28126# a_13940_26004# VSS ppolyf_u_1k r_width=2u r_length=10u
X5 VSS a_8265_5240# a_9289_14719# VSS nfet_03v3 ad=1.78p pd=8.89u as=1.06p ps=4.53u w=4u l=0.28u
X6 VSS a_6509_10589# a_6585_9679# VSS nfet_03v3 ad=1.06p pd=4.53u as=1.06p ps=4.53u w=4u l=0.28u
X7 a_6940_22106# a_7640_19984# VSS ppolyf_u_1k r_width=2u r_length=10u
X8 a_5540_19984# a_1545_5582# VDD VDD pfet_03v3 ad=1.59p pd=6.53u as=1.59p ps=6.53u w=6u l=0.28u
X9 a_1340_22106# a_2740_19984# VSS ppolyf_u_1k r_width=2u r_length=10u
X10 a_4669_9679# a_4593_9469# VSS VSS nfet_03v3 ad=1.06p pd=4.53u as=1.06p ps=4.53u w=4u l=0.28u
X11 VDD a_4593_9469# a_4669_9679# VDD pfet_03v3 ad=1.59p pd=6.53u as=1.59p ps=6.53u w=6u l=0.28u
X12 a_2040_16126# a_2040_14664# VSS ppolyf_u_1k r_width=2u r_length=6.7u
X13 a_9740_28126# a_8340_26004# VSS ppolyf_u_1k r_width=2u r_length=10u
X14 a_14640_21446# a_4140_16126# VSS ppolyf_u_1k r_width=2u r_length=6.7u
X15 a_4840_28126# a_3440_26004# VSS ppolyf_u_1k r_width=2u r_length=10u
X16 a_1469_11009# D6 VSS VSS nfet_03v3 ad=0.445p pd=2.89u as=0.445p ps=2.89u w=1u l=0.28u
X17 a_15340_28126# a_4669_9679# VSS ppolyf_u_1k r_width=2u r_length=10u
X18 a_10440_28126# a_4345_9679# VSS ppolyf_u_1k r_width=2u r_length=10u
X19 a_9289_14719# a_8265_5240# VSS VSS nfet_03v3 ad=1.06p pd=4.53u as=1.06p ps=4.53u w=4u l=0.28u
X20 a_4345_9679# a_4269_10589# VDD VDD pfet_03v3 ad=1.59p pd=6.53u as=2.67p ps=12.89u w=6u l=0.28u
X21 a_2040_14664# a_6240_14664# VSS ppolyf_u_1k r_width=2u r_length=6.7u
X22 VDD a_1545_5582# a_5540_19984# VDD pfet_03v3 ad=1.59p pd=6.53u as=1.59p ps=6.53u w=6u l=0.28u
X23 a_4140_22106# a_5540_19984# VSS ppolyf_u_1k r_width=2u r_length=10u
X24 a_12540_26004# a_16040_19984# VSS ppolyf_u_1k r_width=2u r_length=6.7u
X25 a_5540_19984# a_1545_5582# VSS VSS nfet_03v3 ad=1.06p pd=4.53u as=1.06p ps=4.53u w=4u l=0.28u
X26 a_7640_28126# a_7640_26004# VSS ppolyf_u_1k r_width=2u r_length=10u
X27 a_2040_26004# a_11140_19984# VSS ppolyf_u_1k r_width=2u r_length=6.7u
X28 a_1545_9679# a_1469_11009# VDD VDD pfet_03v3 ad=1.59p pd=6.53u as=2.67p ps=12.89u w=6u l=0.28u
X29 a_1340_28126# a_2740_26004# VSS ppolyf_u_1k r_width=2u r_length=10u
X30 a_13240_28126# a_14640_26004# VSS ppolyf_u_1k r_width=2u r_length=10u
X31 a_6585_9679# a_6509_10589# VDD VDD pfet_03v3 ad=1.59p pd=6.53u as=2.67p ps=12.89u w=6u l=0.28u
X32 a_8340_22106# a_7640_19984# VSS ppolyf_u_1k r_width=2u r_length=10u
X33 a_6585_9679# a_6509_10589# VSS VSS nfet_03v3 ad=1.06p pd=4.53u as=1.78p ps=8.89u w=4u l=0.28u
X34 a_1340_14664# a_3440_14664# VSS ppolyf_u_1k r_width=2u r_length=6.7u
X35 a_2040_22106# a_3440_19984# VSS ppolyf_u_1k r_width=2u r_length=10u
X36 VDD a_1545_1180# a_1869_9679# VDD pfet_03v3 ad=1.59p pd=6.53u as=1.59p ps=6.53u w=6u l=0.28u
X37 VDD a_6585_5240# a_6240_26004# VDD pfet_03v3 ad=1.59p pd=6.53u as=1.59p ps=6.53u w=6u l=0.28u
X38 a_13940_21446# a_15340_19984# VSS ppolyf_u_1k r_width=2u r_length=6.7u
X39 VDD a_1545_1180# a_1869_9679# VDD pfet_03v3 ad=1.59p pd=6.53u as=1.59p ps=6.53u w=6u l=0.28u
X40 a_4140_28126# a_2040_26004# VSS ppolyf_u_1k r_width=2u r_length=10u
X41 a_6240_26004# a_6585_5240# VSS VSS nfet_03v3 ad=1.06p pd=4.53u as=1.78p ps=8.89u w=4u l=0.28u
X42 a_10440_21446# a_7640_26004# VSS ppolyf_u_1k r_width=2u r_length=6.7u
X43 a_6240_26004# a_6585_5240# VDD VDD pfet_03v3 ad=1.59p pd=6.53u as=1.59p ps=6.53u w=6u l=0.28u
X44 a_16040_28126# a_6585_9679# VSS ppolyf_u_1k r_width=2u r_length=10u
X45 VDD a_8265_5240# a_9289_14719# VDD pfet_03v3 ad=1.59p pd=6.53u as=1.59p ps=6.53u w=6u l=0.28u
X46 a_12540_28126# a_12540_26004# VSS ppolyf_u_1k r_width=2u r_length=10u
X47 a_4345_9679# a_4269_10589# VSS VSS nfet_03v3 ad=1.06p pd=4.53u as=1.78p ps=8.89u w=4u l=0.28u
X48 a_1545_9679# a_1469_11009# VSS VSS nfet_03v3 ad=1.06p pd=4.53u as=1.78p ps=8.89u w=4u l=0.28u
X49 a_4840_22106# a_1545_9679# VSS ppolyf_u_1k r_width=2u r_length=10u
X50 a_1340_16126# a_2740_14664# VSS ppolyf_u_1k r_width=2u r_length=6.7u
X51 a_1340_22106# a_1340_14664# VSS ppolyf_u_1k r_width=2u r_length=10u
X52 a_6940_28126# a_8340_26004# VSS ppolyf_u_1k r_width=2u r_length=10u
X53 a_6940_26004# a_11840_19984# VSS ppolyf_u_1k r_width=2u r_length=6.7u
X54 a_6585_5240# D0 VSS VSS nfet_03v3 ad=0.445p pd=2.89u as=0.445p ps=2.89u w=1u l=0.28u
X55 a_2040_28126# a_3440_26004# VSS ppolyf_u_1k r_width=2u r_length=10u
X56 a_15340_28126# a_13940_26004# VSS ppolyf_u_1k r_width=2u r_length=10u
X57 VSS a_4593_9469# a_4669_9679# VSS nfet_03v3 ad=1.78p pd=8.89u as=1.06p ps=4.53u w=4u l=0.28u
X58 a_10440_28126# a_9040_26004# VSS ppolyf_u_1k r_width=2u r_length=10u
X59 a_9289_14719# a_8265_5240# VDD VDD pfet_03v3 ad=1.59p pd=6.53u as=1.59p ps=6.53u w=6u l=0.28u
X60 a_8265_5240# D1 VSS VSS nfet_03v3 ad=0.445p pd=2.89u as=0.445p ps=2.89u w=1u l=0.28u
X61 a_8340_22106# a_1869_9679# VSS ppolyf_u_1k r_width=2u r_length=10u
X62 a_5540_16126# OUT VSS ppolyf_u_1k r_width=2u r_length=6.7u
X63 a_6585_5240# D0 VDD VDD pfet_03v3 ad=0.89p pd=4.89u as=0.89p ps=4.89u w=2u l=0.28u
X64 a_9289_14719# a_8265_5240# VDD VDD pfet_03v3 ad=1.59p pd=6.53u as=1.59p ps=6.53u w=6u l=0.28u
X65 a_4140_22106# a_2740_19984# VSS ppolyf_u_1k r_width=2u r_length=10u
X66 a_14640_21446# a_16040_19984# VSS ppolyf_u_1k r_width=2u r_length=6.7u
X67 a_4840_28126# a_6240_26004# VSS ppolyf_u_1k r_width=2u r_length=10u
X68 a_9740_21446# a_11140_19984# VSS ppolyf_u_1k r_width=2u r_length=6.7u
X69 a_1340_28126# VSS VSS ppolyf_u_1k r_width=2u r_length=10u
X70 a_6509_10589# D4 VSS VSS nfet_03v3 ad=0.445p pd=2.89u as=0.445p ps=2.89u w=1u l=0.28u
X71 VDD a_6585_5240# a_6240_26004# VDD pfet_03v3 ad=2.67p pd=12.89u as=1.59p ps=6.53u w=6u l=0.28u
X72 a_13240_28126# a_4140_16126# VSS ppolyf_u_1k r_width=2u r_length=10u
X73 a_1545_5582# D5 VDD VDD pfet_03v3 ad=0.89p pd=4.89u as=0.89p ps=4.89u w=2u l=0.28u
X74 a_4269_10589# D2 VSS VSS nfet_03v3 ad=0.445p pd=2.89u as=0.445p ps=2.89u w=1u l=0.28u
X75 a_4345_9679# a_4269_10589# VDD VDD pfet_03v3 ad=1.59p pd=6.53u as=1.59p ps=6.53u w=6u l=0.28u
X76 a_1869_9679# a_1545_1180# VSS VSS nfet_03v3 ad=1.06p pd=4.53u as=1.06p ps=4.53u w=4u l=0.28u
X77 a_1545_1180# D7 VDD VDD pfet_03v3 ad=0.89p pd=4.89u as=0.89p ps=4.89u w=2u l=0.28u
X78 VDD a_1469_11009# a_1545_9679# VDD pfet_03v3 ad=1.59p pd=6.53u as=1.59p ps=6.53u w=6u l=0.28u
X79 VDD a_4593_9469# a_4669_9679# VDD pfet_03v3 ad=1.59p pd=6.53u as=1.59p ps=6.53u w=6u l=0.28u
X80 a_2040_16126# a_3440_14664# VSS ppolyf_u_1k r_width=2u r_length=6.7u
X81 a_2040_22106# a_2040_14664# VSS ppolyf_u_1k r_width=2u r_length=10u
X82 a_7640_28126# a_9040_26004# VSS ppolyf_u_1k r_width=2u r_length=10u
X83 a_8265_5240# D1 VDD VDD pfet_03v3 ad=0.89p pd=4.89u as=0.89p ps=4.89u w=2u l=0.28u
X84 a_4593_9469# D3 VDD VDD pfet_03v3 ad=0.89p pd=4.89u as=0.89p ps=4.89u w=2u l=0.28u
X85 a_4140_28126# a_2740_26004# VSS ppolyf_u_1k r_width=2u r_length=10u
X86 VSS a_1545_5582# a_5540_19984# VSS nfet_03v3 ad=1.78p pd=8.89u as=1.06p ps=4.53u w=4u l=0.28u
X87 a_16040_28126# a_14640_26004# VSS ppolyf_u_1k r_width=2u r_length=10u
X88 VDD a_4269_10589# a_4345_9679# VDD pfet_03v3 ad=1.59p pd=6.53u as=1.59p ps=6.53u w=6u l=0.28u
X89 VDD a_8265_5240# a_9289_14719# VDD pfet_03v3 ad=1.59p pd=6.53u as=1.59p ps=6.53u w=6u l=0.28u
X90 a_4269_10589# D2 VDD VDD pfet_03v3 ad=0.89p pd=4.89u as=0.89p ps=4.89u w=2u l=0.28u
X91 a_9740_28126# a_9289_14719# VSS ppolyf_u_1k r_width=2u r_length=10u
X92 a_1545_9679# a_1469_11009# VDD VDD pfet_03v3 ad=1.59p pd=6.53u as=1.59p ps=6.53u w=6u l=0.28u
X93 a_6585_9679# a_6509_10589# VDD VDD pfet_03v3 ad=1.59p pd=6.53u as=1.59p ps=6.53u w=6u l=0.28u
X94 a_6940_22106# OUT VSS ppolyf_u_1k r_width=2u r_length=10u
X95 a_5540_16126# a_6240_14664# VSS ppolyf_u_1k r_width=2u r_length=6.7u
X96 a_1469_11009# D6 VDD VDD pfet_03v3 ad=0.89p pd=4.89u as=0.89p ps=4.89u w=2u l=0.28u
X97 a_4593_9469# D3 VSS VSS nfet_03v3 ad=0.445p pd=2.89u as=0.445p ps=2.89u w=1u l=0.28u
X98 a_1340_16126# a_1340_14664# VSS ppolyf_u_1k r_width=2u r_length=6.7u
X99 a_13940_21446# a_12540_26004# VSS ppolyf_u_1k r_width=2u r_length=6.7u
X100 a_4669_9679# a_4593_9469# VDD VDD pfet_03v3 ad=1.59p pd=6.53u as=1.59p ps=6.53u w=6u l=0.28u
X101 a_6240_26004# a_6585_5240# VDD VDD pfet_03v3 ad=1.59p pd=6.53u as=2.67p ps=12.89u w=6u l=0.28u
X102 VDD a_4269_10589# a_4345_9679# VDD pfet_03v3 ad=2.67p pd=12.89u as=1.59p ps=6.53u w=6u l=0.28u
X103 a_2040_28126# a_2040_26004# VSS ppolyf_u_1k r_width=2u r_length=10u
X104 a_6509_10589# D4 VDD VDD pfet_03v3 ad=0.89p pd=4.89u as=0.89p ps=4.89u w=2u l=0.28u
X105 VSS a_4269_10589# a_4345_9679# VSS nfet_03v3 ad=1.06p pd=4.53u as=1.06p ps=4.53u w=4u l=0.28u
X106 VDD a_6509_10589# a_6585_9679# VDD pfet_03v3 ad=1.59p pd=6.53u as=1.59p ps=6.53u w=6u l=0.28u
X107 VSS a_1545_1180# a_1869_9679# VSS nfet_03v3 ad=1.78p pd=8.89u as=1.06p ps=4.53u w=4u l=0.28u
X108 a_1869_9679# a_1545_1180# VDD VDD pfet_03v3 ad=1.59p pd=6.53u as=1.59p ps=6.53u w=6u l=0.28u
X109 a_4669_9679# a_4593_9469# VDD VDD pfet_03v3 ad=1.59p pd=6.53u as=1.59p ps=6.53u w=6u l=0.28u
X110 a_1869_9679# a_1545_1180# VDD VDD pfet_03v3 ad=1.59p pd=6.53u as=1.59p ps=6.53u w=6u l=0.28u
X111 VSS a_1469_11009# a_1545_9679# VSS nfet_03v3 ad=1.06p pd=4.53u as=1.06p ps=4.53u w=4u l=0.28u
X112 a_9740_21446# a_6940_26004# VSS ppolyf_u_1k r_width=2u r_length=6.7u
X113 a_1545_1180# D7 VSS VSS nfet_03v3 ad=0.445p pd=2.89u as=0.445p ps=2.89u w=1u l=0.28u
X114 VDD a_1545_5582# a_5540_19984# VDD pfet_03v3 ad=1.59p pd=6.53u as=1.59p ps=6.53u w=6u l=0.28u
X115 a_4840_22106# a_3440_19984# VSS ppolyf_u_1k r_width=2u r_length=10u
X116 a_4140_16126# a_2740_14664# VSS ppolyf_u_1k r_width=2u r_length=6.7u
X117 a_7640_26004# a_15340_19984# VSS ppolyf_u_1k r_width=2u r_length=6.7u
X118 VSS a_6585_5240# a_6240_26004# VSS nfet_03v3 ad=1.06p pd=4.53u as=1.06p ps=4.53u w=4u l=0.28u
X119 a_6940_28126# a_6940_26004# VSS ppolyf_u_1k r_width=2u r_length=10u
X120 a_10440_21446# a_11840_19984# VSS ppolyf_u_1k r_width=2u r_length=6.7u
C0 D6 a_3440_19984# 0.02758f
C1 D1 a_4269_10589# 0.05517f
C2 a_1469_11009# VDD 3.79497f
C3 D5 a_4593_9469# 0.04782f
C4 D3 VDD 1.22009f
C5 a_4140_16126# OUT 0.0412f
C6 a_4669_9679# a_1545_9679# 0.04207f
C7 a_14640_21446# a_7640_26004# 0.01103f
C8 a_6240_26004# a_6509_10589# 0.04354f
C9 a_9289_14719# a_4269_10589# 0.13103f
C10 D0 a_4269_10589# 0.20037f
C11 OUT a_6240_14664# 0.03407f
C12 a_4840_22106# a_4140_22106# 0.23983f
C13 a_6585_5240# a_5540_19984# 0.04525f
C14 a_1545_1180# D1 0.11688f
C15 a_1869_9679# a_6509_10589# 0.0387f
C16 a_9740_21446# a_7640_26004# 0.02704f
C17 a_6240_26004# a_5540_16126# 0.01633f
C18 D7 a_1545_5582# 0.03596f
C19 D1 D4 0.03676f
C20 a_1469_11009# a_1869_9679# 0.26461f
C21 a_1869_9679# D3 0.03587f
C22 a_6940_26004# a_7640_26004# 0.32677f
C23 a_13240_28126# a_12540_28126# 0.23983f
C24 D6 a_6585_5240# 0.02918f
C25 a_1284_1120# VDD 0.36665f
C26 D5 a_4269_10589# 0.04782f
C27 a_1545_1180# D0 0.06696f
C28 D2 a_1545_5582# 0.13051f
C29 a_2040_26004# D7 0.04457f
C30 a_4269_10589# a_11504_14659# 0.01071f
C31 D0 D4 0.03676f
C32 OUT a_5540_19984# 0.65336f
C33 a_4140_16126# a_1340_14664# 0.03386f
C34 D6 a_4593_9469# 0.03474f
C35 a_6324_5180# VDD 0.36665f
C36 a_1545_1180# D5 0.08503f
C37 a_4593_9469# a_6585_5240# 0.66321f
C38 a_1469_11009# a_6509_10589# 0.12904f
C39 D3 a_6509_10589# 0.08582f
C40 D5 a_1340_14664# 1.1578f
C41 a_4669_9679# a_6585_9679# 0.03334f
C42 a_4140_16126# a_2040_14664# 0.0546f
C43 D5 D4 0.10997f
C44 OUT a_6585_5240# 0.04298f
C45 a_1469_11009# D3 0.39395f
C46 a_5540_19984# a_4269_10589# 0.06484f
C47 a_14640_21446# a_13940_21446# 0.23983f
C48 a_1545_5582# a_14724_5180# 0.01039f
C49 a_12540_26004# a_4140_16126# 0.17864f
C50 a_6585_9679# a_8265_5240# 0.01836f
C51 D5 a_2040_14664# 0.60737f
C52 a_7640_26004# VDD 0.25314f
C53 a_4669_9679# VDD 2.61319f
C54 D7 a_1545_9679# 0.04262f
C55 D6 a_4269_10589# 0.03474f
C56 a_1340_16126# a_2040_16126# 0.23983f
C57 OUT a_4593_9469# 0.01861f
C58 a_8265_5240# VDD 2.60124f
C59 a_6585_5240# a_4269_10589# 0.10709f
C60 a_6240_26004# a_4669_9679# 0.20934f
C61 a_8414_5180# a_8265_5240# 0.02481f
C62 a_4345_9679# a_9289_14719# 0.06724f
C63 a_1694_5522# a_1545_5582# 0.01511f
C64 a_1545_1180# a_1694_1120# 0.02481f
C65 D1 a_1545_5582# 0.08809f
C66 a_4345_9679# a_4140_16126# 0.04359f
C67 a_6240_26004# a_8265_5240# 0.03878f
C68 D6 a_1545_1180# 0.06804f
C69 a_1869_9679# a_4669_9679# 0.09612f
C70 a_4593_9469# a_4269_10589# 0.79755f
C71 a_1545_1180# a_6585_5240# 0.31505f
C72 a_5540_19984# a_2040_14664# 0.04232f
C73 D6 a_1340_14664# 0.03596f
C74 a_16040_19984# a_6585_9679# 0.02449f
C75 a_1869_9679# a_8265_5240# 0.51376f
C76 D6 D4 0.07987f
C77 a_4345_9679# a_6240_14664# 0.02411f
C78 a_15134_5180# a_1545_5582# 0.01988f
C79 D0 a_1545_5582# 0.0257f
C80 OUT a_4269_10589# 0.04125f
C81 a_6585_5240# D4 0.03676f
C82 a_3440_26004# a_2040_26004# 0.06879f
C83 a_10440_21446# a_4345_9679# 0.02577f
C84 a_6734_5180# VDD 0.34678f
C85 D6 a_2040_14664# 0.03596f
C86 a_4345_9679# a_11504_14659# 0.01212f
C87 a_1545_1180# a_4593_9469# 0.36587f
C88 a_6585_9679# a_15848_14659# 0.01124f
C89 a_9289_14719# a_2040_26004# 0.09494f
C90 a_4669_9679# a_6509_10589# 0.03551f
C91 D5 a_1545_5582# 0.15457f
C92 a_4593_9469# D4 0.04359f
C93 a_1469_11009# a_4669_9679# 0.04f
C94 a_15848_14659# VDD 0.89462f
C95 a_6509_10589# a_8265_5240# 0.07069f
C96 D3 a_4669_9679# 0.03782f
C97 a_4345_9679# a_5540_19984# 0.16159f
C98 a_1469_11009# a_3374_5522# 0.01149f
C99 a_1545_9679# D1 0.01068f
C100 D7 VDD 1.73321f
C101 a_8340_26004# a_2040_26004# 0.026f
C102 a_1469_11009# a_8265_5240# 0.0368f
C103 D3 a_8265_5240# 0.11359f
C104 OUT a_2040_14664# 0.04262f
C105 D2 VDD 1.34693f
C106 a_2740_26004# a_3440_26004# 0.23983f
C107 a_4345_9679# a_6585_5240# 0.06252f
C108 D0 a_1545_9679# 0.25877f
C109 a_9040_26004# a_2040_26004# 0.06387f
C110 a_4269_10589# D4 0.04359f
C111 a_5540_19984# a_1545_5582# 0.35486f
C112 a_4140_16126# a_1545_9679# 0.04083f
C113 a_14640_21446# a_4140_16126# 0.01597f
C114 a_1869_9679# D7 0.0412f
C115 a_9740_21446# a_9289_14719# 0.05272f
C116 D5 a_1545_9679# 0.09853f
C117 a_4345_9679# a_4593_9469# 0.06534f
C118 a_8704_14659# VDD 0.89462f
C119 D6 a_1545_5582# 0.06552f
C120 a_1545_9679# a_6240_14664# 0.01073f
C121 a_3440_19984# a_2740_19984# 0.23983f
C122 a_6585_5240# a_1545_5582# 0.05365f
C123 a_1545_1180# D4 0.04359f
C124 a_6940_26004# a_9289_14719# 0.04058f
C125 a_14724_5180# VDD 0.36281f
C126 a_17934_9722# a_6509_10589# 0.01149f
C127 a_10248_14659# VDD 0.89462f
C128 a_6509_10589# a_15848_14659# 0.01216f
C129 a_2740_14664# a_3440_14664# 0.23983f
C130 a_4345_9679# OUT 0.20071f
C131 a_14304_14659# a_6585_9679# 0.0125f
C132 a_6240_26004# a_8704_14659# 0.01173f
C133 a_2040_14664# a_1340_14664# 0.65896f
C134 a_4593_9469# a_1545_5582# 0.59182f
C135 a_1284_9619# VDD 0.89462f
C136 a_10440_21446# a_9740_21446# 0.23983f
C137 a_6240_26004# a_10248_14659# 0.01232f
C138 a_14304_14659# VDD 0.89462f
C139 a_1469_11009# D7 0.04262f
C140 a_7640_26004# a_4669_9679# 0.13596f
C141 D2 a_6509_10589# 0.09359f
C142 D7 D3 0.04144f
C143 a_4840_28126# a_4140_28126# 0.23983f
C144 a_4345_9679# a_4269_10589# 0.7152f
C145 a_5540_19984# a_1545_9679# 0.83896f
C146 D1 VDD 0.93047f
C147 OUT a_1545_5582# 0.01861f
C148 a_10440_21446# a_6940_26004# 0.0469f
C149 a_9289_14719# a_6585_9679# 0.16169f
C150 D6 a_2740_19984# 0.01054f
C151 D0 a_6585_9679# 0.07996f
C152 a_2828_9619# a_1545_9679# 0.01345f
C153 a_1469_11009# D2 0.03346f
C154 D2 D3 0.47258f
C155 a_11840_19984# a_4345_9679# 0.01554f
C156 D6 a_1545_9679# 0.04262f
C157 a_14640_26004# a_4140_16126# 0.03504f
C158 a_9289_14719# VDD 2.79497f
C159 a_6585_5240# a_1545_9679# 0.04799f
C160 D0 VDD 2.65492f
C161 a_15134_5180# VDD 0.35048f
C162 a_16040_28126# a_15340_28126# 0.23983f
C163 a_1545_5582# a_4269_10589# 0.04516f
C164 a_2040_16126# D7 0.02904f
C165 a_11140_19984# a_9289_14719# 0.0141f
C166 a_14574_9722# a_4269_10589# 0.01149f
C167 a_13454_5180# VDD 0.34678f
C168 a_11214_9722# a_6585_5240# 0.01149f
C169 a_4140_16126# VDD 0.50629f
C170 a_1869_9679# D1 0.0636f
C171 a_9289_14719# a_6240_26004# 0.35302f
C172 D5 VDD 2.07154f
C173 a_4593_9469# a_1545_9679# 0.42217f
C174 a_1545_1180# a_1545_5582# 1.38341f
C175 a_4140_16126# a_6240_26004# 0.0412f
C176 a_1869_9679# a_9289_14719# 0.01992f
C177 a_4345_9679# a_12540_26004# 0.0127f
C178 a_1869_9679# D0 0.3351f
C179 a_13940_26004# a_4140_16126# 0.03598f
C180 a_11504_14659# VDD 0.89462f
C181 OUT a_1545_9679# 0.10413f
C182 a_1545_5582# D4 0.50453f
C183 a_1869_9679# a_4140_16126# 0.04359f
C184 a_6509_10589# D1 0.03234f
C185 a_5540_19984# a_6585_9679# 0.38484f
C186 a_13940_21446# a_7640_26004# 0.01007f
C187 a_1469_11009# D1 0.05909f
C188 D5 a_1869_9679# 0.04295f
C189 D3 D1 0.12143f
C190 a_16404_5180# VDD 0.36295f
C191 a_1545_9679# a_4269_10589# 0.03308f
C192 a_5540_19984# VDD 2.35558f
C193 a_9289_14719# a_6509_10589# 0.06846f
C194 D0 a_6509_10589# 0.02758f
C195 a_6585_5240# a_6585_9679# 0.08754f
C196 a_2828_9619# VDD 0.89462f
C197 a_10094_5180# a_4269_10589# 0.02481f
C198 a_13454_5180# a_6509_10589# 0.02646f
C199 a_1694_1120# VDD 0.34678f
C200 a_12540_26004# a_2040_26004# 0.54797f
C201 a_6940_28126# a_7640_28126# 0.23983f
C202 a_15340_19984# a_4669_9679# 0.05939f
C203 a_6240_26004# a_5540_19984# 1.78762f
C204 D6 VDD 3.19508f
C205 D7 a_2040_22106# 0.02904f
C206 a_1545_1180# a_1545_9679# 0.04019f
C207 a_6585_5240# VDD 3.9051f
C208 D2 a_8265_5240# 0.06844f
C209 D5 a_6509_10589# 0.04231f
C210 a_4593_9469# a_6585_9679# 0.01474f
C211 D5 a_1340_16126# 0.01096f
C212 a_1869_9679# a_5540_19984# 0.08385f
C213 a_1469_11009# D5 0.11428f
C214 D5 D3 0.10123f
C215 a_2828_9619# a_1869_9679# 0.01176f
C216 a_6240_26004# a_6585_5240# 0.46812f
C217 a_9740_28126# a_10440_28126# 0.23983f
C218 OUT a_6585_9679# 1.09283f
C219 a_4593_9469# VDD 2.4387f
C220 a_1545_9679# a_2040_14664# 0.04232f
C221 a_8564_9619# a_1545_9679# 0.01607f
C222 D6 a_1869_9679# 0.0412f
C223 a_4345_9679# a_2040_26004# 0.05299f
C224 a_14640_21446# a_12540_26004# 0.01946f
C225 a_1869_9679# a_6585_5240# 1.30315f
C226 OUT VDD 0.86256f
C227 D6 a_2740_14664# 0.01054f
C228 a_5540_19984# a_6509_10589# 0.22472f
C229 a_6585_9679# a_4269_10589# 0.07605f
C230 a_17104_14659# a_6240_26004# 0.01814f
C231 a_16404_5180# a_1469_11009# 0.01039f
C232 a_16040_19984# a_15340_19984# 0.23983f
C233 a_1469_11009# a_5540_19984# 0.03693f
C234 OUT a_6240_26004# 0.05322f
C235 D3 a_5540_19984# 0.03752f
C236 a_13048_14659# VDD 0.89462f
C237 a_4269_10589# VDD 3.72836f
C238 D6 a_6509_10589# 0.03536f
C239 a_1469_11009# a_2828_9619# 0.01588f
C240 a_6940_26004# a_12540_26004# 0.07112f
C241 a_6585_5240# a_6509_10589# 0.07447f
C242 a_5540_19984# a_5540_16126# 0.02308f
C243 a_4345_9679# a_1545_9679# 1.13739f
C244 a_1869_9679# OUT 0.03667f
C245 a_8265_5240# D1 0.96236f
C246 D7 a_3440_14664# 0.05789f
C247 D6 a_1469_11009# 0.21813f
C248 D6 D3 0.08075f
C249 D2 D7 0.03612f
C250 a_1469_11009# a_6585_5240# 0.08842f
C251 a_9289_14719# a_7640_26004# 0.19325f
C252 a_9289_14719# a_4669_9679# 0.17547f
C253 D3 a_6585_5240# 0.03782f
C254 a_6240_26004# a_4269_10589# 0.02786f
C255 a_11774_5180# a_4593_9469# 0.02481f
C256 a_6940_26004# a_6940_22106# 0.02551f
C257 a_11840_19984# a_11140_19984# 0.23983f
C258 a_1545_1180# VDD 2.20252f
C259 a_4593_9469# a_6509_10589# 0.23794f
C260 a_4140_16126# a_7640_26004# 0.03761f
C261 a_9289_14719# a_8265_5240# 0.35276f
C262 a_1340_14664# VDD 0.1975f
C263 D0 a_8265_5240# 0.04162f
C264 a_1869_9679# a_4269_10589# 1.03187f
C265 D4 VDD 0.80731f
C266 a_1469_11009# a_4593_9469# 0.10718f
C267 D3 a_4593_9469# 0.48749f
C268 a_4345_9679# a_6940_26004# 0.04359f
C269 a_12540_26004# a_6585_9679# 0.11444f
C270 OUT a_6509_10589# 0.04143f
C271 D6 a_2040_16126# 0.05926f
C272 a_2040_14664# VDD 0.23364f
C273 a_10440_21446# a_7640_26004# 0.01818f
C274 D5 a_8265_5240# 0.03625f
C275 a_12540_26004# VDD 0.23364f
C276 a_1545_1180# a_1869_9679# 0.35815f
C277 a_2740_26004# a_2040_26004# 0.03398f
C278 OUT a_5540_16126# 0.01633f
C279 a_6509_10589# a_4269_10589# 0.07124f
C280 a_6240_26004# a_2040_14664# 0.05184f
C281 a_6240_26004# a_4840_22106# 0.03293f
C282 a_1469_11009# a_4269_10589# 1.49455f
C283 a_4345_9679# a_6585_9679# 0.74351f
C284 D3 a_4269_10589# 0.32458f
C285 a_5540_19984# a_4669_9679# 2.99955f
C286 D7 D1 0.04358f
C287 a_6940_26004# a_2040_26004# 0.1169f
C288 a_1545_1180# a_6509_10589# 0.03183f
C289 a_4345_9679# VDD 3.24938f
C290 a_3440_26004# D7 0.05939f
C291 D2 D1 0.15119f
C292 a_4345_9679# a_11140_19984# 0.042f
C293 a_1340_16126# a_1340_14664# 0.03078f
C294 a_1469_11009# a_1545_1180# 0.13958f
C295 a_6509_10589# D4 0.48179f
C296 a_6585_9679# a_1545_5582# 0.05507f
C297 a_6585_5240# a_4669_9679# 1.61657f
C298 D0 D7 0.058f
C299 a_13940_21446# a_4140_16126# 0.04456f
C300 a_4345_9679# a_6240_26004# 1.16132f
C301 D6 a_8265_5240# 0.03135f
C302 a_1469_11009# D4 0.08035f
C303 D3 D4 0.0921f
C304 a_1340_16126# a_2040_14664# 0.02177f
C305 a_6585_5240# a_8265_5240# 0.45505f
C306 D2 D0 0.1128f
C307 a_1545_5582# VDD 2.72294f
C308 D6 a_2040_22106# 0.05926f
C309 a_16814_5180# VDD 0.35048f
C310 a_4345_9679# a_1869_9679# 0.09232f
C311 a_4593_9469# a_4669_9679# 0.35321f
C312 D5 D7 0.0417f
C313 a_5540_16126# a_2040_14664# 0.0317f
C314 a_2040_16126# a_1340_14664# 0.01866f
C315 a_2040_26004# VDD 0.23364f
C316 a_4593_9469# a_8265_5240# 0.22982f
C317 a_16254_9722# a_4593_9469# 0.01149f
C318 OUT a_4669_9679# 0.26072f
C319 D5 D2 0.09695f
C320 a_6940_26004# a_9740_21446# 0.12999f
C321 a_8004_5180# VDD 0.36665f
C322 D7 a_3440_19984# 0.05789f
C323 a_2040_28126# a_1340_28126# 0.23983f
C324 a_2040_16126# a_2040_14664# 0.09106f
C325 OUT a_8265_5240# 1.62342f
C326 a_4980_9619# a_4669_9679# 0.01367f
C327 a_2040_26004# a_6240_26004# 0.06667f
C328 a_4345_9679# a_6509_10589# 0.06909f
C329 a_9289_14719# a_10248_14659# 0.01176f
C330 a_6734_5180# a_6585_5240# 0.02481f
C331 a_6585_9679# a_1545_9679# 0.1149f
C332 a_4669_9679# a_4269_10589# 0.11606f
C333 a_4345_9679# a_1469_11009# 0.0343f
C334 a_4345_9679# D3 0.03782f
C335 a_8265_5240# a_4269_10589# 0.40457f
C336 a_1545_9679# VDD 2.47876f
C337 a_6509_10589# a_1545_5582# 1.84121f
C338 a_1545_1180# a_5054_5522# 0.01149f
C339 D6 D7 2.05954f
C340 a_10094_5180# VDD 0.34678f
C341 D0 D1 0.18158f
C342 a_6240_26004# a_1545_9679# 0.57828f
C343 a_1469_11009# a_1545_5582# 0.87952f
C344 D6 a_3440_14664# 0.02758f
C345 a_13044_5180# VDD 0.36665f
C346 D3 a_1545_5582# 0.07545f
C347 D6 D2 0.08051f
C348 a_1469_11009# a_16814_5180# 0.01988f
C349 a_1545_1180# a_8265_5240# 0.05551f
C350 D2 a_6585_5240# 0.07774f
C351 a_9684_5180# VDD 0.36665f
C352 a_6940_26004# VDD 0.25314f
C353 a_1869_9679# a_1545_9679# 0.74164f
C354 D5 D1 1.21903f
C355 a_8265_5240# D4 0.03676f
C356 a_4140_16126# a_9289_14719# 0.04359f
C357 a_12540_26004# a_7640_26004# 0.89342f
C358 a_12540_26004# a_4669_9679# 0.03204f
C359 D2 a_4593_9469# 0.29906f
C360 a_6940_26004# a_6240_26004# 0.01368f
C361 a_12894_9722# a_8265_5240# 0.01149f
C362 a_6585_5240# a_8704_14659# 0.01341f
C363 D5 D0 0.08994f
C364 a_7640_26004# a_6940_22106# 0.01966f
C365 a_10440_21446# a_9289_14719# 0.01017f
C366 a_6940_26004# a_1869_9679# 0.0127f
C367 a_6509_10589# a_1545_9679# 0.04491f
C368 a_9289_14719# a_11504_14659# 0.01416f
C369 a_11364_5180# VDD 0.36665f
C370 a_6585_9679# VDD 3.51522f
C371 a_9040_26004# a_9289_14719# 0.01429f
C372 a_1469_11009# a_1545_9679# 0.55302f
C373 D3 a_1545_9679# 0.03752f
C374 a_4345_9679# a_7640_26004# 0.04457f
C375 a_4345_9679# a_4669_9679# 0.42397f
C376 D2 a_4269_10589# 0.35226f
C377 a_5540_16126# a_1545_9679# 0.02308f
C378 a_6240_26004# a_6585_9679# 0.76584f
C379 D6 D1 0.04579f
C380 a_8414_5180# VDD 0.34678f
C381 a_9289_14719# a_5540_19984# 0.04378f
C382 a_6585_5240# D1 0.22436f
C383 a_9040_26004# a_8340_26004# 0.23983f
C384 a_1545_1180# D7 1.12702f
C385 a_13940_26004# a_14640_26004# 0.23983f
C386 a_1869_9679# a_6585_9679# 0.08014f
C387 a_6240_26004# VDD 2.82917f
C388 a_4140_16126# a_5540_19984# 0.04083f
C389 D7 a_1340_14664# 0.03596f
C390 D7 D4 0.0412f
C391 a_1545_1180# D2 0.04922f
C392 a_1340_22106# a_2040_22106# 0.23983f
C393 D6 D0 0.04058f
C394 a_9289_14719# a_6585_5240# 1.32694f
C395 a_4593_9469# D1 0.14696f
C396 a_1869_9679# VDD 2.73835f
C397 D0 a_6585_5240# 0.95333f
C398 a_8265_5240# a_1545_5582# 0.70734f
C399 D7 a_2040_14664# 0.03596f
C400 a_13940_21446# a_12540_26004# 0.05041f
C401 D2 D4 0.15724f
C402 a_7640_26004# a_2040_26004# 0.06246f
C403 a_6509_10589# a_6585_9679# 0.54868f
C404 D6 D5 2.22386f
C405 a_1869_9679# a_6240_26004# 0.12341f
C406 D5 a_6585_5240# 0.02578f
C407 D0 a_4593_9469# 0.19461f
C408 a_11774_5180# VDD 0.34678f
C409 a_1469_11009# a_6585_9679# 0.05327f
C410 D3 a_6585_9679# 0.04339f
C411 a_6509_10589# VDD 3.77687f
C412 D7 VSS 9.83239f
C413 D6 VSS 8.12613f
C414 D5 VSS 6.81015f
C415 D4 VSS 12.4341f
C416 D3 VSS 6.60052f
C417 D2 VSS 7.51985f
C418 D1 VSS 5.41397f
C419 D0 VSS 5.13595f
C420 OUT VSS 4.65262f
C421 VDD VSS 0.16343p
C422 a_1694_1120# VSS 0.04368f
C423 a_1284_1120# VSS 0.04368f
C424 a_16814_5180# VSS 0.04368f
C425 a_16404_5180# VSS 0.04368f
C426 a_15134_5180# VSS 0.04368f
C427 a_14724_5180# VSS 0.04368f
C428 a_13454_5180# VSS 0.04368f
C429 a_13044_5180# VSS 0.04368f
C430 a_11774_5180# VSS 0.04368f
C431 a_11364_5180# VSS 0.04368f
C432 a_10094_5180# VSS 0.04368f
C433 a_9684_5180# VSS 0.04368f
C434 a_8414_5180# VSS 0.04368f
C435 a_8004_5180# VSS 0.04368f
C436 a_6734_5180# VSS 0.04368f
C437 a_6324_5180# VSS 0.04368f
C438 a_5054_5522# VSS 0.24358f
C439 a_4644_5522# VSS 0.25096f ; **FLOATING
C440 a_3374_5522# VSS 0.24275f
C441 a_2964_5522# VSS 0.25159f ; **FLOATING
C442 a_1694_5522# VSS 0.24044f
C443 a_1284_5522# VSS 0.2541f ; **FLOATING
C444 a_17934_9722# VSS 0.24358f
C445 a_17524_9722# VSS 0.25096f ; **FLOATING
C446 a_16254_9722# VSS 0.24358f
C447 a_15844_9722# VSS 0.25096f ; **FLOATING
C448 a_14574_9722# VSS 0.24358f
C449 a_14164_9722# VSS 0.25096f ; **FLOATING
C450 a_12894_9722# VSS 0.24358f
C451 a_12484_9722# VSS 0.25096f ; **FLOATING
C452 a_11214_9722# VSS 0.24275f
C453 a_10804_9722# VSS 0.25096f ; **FLOATING
C454 a_9460_9619# VSS 0.73005f ; **FLOATING
C455 a_8564_9619# VSS 0.72843f
C456 a_7220_9619# VSS 0.73005f ; **FLOATING
C457 a_6324_9619# VSS 0.72984f ; **FLOATING
C458 a_4980_9619# VSS 0.72901f
C459 a_4084_9619# VSS 0.73111f ; **FLOATING
C460 a_2828_9619# VSS 0.14277f
C461 a_1545_1180# VSS 5.17202f ; **FLOATING
C462 a_1284_9619# VSS 0.14277f
C463 a_1469_11009# VSS 7.30876f ; **FLOATING
C464 a_18000_14659# VSS 0.73261f ; **FLOATING
C465 a_17104_14659# VSS 0.72843f
C466 a_15848_14659# VSS 0.14277f
C467 a_1545_5582# VSS 6.69601f ; **FLOATING
C468 a_14304_14659# VSS 0.14277f
C469 a_6509_10589# VSS 8.14681f ; **FLOATING
C470 a_13048_14659# VSS 0.14277f
C471 a_4593_9469# VSS 5.49955f ; **FLOATING
C472 a_11504_14659# VSS 0.14277f
C473 a_4269_10589# VSS 5.36749f ; **FLOATING
C474 a_10248_14659# VSS 0.14277f
C475 a_8265_5240# VSS 5.01181f ; **FLOATING
C476 a_8704_14659# VSS 0.14277f
C477 a_6585_5240# VSS 4.46568f ; **FLOATING
C478 a_6240_14664# VSS 1.18035f ; **FLOATING
C479 a_5540_16126# VSS 1.16914f ; **FLOATING
C480 a_3440_14664# VSS 1.38984f ; **FLOATING
C481 a_2740_14664# VSS 1.39549f ; **FLOATING
C482 a_2040_16126# VSS 1.38984f ; **FLOATING
C483 a_1340_16126# VSS 1.40264f ; **FLOATING
C484 a_16040_19984# VSS 1.40264f ; **FLOATING
C485 a_15340_19984# VSS 1.39814f ; **FLOATING
C486 a_14640_21446# VSS 1.39617f ; **FLOATING
C487 a_13940_21446# VSS 1.435f ; **FLOATING
C488 a_11840_19984# VSS 1.39143f ; **FLOATING
C489 a_11140_19984# VSS 1.39566f ; **FLOATING
C490 a_10440_21446# VSS 1.39617f ; **FLOATING
C491 a_9740_21446# VSS 1.27008f ; **FLOATING
C492 a_1869_9679# VSS 3.66588f ; **FLOATING
C493 a_8340_22106# VSS 1.17979f ; **FLOATING
C494 a_7640_19984# VSS 1.17252f ; **FLOATING
C495 a_6940_22106# VSS 1.16914f ; **FLOATING
C496 a_1545_9679# VSS 3.36628f ; **FLOATING
C497 a_5540_19984# VSS 2.76164f ; **FLOATING
C498 a_4840_22106# VSS 1.38984f ; **FLOATING
C499 a_4140_22106# VSS 1.39143f ; **FLOATING
C500 a_3440_19984# VSS 1.39441f ; **FLOATING
C501 a_2740_19984# VSS 1.39872f ; **FLOATING
C502 a_2040_14664# VSS 4.14601f ; **FLOATING
C503 a_2040_22106# VSS 1.38984f ; **FLOATING
C504 a_1340_14664# VSS 3.49296f ; **FLOATING
C505 a_1340_22106# VSS 1.40264f ; **FLOATING
C506 a_6585_9679# VSS 7.87845f ; **FLOATING
C507 a_4669_9679# VSS 6.96679f ; **FLOATING
C508 a_16040_28126# VSS 1.40711f ; **FLOATING
C509 a_15340_28126# VSS 1.39143f ; **FLOATING
C510 a_14640_26004# VSS 1.39441f ; **FLOATING
C511 a_13940_26004# VSS 1.39872f ; **FLOATING
C512 a_4140_16126# VSS 10.0223f ; **FLOATING
C513 a_13240_28126# VSS 1.38984f ; **FLOATING
C514 a_12540_26004# VSS 4.09663f ; **FLOATING
C515 a_12540_28126# VSS 1.39143f ; **FLOATING
C516 a_4345_9679# VSS 6.337f ; **FLOATING
C517 a_9289_14719# VSS 6.46321f ; **FLOATING
C518 a_10440_28126# VSS 1.38984f ; **FLOATING
C519 a_9740_28126# VSS 1.39143f ; **FLOATING
C520 a_9040_26004# VSS 1.39588f ; **FLOATING
C521 a_8340_26004# VSS 1.39265f ; **FLOATING
C522 a_7640_26004# VSS 5.85085f ; **FLOATING
C523 a_7640_28126# VSS 1.38984f ; **FLOATING
C524 a_6940_26004# VSS 5.89985f ; **FLOATING
C525 a_6940_28126# VSS 1.39143f ; **FLOATING
C526 a_6240_26004# VSS 4.92898f ; **FLOATING
C527 a_4840_28126# VSS 1.38984f ; **FLOATING
C528 a_4140_28126# VSS 1.39143f ; **FLOATING
C529 a_3440_26004# VSS 1.39441f ; **FLOATING
C530 a_2740_26004# VSS 1.39872f ; **FLOATING
C531 a_2040_26004# VSS 6.12472f ; **FLOATING
C532 a_2040_28126# VSS 1.38984f ; **FLOATING
C533 a_1340_28126# VSS 1.40264f ; **FLOATING
.ends

.subckt afc_dac D0 D1 D2 D3 D4 D5 D6 D7 OUT VDD VSS
XPEX VSS VDD D0 D1 D2 D3 D4 D5 D6 D7 OUT afc_dac_flat
.ends
.end
