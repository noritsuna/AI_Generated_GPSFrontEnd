** sch_path: /home/noritsuna/GPS/xschem/tb_lna.sch
**.subckt tb_lna
VDD vdd 0 3.3
XB nb pb vdd 0 bias_gen
VRF s0 0 dc 0 ac 1
RS50 s0 s1 50
LP s1 0 1
CP s1 0 1a
CIN s1 s2 10p
LS s2 pad 1p
CPV pad vdd 5.4e-13
CPS pad 0 7e-13
DN0 0 pad diode_nd2ps_06v0 area=150e-12 pj=106e-6
DP0 pad vdd diode_pd2nw_06v0 area=150e-12 pj=106e-6
DN1 0 pad diode_nd2ps_06v0 area=150e-12 pj=106e-6
DP1 pad vdd diode_pd2nw_06v0 area=150e-12 pj=106e-6
DN2 0 pad diode_nd2ps_06v0 area=150e-12 pj=106e-6
DP2 pad vdd diode_pd2nw_06v0 area=150e-12 pj=106e-6
DN3 0 pad diode_nd2ps_06v0 area=150e-12 pj=106e-6
DP3 pad vdd diode_pd2nw_06v0 area=150e-12 pj=106e-6
RW pad rfin 0.3
CW rfin 0 4.11102e-14
XLNA rfin pb rfp rfn vdd 0 lna_nc
VL1P l1p 0 2.0
VL1N l1n 0 0
VL2P l2p 0 2.0
VL2N l2n 0 0
VL3P l3p 0 2.0
VL3N l3n 0 0
VL4P l4p 0 2.0
VL4N l4n 0 0
XM rfp rfn l1p l1n l2p l2n l3p l3n l4p l4n nb ifip ifin ifqp ifqn vdd 0 mixer_iq
**** begin user architecture code
 .include /home/noritsuna/pdk/gf180mcuD/libs.tech/ngspice/design.ngspice
.lib /home/noritsuna/pdk/gf180mcuD/libs.tech/ngspice/sm141064.ngspice typical
.lib /home/noritsuna/pdk/gf180mcuD/libs.tech/ngspice/sm141064.ngspice res_typical
.lib /home/noritsuna/pdk/gf180mcuD/libs.tech/ngspice/sm141064.ngspice mimcap_typical
.lib /home/noritsuna/pdk/gf180mcuD/libs.tech/ngspice/sm141064.ngspice diode_typical

.temp 27
.control
set num_threads=1
alter LP = 1
alter CP = 2.7e-12
alter LS = 6e-09
op
echo RES op idd=$&i(VDD) vpad=$&v(pad)
ac lin 1 1.57542e+09 1.57542e+09
let zin = v(s1)/(-i(VRF))
let s11 = db((zin-50)/(zin+50))
let gd = db((v(rfp)-v(rfn))/v(s0)*2)
let gp = v(rfp)/v(s0)*2
let gn = v(rfn)/v(s0)*2
let bal = db(mag(gp)/mag(gn))
let ph = (cph(gp)-cph(gn))*180/pi
echo RES f0 s11=$&s11 gd=$&gd bal=$&bal ph=$&ph
alter LP = 1
alter CP = 1e-18
alter LS = 1e-12
ac dec 40 1e6 2e10
let rs = real(v(s1)/(-i(VRF)))
let gdb = db((v(rfp)-v(rfn))/v(s0)*2)
meas ac rsmin min rs
meas ac frsmin min_at rs
meas ac gmax max gdb
meas ac fgmax max_at gdb
echo RES stab rsmin=$&rsmin frsmin=$&frsmin gmax=$&gmax fgmax=$&fgmax
alter LP = 1
alter CP = 2.7e-12
alter LS = 6e-09
destroy all
noise v(rfp,rfn) VRF lin 2 1.57542e+09 1.57642e+09 1
setplot noise1
let nf = 10*log10(inoise_spectrum^2/(4*1.380649e-23*300*50))
let nf0 = nf[0]
echo RES nf=$&nf0
setplot noise2
print all
.endc

**** end user architecture code
**.ends

* expanding   symbol:  bias_gen.sym # of pins=4
** sym_path: /home/noritsuna/GPS/xschem/bias_gen.sym
** sch_path: /home/noritsuna/GPS/xschem/bias_gen.sch
.subckt bias_gen NB PB VDD VSS
*.opin NB
*.opin PB
*.iopin VDD
*.iopin VSS
XMN1 nbc nbc VSS VSS nfet_03v3 L=2u W=4u nf=1 ad='int((nf+1)/2) * W/nf * 0.18u' as='int((nf+2)/2) * W/nf * 0.18u' pd='2*int((nf+1)/2) * (W/nf + 0.18u)'
+ ps='2*int((nf+2)/2) * (W/nf + 0.18u)' nrd='0.18u / W' nrs='0.18u / W' sa=0 sb=0 sd=0 m=1 par=1
XMN2 pbc nbc nr VSS nfet_03v3 L=2u W=16u nf=2 ad='int((nf+1)/2) * W/nf * 0.18u' as='int((nf+2)/2) * W/nf * 0.18u' pd='2*int((nf+1)/2) * (W/nf + 0.18u)'
+ ps='2*int((nf+2)/2) * (W/nf + 0.18u)' nrd='0.18u / W' nrs='0.18u / W' sa=0 sb=0 sd=0 m=1 par=1
XRB VSS nr VSS ppolyf_u_1k r_width=1u r_length=4.6u
XMP1 nbc pbc VDD VDD pfet_03v3 L=2u W=8u nf=1 ad='int((nf+1)/2) * W/nf * 0.18u' as='int((nf+2)/2) * W/nf * 0.18u' pd='2*int((nf+1)/2) * (W/nf + 0.18u)'
+ ps='2*int((nf+2)/2) * (W/nf + 0.18u)' nrd='0.18u / W' nrs='0.18u / W' sa=0 sb=0 sd=0 m=1 par=1
XMP2 pbc pbc VDD VDD pfet_03v3 L=2u W=8u nf=1 ad='int((nf+1)/2) * W/nf * 0.18u' as='int((nf+2)/2) * W/nf * 0.18u' pd='2*int((nf+1)/2) * (W/nf + 0.18u)'
+ ps='2*int((nf+2)/2) * (W/nf + 0.18u)' nrd='0.18u / W' nrs='0.18u / W' sa=0 sb=0 sd=0 m=1 par=1
XMSP st VSS VDD VDD pfet_03v3 L=20u W=1u nf=1 ad='int((nf+1)/2) * W/nf * 0.18u' as='int((nf+2)/2) * W/nf * 0.18u' pd='2*int((nf+1)/2) * (W/nf + 0.18u)'
+ ps='2*int((nf+2)/2) * (W/nf + 0.18u)' nrd='0.18u / W' nrs='0.18u / W' sa=0 sb=0 sd=0 m=1 par=1
XMSN st nbc VSS VSS nfet_03v3 L=1u W=2u nf=1 ad='int((nf+1)/2) * W/nf * 0.18u' as='int((nf+2)/2) * W/nf * 0.18u' pd='2*int((nf+1)/2) * (W/nf + 0.18u)'
+ ps='2*int((nf+2)/2) * (W/nf + 0.18u)' nrd='0.18u / W' nrs='0.18u / W' sa=0 sb=0 sd=0 m=1 par=1
XMSU pbc st VSS VSS nfet_03v3 L=1u W=1u nf=1 ad='int((nf+1)/2) * W/nf * 0.18u' as='int((nf+2)/2) * W/nf * 0.18u' pd='2*int((nf+1)/2) * (W/nf + 0.18u)'
+ ps='2*int((nf+2)/2) * (W/nf + 0.18u)' nrd='0.18u / W' nrs='0.18u / W' sa=0 sb=0 sd=0 m=1 par=1
XMP3 NB pbc VDD VDD pfet_03v3 L=2u W=8u nf=1 ad='int((nf+1)/2) * W/nf * 0.18u' as='int((nf+2)/2) * W/nf * 0.18u' pd='2*int((nf+1)/2) * (W/nf + 0.18u)'
+ ps='2*int((nf+2)/2) * (W/nf + 0.18u)' nrd='0.18u / W' nrs='0.18u / W' sa=0 sb=0 sd=0 m=1 par=1
XMN3 NB NB VSS VSS nfet_03v3 L=2u W=16u nf=2 ad='int((nf+1)/2) * W/nf * 0.18u' as='int((nf+2)/2) * W/nf * 0.18u' pd='2*int((nf+1)/2) * (W/nf + 0.18u)'
+ ps='2*int((nf+2)/2) * (W/nf + 0.18u)' nrd='0.18u / W' nrs='0.18u / W' sa=0 sb=0 sd=0 m=1 par=1
XMN4 PB nbc VSS VSS nfet_03v3 L=2u W=4u nf=1 ad='int((nf+1)/2) * W/nf * 0.18u' as='int((nf+2)/2) * W/nf * 0.18u' pd='2*int((nf+1)/2) * (W/nf + 0.18u)'
+ ps='2*int((nf+2)/2) * (W/nf + 0.18u)' nrd='0.18u / W' nrs='0.18u / W' sa=0 sb=0 sd=0 m=1 par=1
XMP4 PB PB VDD VDD pfet_03v3 L=2u W=32u nf=4 ad='int((nf+1)/2) * W/nf * 0.18u' as='int((nf+2)/2) * W/nf * 0.18u' pd='2*int((nf+1)/2) * (W/nf + 0.18u)'
+ ps='2*int((nf+2)/2) * (W/nf + 0.18u)' nrd='0.18u / W' nrs='0.18u / W' sa=0 sb=0 sd=0 m=1 par=1
XCNB NB VSS cap_mim_2f0_m4m5_noshield c_width=20e-6 c_length=20e-6
XCPB VDD PB cap_mim_2f0_m4m5_noshield c_width=20e-6 c_length=20e-6
.ends

* expanding   symbol:  lna_nc.sym # of pins=6
** sym_path: /home/noritsuna/GPS/xschem/lna_nc.sym
** sch_path: /home/noritsuna/GPS/xschem/lna_nc.sch
.subckt lna_nc RFIN PB OUTP OUTN VDD VSS
*.ipin RFIN
*.ipin PB
*.opin OUTP
*.opin OUTN
*.iopin VDD
*.iopin VSS
XM1 op_i vb1 RFIN VSS nfet_03v3 L=0.28u W=40u nf=8 ad='int((nf+1)/2) * W/nf * 0.18u' as='int((nf+2)/2) * W/nf * 0.18u' pd='2*int((nf+1)/2) * (W/nf + 0.18u)'
+ ps='2*int((nf+2)/2) * (W/nf + 0.18u)' nrd='0.18u / W' nrs='0.18u / W' sa=0 sb=0 sd=0 m=3 par=3
XRS VSS RFIN VSS ppolyf_u_1k r_width=10u r_length=3u
XR1 op_i VDD VSS ppolyf_u_1k r_width=10u r_length=2u
XCC2 RFIN g2 cap_mim_2f0_m4m5_noshield c_width=45e-6 c_length=45e-6
XRB2 vb2 g2 VSS ppolyf_u_1k r_width=1u r_length=10u
XM2_0 on_i g2 VSS VSS nfet_03v3 L=0.28u W=5u ad=1.325p pd=5.53u as=1.325p ps=5.53u
XM2_1 on_i g2 VSS VSS nfet_03v3 L=0.28u W=5u ad=1.325p pd=5.53u as=1.325p ps=5.53u
XM2_2 on_i g2 VSS VSS nfet_03v3 L=0.28u W=5u ad=1.325p pd=5.53u as=1.325p ps=5.53u
XM2_3 on_i g2 VSS VSS nfet_03v3 L=0.28u W=5u ad=1.325p pd=5.53u as=1.325p ps=5.53u
XM2_4 on_i g2 VSS VSS nfet_03v3 L=0.28u W=5u ad=1.325p pd=5.53u as=1.325p ps=5.53u
XM2_5 on_i g2 VSS VSS nfet_03v3 L=0.28u W=5u ad=1.325p pd=5.53u as=1.325p ps=5.53u
XM2_6 on_i g2 VSS VSS nfet_03v3 L=0.28u W=5u ad=1.325p pd=5.53u as=1.325p ps=5.53u
XM2_7 on_i g2 VSS VSS nfet_03v3 L=0.28u W=5u ad=1.325p pd=5.53u as=1.325p ps=5.53u
XM2_8 on_i g2 VSS VSS nfet_03v3 L=0.28u W=5u ad=1.325p pd=5.53u as=1.325p ps=5.53u
XM2_9 on_i g2 VSS VSS nfet_03v3 L=0.28u W=5u ad=1.325p pd=5.53u as=1.325p ps=5.53u
XM2_10 on_i g2 VSS VSS nfet_03v3 L=0.28u W=5u ad=1.325p pd=5.53u as=1.325p ps=5.53u
XM2_11 on_i g2 VSS VSS nfet_03v3 L=0.28u W=5u ad=1.325p pd=5.53u as=1.325p ps=5.53u
XM2_12 on_i g2 VSS VSS nfet_03v3 L=0.28u W=5u ad=1.325p pd=5.53u as=1.325p ps=5.53u
XM2_13 on_i g2 VSS VSS nfet_03v3 L=0.28u W=5u ad=1.325p pd=5.53u as=1.325p ps=5.53u
XM2_14 on_i g2 VSS VSS nfet_03v3 L=0.28u W=5u ad=1.325p pd=5.53u as=1.325p ps=5.53u
XM2_15 on_i g2 VSS VSS nfet_03v3 L=0.28u W=5u ad=1.325p pd=5.53u as=1.325p ps=5.53u
XM2_16 on_i g2 VSS VSS nfet_03v3 L=0.28u W=5u ad=1.325p pd=5.53u as=1.325p ps=5.53u
XM2_17 on_i g2 VSS VSS nfet_03v3 L=0.28u W=5u ad=1.325p pd=5.53u as=1.325p ps=5.53u
XM2_18 on_i g2 VSS VSS nfet_03v3 L=0.28u W=5u ad=1.325p pd=5.53u as=1.325p ps=5.53u
XM2_19 on_i g2 VSS VSS nfet_03v3 L=0.28u W=5u ad=1.325p pd=5.53u as=1.325p ps=5.53u
XM2_20 on_i g2 VSS VSS nfet_03v3 L=0.28u W=5u ad=1.325p pd=5.53u as=1.325p ps=5.53u
XM2_21 on_i g2 VSS VSS nfet_03v3 L=0.28u W=5u ad=1.325p pd=5.53u as=1.325p ps=5.53u
XM2_22 on_i g2 VSS VSS nfet_03v3 L=0.28u W=5u ad=1.325p pd=5.53u as=1.325p ps=5.53u
XM2_23 on_i g2 VSS VSS nfet_03v3 L=0.28u W=5u ad=1.325p pd=5.53u as=1.325p ps=5.53u
XM2_24 on_i g2 VSS VSS nfet_03v3 L=0.28u W=5u ad=1.325p pd=5.53u as=1.325p ps=5.53u
XM2_25 on_i g2 VSS VSS nfet_03v3 L=0.28u W=5u ad=1.325p pd=5.53u as=1.325p ps=5.53u
XM2_26 on_i g2 VSS VSS nfet_03v3 L=0.28u W=5u ad=1.325p pd=5.53u as=1.325p ps=5.53u
XM2_27 on_i g2 VSS VSS nfet_03v3 L=0.28u W=5u ad=1.325p pd=5.53u as=1.325p ps=5.53u
XM2_28 on_i g2 VSS VSS nfet_03v3 L=0.28u W=5u ad=1.325p pd=5.53u as=1.325p ps=5.53u
XM2_29 on_i g2 VSS VSS nfet_03v3 L=0.28u W=5u ad=1.325p pd=5.53u as=1.325p ps=5.53u
XM2_30 on_i g2 VSS VSS nfet_03v3 L=0.28u W=5u ad=1.325p pd=5.53u as=1.325p ps=5.53u
XM2_31 on_i g2 VSS VSS nfet_03v3 L=0.28u W=5u ad=1.325p pd=5.53u as=1.325p ps=5.53u
XM2_32 on_i g2 VSS VSS nfet_03v3 L=0.28u W=5u ad=1.325p pd=5.53u as=1.325p ps=5.53u
XM2_33 on_i g2 VSS VSS nfet_03v3 L=0.28u W=5u ad=1.325p pd=5.53u as=1.325p ps=5.53u
XM2_34 on_i g2 VSS VSS nfet_03v3 L=0.28u W=5u ad=1.325p pd=5.53u as=1.325p ps=5.53u
XM2_35 on_i g2 VSS VSS nfet_03v3 L=0.28u W=5u ad=1.325p pd=5.53u as=1.325p ps=5.53u
XM2_36 on_i g2 VSS VSS nfet_03v3 L=0.28u W=5u ad=1.325p pd=5.53u as=1.325p ps=5.53u
XM2_37 on_i g2 VSS VSS nfet_03v3 L=0.28u W=5u ad=1.325p pd=5.53u as=1.325p ps=5.53u
XM2_38 on_i g2 VSS VSS nfet_03v3 L=0.28u W=5u ad=1.325p pd=5.53u as=1.325p ps=5.53u
XM2_39 on_i g2 VSS VSS nfet_03v3 L=0.28u W=5u ad=1.325p pd=5.53u as=1.325p ps=5.53u
XM2_40 on_i g2 VSS VSS nfet_03v3 L=0.28u W=5u ad=1.325p pd=5.53u as=1.325p ps=5.53u
XM2_41 on_i g2 VSS VSS nfet_03v3 L=0.28u W=5u ad=1.325p pd=5.53u as=1.325p ps=5.53u
XM2_42 on_i g2 VSS VSS nfet_03v3 L=0.28u W=5u ad=1.325p pd=5.53u as=1.325p ps=5.53u
XM2_43 on_i g2 VSS VSS nfet_03v3 L=0.28u W=5u ad=1.325p pd=5.53u as=1.325p ps=5.53u
XM2_44 on_i g2 VSS VSS nfet_03v3 L=0.28u W=5u ad=1.325p pd=5.53u as=1.325p ps=5.53u
XM2_45 on_i g2 VSS VSS nfet_03v3 L=0.28u W=5u ad=1.325p pd=5.53u as=1.325p ps=5.53u
XM2_46 on_i g2 VSS VSS nfet_03v3 L=0.28u W=5u ad=1.325p pd=5.53u as=1.325p ps=5.53u
XM2_47 on_i g2 VSS VSS nfet_03v3 L=0.28u W=5u ad=1.325p pd=5.53u as=1.325p ps=5.53u
XM2_48 on_i g2 VSS VSS nfet_03v3 L=0.28u W=5u ad=1.325p pd=5.53u as=1.325p ps=5.53u
XM2_49 on_i g2 VSS VSS nfet_03v3 L=0.28u W=5u ad=1.325p pd=5.53u as=1.325p ps=5.53u
XM2_50 on_i g2 VSS VSS nfet_03v3 L=0.28u W=5u ad=1.325p pd=5.53u as=1.325p ps=5.53u
XM2_51 on_i g2 VSS VSS nfet_03v3 L=0.28u W=5u ad=1.325p pd=5.53u as=1.325p ps=5.53u
XM2_52 on_i g2 VSS VSS nfet_03v3 L=0.28u W=5u ad=1.325p pd=5.53u as=1.325p ps=5.53u
XM2_53 on_i g2 VSS VSS nfet_03v3 L=0.28u W=5u ad=1.325p pd=5.53u as=1.325p ps=5.53u
XM2_54 on_i g2 VSS VSS nfet_03v3 L=0.28u W=5u ad=1.325p pd=5.53u as=1.325p ps=5.53u
XM2_55 on_i g2 VSS VSS nfet_03v3 L=0.28u W=5u ad=1.325p pd=5.53u as=1.325p ps=5.53u
XM2_56 on_i g2 VSS VSS nfet_03v3 L=0.28u W=5u ad=1.325p pd=5.53u as=1.325p ps=5.53u
XM2_57 on_i g2 VSS VSS nfet_03v3 L=0.28u W=5u ad=1.325p pd=5.53u as=1.325p ps=5.53u
XM2_58 on_i g2 VSS VSS nfet_03v3 L=0.28u W=5u ad=1.325p pd=5.53u as=1.325p ps=5.53u
XM2_59 on_i g2 VSS VSS nfet_03v3 L=0.28u W=5u ad=1.325p pd=5.53u as=1.325p ps=5.53u
XM2_60 on_i g2 VSS VSS nfet_03v3 L=0.28u W=5u ad=1.325p pd=5.53u as=1.325p ps=5.53u
XM2_61 on_i g2 VSS VSS nfet_03v3 L=0.28u W=5u ad=1.325p pd=5.53u as=1.325p ps=5.53u
XM2_62 on_i g2 VSS VSS nfet_03v3 L=0.28u W=5u ad=1.325p pd=5.53u as=1.325p ps=5.53u
XM2_63 on_i g2 VSS VSS nfet_03v3 L=0.28u W=5u ad=1.325p pd=5.53u as=1.325p ps=5.53u
XR2 on_i VDD VSS ppolyf_u_1k r_width=30u r_length=2.17u
XMP1 vb1 PB VDD VDD pfet_03v3 L=2u W=32u nf=4 ad='int((nf+1)/2) * W/nf * 0.18u' as='int((nf+2)/2) * W/nf * 0.18u' pd='2*int((nf+1)/2) * (W/nf + 0.18u)'
+ ps='2*int((nf+2)/2) * (W/nf + 0.18u)' nrd='0.18u / W' nrs='0.18u / W' sa=0 sb=0 sd=0 m=6 par=6
XM1R vb1 vb1 s1r VSS nfet_03v3 L=0.28u W=12u nf=2 ad='int((nf+1)/2) * W/nf * 0.18u' as='int((nf+2)/2) * W/nf * 0.18u' pd='2*int((nf+1)/2) * (W/nf + 0.18u)'
+ ps='2*int((nf+2)/2) * (W/nf + 0.18u)' nrd='0.18u / W' nrs='0.18u / W' sa=0 sb=0 sd=0 m=1 par=1
XRSR VSS s1r VSS ppolyf_u_1k r_width=1u r_length=3u
XMP2 vb2 PB VDD VDD pfet_03v3 L=2u W=32u nf=4 ad='int((nf+1)/2) * W/nf * 0.18u' as='int((nf+2)/2) * W/nf * 0.18u' pd='2*int((nf+1)/2) * (W/nf + 0.18u)'
+ ps='2*int((nf+2)/2) * (W/nf + 0.18u)' nrd='0.18u / W' nrs='0.18u / W' sa=0 sb=0 sd=0 m=5 par=5
XM2R vb2 vb2 VSS VSS nfet_03v3 L=0.28u W=8u nf=2 ad='int((nf+1)/2) * W/nf * 0.18u' as='int((nf+2)/2) * W/nf * 0.18u' pd='2*int((nf+1)/2) * (W/nf + 0.18u)'
+ ps='2*int((nf+2)/2) * (W/nf + 0.18u)' nrd='0.18u / W' nrs='0.18u / W' sa=0 sb=0 sd=0 m=1 par=1
XCB1 vb1 VSS cap_mim_2f0_m4m5_noshield c_width=50e-6 c_length=50e-6
XCB2 vb2 VSS cap_mim_2f0_m4m5_noshield c_width=50e-6 c_length=50e-6
XCOP op_i OUTP cap_mim_2f0_m4m5_noshield c_width=45e-6 c_length=45e-6
XCON on_i OUTN cap_mim_2f0_m4m5_noshield c_width=45e-6 c_length=45e-6
.ends

* expanding   symbol:  mixer_iq.sym # of pins=17
** sym_path: /home/noritsuna/GPS/xschem/mixer_iq.sym
** sch_path: /home/noritsuna/GPS/xschem/mixer_iq.sch
.subckt mixer_iq RFP RFN L1P L1N L2P L2N L3P L3N L4P L4N NB IFIP IFIN IFQP IFQN VDD VSS
*.ipin RFP
*.ipin RFN
*.ipin L1P
*.ipin L1N
*.ipin L2P
*.ipin L2N
*.ipin L3P
*.ipin L3N
*.ipin L4P
*.ipin L4N
*.ipin NB
*.opin IFIP
*.opin IFIN
*.opin IFQP
*.opin IFQN
*.iopin VDD
*.iopin VSS
XRT1 vbrf RFP VSS ppolyf_u_1k r_width=1u r_length=5u
XRT2 vbrf RFN VSS ppolyf_u_1k r_width=1u r_length=5u
XRBA vbrf VDD VSS ppolyf_u_1k r_width=1u r_length=20u
XRBB VSS vbrf VSS ppolyf_u_1k r_width=1u r_length=13u
XCBRF vbrf VSS cap_mim_2f0_m4m5_noshield c_width=70e-6 c_length=70e-6
XRLUA vlou VDD VSS ppolyf_u_1k r_width=1u r_length=47u
XRLUB VSS vlou VSS ppolyf_u_1k r_width=1u r_length=56u
XCLOU vlou VSS cap_mim_2f0_m4m5_noshield c_width=50e-6 c_length=50e-6
XRLLA vlol VDD VSS ppolyf_u_1k r_width=1u r_length=65u
XRLLB VSS vlol VSS ppolyf_u_1k r_width=1u r_length=37u
XCLOL vlol VSS cap_mim_2f0_m4m5_noshield c_width=50e-6 c_length=50e-6
XCACL1P L1P gl1p cap_mim_2f0_m4m5_noshield c_width=31.6e-6 c_length=31.6e-6
XRACL1P vlou gl1p VSS ppolyf_u_1k r_width=1u r_length=20u
XCACL1N L1N gl1n cap_mim_2f0_m4m5_noshield c_width=31.6e-6 c_length=31.6e-6
XRACL1N vlou gl1n VSS ppolyf_u_1k r_width=1u r_length=20u
XCACL2P L2P gl2p cap_mim_2f0_m4m5_noshield c_width=31.6e-6 c_length=31.6e-6
XRACL2P vlou gl2p VSS ppolyf_u_1k r_width=1u r_length=20u
XCACL2N L2N gl2n cap_mim_2f0_m4m5_noshield c_width=31.6e-6 c_length=31.6e-6
XRACL2N vlou gl2n VSS ppolyf_u_1k r_width=1u r_length=20u
XCACL3P L3P gl3p cap_mim_2f0_m4m5_noshield c_width=31.6e-6 c_length=31.6e-6
XRACL3P vlol gl3p VSS ppolyf_u_1k r_width=1u r_length=20u
XCACL3N L3N gl3n cap_mim_2f0_m4m5_noshield c_width=31.6e-6 c_length=31.6e-6
XRACL3N vlol gl3n VSS ppolyf_u_1k r_width=1u r_length=20u
XCACL4P L4P gl4p cap_mim_2f0_m4m5_noshield c_width=31.6e-6 c_length=31.6e-6
XRACL4P vlol gl4p VSS ppolyf_u_1k r_width=1u r_length=20u
XCACL4N L4N gl4n cap_mim_2f0_m4m5_noshield c_width=31.6e-6 c_length=31.6e-6
XRACL4N vlol gl4n VSS ppolyf_u_1k r_width=1u r_length=20u
XMCTL1P VSS gl1p VSS VSS nfet_03v3 L=2u W=4.96u nf=1 ad='int((nf+1)/2) * W/nf * 0.18u' as='int((nf+2)/2) * W/nf * 0.18u' pd='2*int((nf+1)/2) * (W/nf + 0.18u)'
+ ps='2*int((nf+2)/2) * (W/nf + 0.18u)' nrd='0.18u / W' nrs='0.18u / W' sa=0 sb=0 sd=0 m=1 par=1
XMCTL1N VSS gl1n VSS VSS nfet_03v3 L=2u W=6.08u nf=1 ad='int((nf+1)/2) * W/nf * 0.18u' as='int((nf+2)/2) * W/nf * 0.18u' pd='2*int((nf+1)/2) * (W/nf + 0.18u)'
+ ps='2*int((nf+2)/2) * (W/nf + 0.18u)' nrd='0.18u / W' nrs='0.18u / W' sa=0 sb=0 sd=0 m=1 par=1
XMCTL2P VSS gl2p VSS VSS nfet_03v3 L=2u W=3.97u nf=1 ad='int((nf+1)/2) * W/nf * 0.18u' as='int((nf+2)/2) * W/nf * 0.18u' pd='2*int((nf+1)/2) * (W/nf + 0.18u)'
+ ps='2*int((nf+2)/2) * (W/nf + 0.18u)' nrd='0.18u / W' nrs='0.18u / W' sa=0 sb=0 sd=0 m=1 par=1
XMCTL2N VSS gl2n VSS VSS nfet_03v3 L=2u W=4.25u nf=1 ad='int((nf+1)/2) * W/nf * 0.18u' as='int((nf+2)/2) * W/nf * 0.18u' pd='2*int((nf+1)/2) * (W/nf + 0.18u)'
+ ps='2*int((nf+2)/2) * (W/nf + 0.18u)' nrd='0.18u / W' nrs='0.18u / W' sa=0 sb=0 sd=0 m=1 par=1
XMCTL3P VSS gl3p VSS VSS nfet_03v3 L=2u W=0.83u nf=1 ad='int((nf+1)/2) * W/nf * 0.18u' as='int((nf+2)/2) * W/nf * 0.18u' pd='2*int((nf+1)/2) * (W/nf + 0.18u)'
+ ps='2*int((nf+2)/2) * (W/nf + 0.18u)' nrd='0.18u / W' nrs='0.18u / W' sa=0 sb=0 sd=0 m=1 par=1
XMCTL3N VSS gl3n VSS VSS nfet_03v3 L=2u W=0.8u nf=1 ad='int((nf+1)/2) * W/nf * 0.18u' as='int((nf+2)/2) * W/nf * 0.18u' pd='2*int((nf+1)/2) * (W/nf + 0.18u)'
+ ps='2*int((nf+2)/2) * (W/nf + 0.18u)' nrd='0.18u / W' nrs='0.18u / W' sa=0 sb=0 sd=0 m=1 par=1
XMCTL4P VSS gl4p VSS VSS nfet_03v3 L=2u W=1.3u nf=1 ad='int((nf+1)/2) * W/nf * 0.18u' as='int((nf+2)/2) * W/nf * 0.18u' pd='2*int((nf+1)/2) * (W/nf + 0.18u)'
+ ps='2*int((nf+2)/2) * (W/nf + 0.18u)' nrd='0.18u / W' nrs='0.18u / W' sa=0 sb=0 sd=0 m=1 par=1
XMCTL4N VSS gl4n VSS VSS nfet_03v3 L=2u W=1.65u nf=1 ad='int((nf+1)/2) * W/nf * 0.18u' as='int((nf+2)/2) * W/nf * 0.18u' pd='2*int((nf+1)/2) * (W/nf + 0.18u)'
+ ps='2*int((nf+2)/2) * (W/nf + 0.18u)' nrd='0.18u / W' nrs='0.18u / W' sa=0 sb=0 sd=0 m=1 par=1
XMTI tI NB VSS VSS nfet_03v3 L=2u W=40u nf=4 ad='int((nf+1)/2) * W/nf * 0.18u' as='int((nf+2)/2) * W/nf * 0.18u' pd='2*int((nf+1)/2) * (W/nf + 0.18u)'
+ ps='2*int((nf+2)/2) * (W/nf + 0.18u)' nrd='0.18u / W' nrs='0.18u / W' sa=0 sb=0 sd=0 m=16 par=16
XMG1I xpI RFP tI VSS nfet_03v3 L=0.28u W=80u nf=16 ad='int((nf+1)/2) * W/nf * 0.18u' as='int((nf+2)/2) * W/nf * 0.18u' pd='2*int((nf+1)/2) * (W/nf + 0.18u)'
+ ps='2*int((nf+2)/2) * (W/nf + 0.18u)' nrd='0.18u / W' nrs='0.18u / W' sa=0 sb=0 sd=0 m=1 par=1
XMG2I xnI RFN tI VSS nfet_03v3 L=0.28u W=80u nf=16 ad='int((nf+1)/2) * W/nf * 0.18u' as='int((nf+2)/2) * W/nf * 0.18u' pd='2*int((nf+1)/2) * (W/nf + 0.18u)'
+ ps='2*int((nf+2)/2) * (W/nf + 0.18u)' nrd='0.18u / W' nrs='0.18u / W' sa=0 sb=0 sd=0 m=1 par=1
XMLApI mpaI gl3n xpI VSS nfet_03v3 L=0.28u W=40u nf=8 ad='int((nf+1)/2) * W/nf * 0.18u' as='int((nf+2)/2) * W/nf * 0.18u' pd='2*int((nf+1)/2) * (W/nf + 0.18u)'
+ ps='2*int((nf+2)/2) * (W/nf + 0.18u)' nrd='0.18u / W' nrs='0.18u / W' sa=0 sb=0 sd=0 m=1 par=1
XMLBpI mpbI gl3p xpI VSS nfet_03v3 L=0.28u W=40u nf=8 ad='int((nf+1)/2) * W/nf * 0.18u' as='int((nf+2)/2) * W/nf * 0.18u' pd='2*int((nf+1)/2) * (W/nf + 0.18u)'
+ ps='2*int((nf+2)/2) * (W/nf + 0.18u)' nrd='0.18u / W' nrs='0.18u / W' sa=0 sb=0 sd=0 m=1 par=1
XMU1pI IFIP gl1p mpaI VSS nfet_03v3 L=0.28u W=20u nf=4 ad='int((nf+1)/2) * W/nf * 0.18u' as='int((nf+2)/2) * W/nf * 0.18u' pd='2*int((nf+1)/2) * (W/nf + 0.18u)'
+ ps='2*int((nf+2)/2) * (W/nf + 0.18u)' nrd='0.18u / W' nrs='0.18u / W' sa=0 sb=0 sd=0 m=1 par=1
XMU2pI IFIN gl1n mpaI VSS nfet_03v3 L=0.28u W=20u nf=4 ad='int((nf+1)/2) * W/nf * 0.18u' as='int((nf+2)/2) * W/nf * 0.18u' pd='2*int((nf+1)/2) * (W/nf + 0.18u)'
+ ps='2*int((nf+2)/2) * (W/nf + 0.18u)' nrd='0.18u / W' nrs='0.18u / W' sa=0 sb=0 sd=0 m=1 par=1
XMU3pI IFIN gl1p mpbI VSS nfet_03v3 L=0.28u W=20u nf=4 ad='int((nf+1)/2) * W/nf * 0.18u' as='int((nf+2)/2) * W/nf * 0.18u' pd='2*int((nf+1)/2) * (W/nf + 0.18u)'
+ ps='2*int((nf+2)/2) * (W/nf + 0.18u)' nrd='0.18u / W' nrs='0.18u / W' sa=0 sb=0 sd=0 m=1 par=1
XMU4pI IFIP gl1n mpbI VSS nfet_03v3 L=0.28u W=20u nf=4 ad='int((nf+1)/2) * W/nf * 0.18u' as='int((nf+2)/2) * W/nf * 0.18u' pd='2*int((nf+1)/2) * (W/nf + 0.18u)'
+ ps='2*int((nf+2)/2) * (W/nf + 0.18u)' nrd='0.18u / W' nrs='0.18u / W' sa=0 sb=0 sd=0 m=1 par=1
XMLAnI mnaI gl3n xnI VSS nfet_03v3 L=0.28u W=40u nf=8 ad='int((nf+1)/2) * W/nf * 0.18u' as='int((nf+2)/2) * W/nf * 0.18u' pd='2*int((nf+1)/2) * (W/nf + 0.18u)'
+ ps='2*int((nf+2)/2) * (W/nf + 0.18u)' nrd='0.18u / W' nrs='0.18u / W' sa=0 sb=0 sd=0 m=1 par=1
XMLBnI mnbI gl3p xnI VSS nfet_03v3 L=0.28u W=40u nf=8 ad='int((nf+1)/2) * W/nf * 0.18u' as='int((nf+2)/2) * W/nf * 0.18u' pd='2*int((nf+1)/2) * (W/nf + 0.18u)'
+ ps='2*int((nf+2)/2) * (W/nf + 0.18u)' nrd='0.18u / W' nrs='0.18u / W' sa=0 sb=0 sd=0 m=1 par=1
XMU1nI IFIN gl1p mnaI VSS nfet_03v3 L=0.28u W=20u nf=4 ad='int((nf+1)/2) * W/nf * 0.18u' as='int((nf+2)/2) * W/nf * 0.18u' pd='2*int((nf+1)/2) * (W/nf + 0.18u)'
+ ps='2*int((nf+2)/2) * (W/nf + 0.18u)' nrd='0.18u / W' nrs='0.18u / W' sa=0 sb=0 sd=0 m=1 par=1
XMU2nI IFIP gl1n mnaI VSS nfet_03v3 L=0.28u W=20u nf=4 ad='int((nf+1)/2) * W/nf * 0.18u' as='int((nf+2)/2) * W/nf * 0.18u' pd='2*int((nf+1)/2) * (W/nf + 0.18u)'
+ ps='2*int((nf+2)/2) * (W/nf + 0.18u)' nrd='0.18u / W' nrs='0.18u / W' sa=0 sb=0 sd=0 m=1 par=1
XMU3nI IFIP gl1p mnbI VSS nfet_03v3 L=0.28u W=20u nf=4 ad='int((nf+1)/2) * W/nf * 0.18u' as='int((nf+2)/2) * W/nf * 0.18u' pd='2*int((nf+1)/2) * (W/nf + 0.18u)'
+ ps='2*int((nf+2)/2) * (W/nf + 0.18u)' nrd='0.18u / W' nrs='0.18u / W' sa=0 sb=0 sd=0 m=1 par=1
XMU4nI IFIN gl1n mnbI VSS nfet_03v3 L=0.28u W=20u nf=4 ad='int((nf+1)/2) * W/nf * 0.18u' as='int((nf+2)/2) * W/nf * 0.18u' pd='2*int((nf+1)/2) * (W/nf + 0.18u)'
+ ps='2*int((nf+2)/2) * (W/nf + 0.18u)' nrd='0.18u / W' nrs='0.18u / W' sa=0 sb=0 sd=0 m=1 par=1
XRL1I IFIP VDD VSS ppolyf_u_1k r_width=4u r_length=5u
XRL2I IFIN VDD VSS ppolyf_u_1k r_width=4u r_length=5u
XCL1I IFIP VSS cap_mim_2f0_m4m5_noshield c_width=45e-6 c_length=45e-6
XCL2I IFIN VSS cap_mim_2f0_m4m5_noshield c_width=45e-6 c_length=45e-6
XMTQ tQ NB VSS VSS nfet_03v3 L=2u W=40u nf=4 ad='int((nf+1)/2) * W/nf * 0.18u' as='int((nf+2)/2) * W/nf * 0.18u' pd='2*int((nf+1)/2) * (W/nf + 0.18u)'
+ ps='2*int((nf+2)/2) * (W/nf + 0.18u)' nrd='0.18u / W' nrs='0.18u / W' sa=0 sb=0 sd=0 m=16 par=16
XMG1Q xpQ RFP tQ VSS nfet_03v3 L=0.28u W=80u nf=16 ad='int((nf+1)/2) * W/nf * 0.18u' as='int((nf+2)/2) * W/nf * 0.18u' pd='2*int((nf+1)/2) * (W/nf + 0.18u)'
+ ps='2*int((nf+2)/2) * (W/nf + 0.18u)' nrd='0.18u / W' nrs='0.18u / W' sa=0 sb=0 sd=0 m=1 par=1
XMG2Q xnQ RFN tQ VSS nfet_03v3 L=0.28u W=80u nf=16 ad='int((nf+1)/2) * W/nf * 0.18u' as='int((nf+2)/2) * W/nf * 0.18u' pd='2*int((nf+1)/2) * (W/nf + 0.18u)'
+ ps='2*int((nf+2)/2) * (W/nf + 0.18u)' nrd='0.18u / W' nrs='0.18u / W' sa=0 sb=0 sd=0 m=1 par=1
XMLApQ mpaQ gl4n xpQ VSS nfet_03v3 L=0.28u W=40u nf=8 ad='int((nf+1)/2) * W/nf * 0.18u' as='int((nf+2)/2) * W/nf * 0.18u' pd='2*int((nf+1)/2) * (W/nf + 0.18u)'
+ ps='2*int((nf+2)/2) * (W/nf + 0.18u)' nrd='0.18u / W' nrs='0.18u / W' sa=0 sb=0 sd=0 m=1 par=1
XMLBpQ mpbQ gl4p xpQ VSS nfet_03v3 L=0.28u W=40u nf=8 ad='int((nf+1)/2) * W/nf * 0.18u' as='int((nf+2)/2) * W/nf * 0.18u' pd='2*int((nf+1)/2) * (W/nf + 0.18u)'
+ ps='2*int((nf+2)/2) * (W/nf + 0.18u)' nrd='0.18u / W' nrs='0.18u / W' sa=0 sb=0 sd=0 m=1 par=1
XMU1pQ IFQP gl2p mpaQ VSS nfet_03v3 L=0.28u W=20u nf=4 ad='int((nf+1)/2) * W/nf * 0.18u' as='int((nf+2)/2) * W/nf * 0.18u' pd='2*int((nf+1)/2) * (W/nf + 0.18u)'
+ ps='2*int((nf+2)/2) * (W/nf + 0.18u)' nrd='0.18u / W' nrs='0.18u / W' sa=0 sb=0 sd=0 m=1 par=1
XMU2pQ IFQN gl2n mpaQ VSS nfet_03v3 L=0.28u W=20u nf=4 ad='int((nf+1)/2) * W/nf * 0.18u' as='int((nf+2)/2) * W/nf * 0.18u' pd='2*int((nf+1)/2) * (W/nf + 0.18u)'
+ ps='2*int((nf+2)/2) * (W/nf + 0.18u)' nrd='0.18u / W' nrs='0.18u / W' sa=0 sb=0 sd=0 m=1 par=1
XMU3pQ IFQN gl2p mpbQ VSS nfet_03v3 L=0.28u W=20u nf=4 ad='int((nf+1)/2) * W/nf * 0.18u' as='int((nf+2)/2) * W/nf * 0.18u' pd='2*int((nf+1)/2) * (W/nf + 0.18u)'
+ ps='2*int((nf+2)/2) * (W/nf + 0.18u)' nrd='0.18u / W' nrs='0.18u / W' sa=0 sb=0 sd=0 m=1 par=1
XMU4pQ IFQP gl2n mpbQ VSS nfet_03v3 L=0.28u W=20u nf=4 ad='int((nf+1)/2) * W/nf * 0.18u' as='int((nf+2)/2) * W/nf * 0.18u' pd='2*int((nf+1)/2) * (W/nf + 0.18u)'
+ ps='2*int((nf+2)/2) * (W/nf + 0.18u)' nrd='0.18u / W' nrs='0.18u / W' sa=0 sb=0 sd=0 m=1 par=1
XMLAnQ mnaQ gl4n xnQ VSS nfet_03v3 L=0.28u W=40u nf=8 ad='int((nf+1)/2) * W/nf * 0.18u' as='int((nf+2)/2) * W/nf * 0.18u' pd='2*int((nf+1)/2) * (W/nf + 0.18u)'
+ ps='2*int((nf+2)/2) * (W/nf + 0.18u)' nrd='0.18u / W' nrs='0.18u / W' sa=0 sb=0 sd=0 m=1 par=1
XMLBnQ mnbQ gl4p xnQ VSS nfet_03v3 L=0.28u W=40u nf=8 ad='int((nf+1)/2) * W/nf * 0.18u' as='int((nf+2)/2) * W/nf * 0.18u' pd='2*int((nf+1)/2) * (W/nf + 0.18u)'
+ ps='2*int((nf+2)/2) * (W/nf + 0.18u)' nrd='0.18u / W' nrs='0.18u / W' sa=0 sb=0 sd=0 m=1 par=1
XMU1nQ IFQN gl2p mnaQ VSS nfet_03v3 L=0.28u W=20u nf=4 ad='int((nf+1)/2) * W/nf * 0.18u' as='int((nf+2)/2) * W/nf * 0.18u' pd='2*int((nf+1)/2) * (W/nf + 0.18u)'
+ ps='2*int((nf+2)/2) * (W/nf + 0.18u)' nrd='0.18u / W' nrs='0.18u / W' sa=0 sb=0 sd=0 m=1 par=1
XMU2nQ IFQP gl2n mnaQ VSS nfet_03v3 L=0.28u W=20u nf=4 ad='int((nf+1)/2) * W/nf * 0.18u' as='int((nf+2)/2) * W/nf * 0.18u' pd='2*int((nf+1)/2) * (W/nf + 0.18u)'
+ ps='2*int((nf+2)/2) * (W/nf + 0.18u)' nrd='0.18u / W' nrs='0.18u / W' sa=0 sb=0 sd=0 m=1 par=1
XMU3nQ IFQP gl2p mnbQ VSS nfet_03v3 L=0.28u W=20u nf=4 ad='int((nf+1)/2) * W/nf * 0.18u' as='int((nf+2)/2) * W/nf * 0.18u' pd='2*int((nf+1)/2) * (W/nf + 0.18u)'
+ ps='2*int((nf+2)/2) * (W/nf + 0.18u)' nrd='0.18u / W' nrs='0.18u / W' sa=0 sb=0 sd=0 m=1 par=1
XMU4nQ IFQN gl2n mnbQ VSS nfet_03v3 L=0.28u W=20u nf=4 ad='int((nf+1)/2) * W/nf * 0.18u' as='int((nf+2)/2) * W/nf * 0.18u' pd='2*int((nf+1)/2) * (W/nf + 0.18u)'
+ ps='2*int((nf+2)/2) * (W/nf + 0.18u)' nrd='0.18u / W' nrs='0.18u / W' sa=0 sb=0 sd=0 m=1 par=1
XRL1Q IFQP VDD VSS ppolyf_u_1k r_width=4u r_length=5u
XRL2Q IFQN VDD VSS ppolyf_u_1k r_width=4u r_length=5u
XCL1Q IFQP VSS cap_mim_2f0_m4m5_noshield c_width=45e-6 c_length=45e-6
XCL2Q IFQN VSS cap_mim_2f0_m4m5_noshield c_width=45e-6 c_length=45e-6
.ends

.end
