** sch_path: /home/noritsuna/GPS/xschem/tb_vco.sch
**.subckt tb_vco
VDD vdd 0 3.3
VC vctrl 0 1.5
VB0 b0 0 3.3
VB1 b1 0 3.3
XVCO vctrl b0 b1 loip loin loqp loqn vr vdd 0 vco_ring4
CLloip loip 0 60f
CLloin loin 0 60f
CLloqp loqp 0 60f
CLloqn loqn 0 60f
**** begin user architecture code
 .include /home/noritsuna/pdk/gf180mcuD/libs.tech/ngspice/design.ngspice
.lib /home/noritsuna/pdk/gf180mcuD/libs.tech/ngspice/sm141064.ngspice typical
.lib /home/noritsuna/pdk/gf180mcuD/libs.tech/ngspice/sm141064.ngspice res_typical
.lib /home/noritsuna/pdk/gf180mcuD/libs.tech/ngspice/sm141064.ngspice mimcap_typical

.option method=gear reltol=1e-4
.ic v(xvco.xpex.a_9449_57629#)=0 v(xvco.xpex.a_9773_56649#)=2
.control
set num_threads=1
let vlist = vector(9)*0.25+0.8
let k = 0
while k < 9
 let vv = vlist[k]
 alter VC dc = vv
 tran 2p 25n uic
 meas tran ta when v(loip)=v(loin) rise=14
 meas tran tb when v(loip)=v(loin) rise=22
 meas tran tq when v(loqp)=v(loqn) rise=14
 meas tran ivdd avg i(VDD) from=12n to=25n
 meas tran vravg avg v(vr) from=12n to=25n
 let f = 8/(tb-ta)
 let qerr = ((tq-ta)*f - floor((tq-ta)*f))*360 - 90
 echo RES vc=$&vv f=$&f qerr=$&qerr ivdd=$&ivdd vr=$&vravg
 let k = k + 1
end
.endc

**** end user architecture code
**.ends

* expanding   symbol:  vco_ring4.sym # of pins=10
** sym_path: /home/noritsuna/GPS/xschem/vco_ring4.sym
** sch_path: /home/noritsuna/GPS/xschem/vco_ring4.sch

* expanding   symbol:  inv_dig.sym # of pins=4
** sym_path: /home/noritsuna/GPS/xschem/inv_dig.sym
** sch_path: /home/noritsuna/GPS/xschem/inv_dig.sch
.subckt inv_dig A Y VDD VSS
*.ipin A
*.opin Y
*.iopin VDD
*.iopin VSS
XMN Y A VSS VSS nfet_03v3 L=0.28u W=1u nf=1 ad='int((nf+1)/2) * W/nf * 0.18u' as='int((nf+2)/2) * W/nf * 0.18u' pd='2*int((nf+1)/2) * (W/nf + 0.18u)'
+ ps='2*int((nf+2)/2) * (W/nf + 0.18u)' nrd='0.18u / W' nrs='0.18u / W' sa=0 sb=0 sd=0 m=1 par=1
XMP Y A VDD VDD pfet_03v3 L=0.28u W=2u nf=1 ad='int((nf+1)/2) * W/nf * 0.18u' as='int((nf+2)/2) * W/nf * 0.18u' pd='2*int((nf+1)/2) * (W/nf + 0.18u)'
+ ps='2*int((nf+2)/2) * (W/nf + 0.18u)' nrd='0.18u / W' nrs='0.18u / W' sa=0 sb=0 sd=0 m=1 par=1
.ends

* expanding   symbol:  vco_core.sym # of pins=12
** sym_path: /home/noritsuna/GPS/xschem/vco_core.sym
** sch_path: /home/noritsuna/GPS/xschem/vco_core.sch
.subckt vco_core p1 n1 p2 n2 p3 n3 p4 n4 kh kl VR VSS
*.opin p1
*.opin n1
*.opin p2
*.opin n2
*.opin p3
*.opin n3
*.opin p4
*.opin n4
*.ipin kh
*.ipin kl
*.iopin VR
*.iopin VSS
XMNa1 n1 p4 VSS VSS nfet_03v3 L=0.28u W=8u nf=2 ad='int((nf+1)/2) * W/nf * 0.18u' as='int((nf+2)/2) * W/nf * 0.18u' pd='2*int((nf+1)/2) * (W/nf + 0.18u)'
+ ps='2*int((nf+2)/2) * (W/nf + 0.18u)' nrd='0.18u / W' nrs='0.18u / W' sa=0 sb=0 sd=0 m=1 par=1
XMNb1 p1 n4 VSS VSS nfet_03v3 L=0.28u W=8u nf=2 ad='int((nf+1)/2) * W/nf * 0.18u' as='int((nf+2)/2) * W/nf * 0.18u' pd='2*int((nf+1)/2) * (W/nf + 0.18u)'
+ ps='2*int((nf+2)/2) * (W/nf + 0.18u)' nrd='0.18u / W' nrs='0.18u / W' sa=0 sb=0 sd=0 m=1 par=1
XMPa1 n1 p4 VR VR pfet_03v3 L=0.28u W=12u nf=4 ad='int((nf+1)/2) * W/nf * 0.18u' as='int((nf+2)/2) * W/nf * 0.18u' pd='2*int((nf+1)/2) * (W/nf + 0.18u)'
+ ps='2*int((nf+2)/2) * (W/nf + 0.18u)' nrd='0.18u / W' nrs='0.18u / W' sa=0 sb=0 sd=0 m=1 par=1
XMPb1 p1 n4 VR VR pfet_03v3 L=0.28u W=12u nf=4 ad='int((nf+1)/2) * W/nf * 0.18u' as='int((nf+2)/2) * W/nf * 0.18u' pd='2*int((nf+1)/2) * (W/nf + 0.18u)'
+ ps='2*int((nf+2)/2) * (W/nf + 0.18u)' nrd='0.18u / W' nrs='0.18u / W' sa=0 sb=0 sd=0 m=1 par=1
XMNc1 n1 p1 VSS VSS nfet_03v3 L=0.28u W=1u nf=1 ad='int((nf+1)/2) * W/nf * 0.18u' as='int((nf+2)/2) * W/nf * 0.18u' pd='2*int((nf+1)/2) * (W/nf + 0.18u)'
+ ps='2*int((nf+2)/2) * (W/nf + 0.18u)' nrd='0.18u / W' nrs='0.18u / W' sa=0 sb=0 sd=0 m=1 par=1
XMNd1 p1 n1 VSS VSS nfet_03v3 L=0.28u W=1u nf=1 ad='int((nf+1)/2) * W/nf * 0.18u' as='int((nf+2)/2) * W/nf * 0.18u' pd='2*int((nf+1)/2) * (W/nf + 0.18u)'
+ ps='2*int((nf+2)/2) * (W/nf + 0.18u)' nrd='0.18u / W' nrs='0.18u / W' sa=0 sb=0 sd=0 m=1 par=1
XMPc1 n1 p1 VR VR pfet_03v3 L=0.28u W=2u nf=1 ad='int((nf+1)/2) * W/nf * 0.18u' as='int((nf+2)/2) * W/nf * 0.18u' pd='2*int((nf+1)/2) * (W/nf + 0.18u)'
+ ps='2*int((nf+2)/2) * (W/nf + 0.18u)' nrd='0.18u / W' nrs='0.18u / W' sa=0 sb=0 sd=0 m=1 par=1
XMPd1 p1 n1 VR VR pfet_03v3 L=0.28u W=2u nf=1 ad='int((nf+1)/2) * W/nf * 0.18u' as='int((nf+2)/2) * W/nf * 0.18u' pd='2*int((nf+1)/2) * (W/nf + 0.18u)'
+ ps='2*int((nf+2)/2) * (W/nf + 0.18u)' nrd='0.18u / W' nrs='0.18u / W' sa=0 sb=0 sd=0 m=1 par=1
XMNa2 n2 p1 VSS VSS nfet_03v3 L=0.28u W=8u nf=2 ad='int((nf+1)/2) * W/nf * 0.18u' as='int((nf+2)/2) * W/nf * 0.18u' pd='2*int((nf+1)/2) * (W/nf + 0.18u)'
+ ps='2*int((nf+2)/2) * (W/nf + 0.18u)' nrd='0.18u / W' nrs='0.18u / W' sa=0 sb=0 sd=0 m=1 par=1
XMNb2 p2 n1 VSS VSS nfet_03v3 L=0.28u W=8u nf=2 ad='int((nf+1)/2) * W/nf * 0.18u' as='int((nf+2)/2) * W/nf * 0.18u' pd='2*int((nf+1)/2) * (W/nf + 0.18u)'
+ ps='2*int((nf+2)/2) * (W/nf + 0.18u)' nrd='0.18u / W' nrs='0.18u / W' sa=0 sb=0 sd=0 m=1 par=1
XMPa2 n2 p1 VR VR pfet_03v3 L=0.28u W=12u nf=4 ad='int((nf+1)/2) * W/nf * 0.18u' as='int((nf+2)/2) * W/nf * 0.18u' pd='2*int((nf+1)/2) * (W/nf + 0.18u)'
+ ps='2*int((nf+2)/2) * (W/nf + 0.18u)' nrd='0.18u / W' nrs='0.18u / W' sa=0 sb=0 sd=0 m=1 par=1
XMPb2 p2 n1 VR VR pfet_03v3 L=0.28u W=12u nf=4 ad='int((nf+1)/2) * W/nf * 0.18u' as='int((nf+2)/2) * W/nf * 0.18u' pd='2*int((nf+1)/2) * (W/nf + 0.18u)'
+ ps='2*int((nf+2)/2) * (W/nf + 0.18u)' nrd='0.18u / W' nrs='0.18u / W' sa=0 sb=0 sd=0 m=1 par=1
XMNc2 n2 p2 VSS VSS nfet_03v3 L=0.28u W=1u nf=1 ad='int((nf+1)/2) * W/nf * 0.18u' as='int((nf+2)/2) * W/nf * 0.18u' pd='2*int((nf+1)/2) * (W/nf + 0.18u)'
+ ps='2*int((nf+2)/2) * (W/nf + 0.18u)' nrd='0.18u / W' nrs='0.18u / W' sa=0 sb=0 sd=0 m=1 par=1
XMNd2 p2 n2 VSS VSS nfet_03v3 L=0.28u W=1u nf=1 ad='int((nf+1)/2) * W/nf * 0.18u' as='int((nf+2)/2) * W/nf * 0.18u' pd='2*int((nf+1)/2) * (W/nf + 0.18u)'
+ ps='2*int((nf+2)/2) * (W/nf + 0.18u)' nrd='0.18u / W' nrs='0.18u / W' sa=0 sb=0 sd=0 m=1 par=1
XMPc2 n2 p2 VR VR pfet_03v3 L=0.28u W=2u nf=1 ad='int((nf+1)/2) * W/nf * 0.18u' as='int((nf+2)/2) * W/nf * 0.18u' pd='2*int((nf+1)/2) * (W/nf + 0.18u)'
+ ps='2*int((nf+2)/2) * (W/nf + 0.18u)' nrd='0.18u / W' nrs='0.18u / W' sa=0 sb=0 sd=0 m=1 par=1
XMPd2 p2 n2 VR VR pfet_03v3 L=0.28u W=2u nf=1 ad='int((nf+1)/2) * W/nf * 0.18u' as='int((nf+2)/2) * W/nf * 0.18u' pd='2*int((nf+1)/2) * (W/nf + 0.18u)'
+ ps='2*int((nf+2)/2) * (W/nf + 0.18u)' nrd='0.18u / W' nrs='0.18u / W' sa=0 sb=0 sd=0 m=1 par=1
XMNa3 n3 p2 VSS VSS nfet_03v3 L=0.28u W=8u nf=2 ad='int((nf+1)/2) * W/nf * 0.18u' as='int((nf+2)/2) * W/nf * 0.18u' pd='2*int((nf+1)/2) * (W/nf + 0.18u)'
+ ps='2*int((nf+2)/2) * (W/nf + 0.18u)' nrd='0.18u / W' nrs='0.18u / W' sa=0 sb=0 sd=0 m=1 par=1
XMNb3 p3 n2 VSS VSS nfet_03v3 L=0.28u W=8u nf=2 ad='int((nf+1)/2) * W/nf * 0.18u' as='int((nf+2)/2) * W/nf * 0.18u' pd='2*int((nf+1)/2) * (W/nf + 0.18u)'
+ ps='2*int((nf+2)/2) * (W/nf + 0.18u)' nrd='0.18u / W' nrs='0.18u / W' sa=0 sb=0 sd=0 m=1 par=1
XMPa3 n3 p2 VR VR pfet_03v3 L=0.28u W=12u nf=4 ad='int((nf+1)/2) * W/nf * 0.18u' as='int((nf+2)/2) * W/nf * 0.18u' pd='2*int((nf+1)/2) * (W/nf + 0.18u)'
+ ps='2*int((nf+2)/2) * (W/nf + 0.18u)' nrd='0.18u / W' nrs='0.18u / W' sa=0 sb=0 sd=0 m=1 par=1
XMPb3 p3 n2 VR VR pfet_03v3 L=0.28u W=12u nf=4 ad='int((nf+1)/2) * W/nf * 0.18u' as='int((nf+2)/2) * W/nf * 0.18u' pd='2*int((nf+1)/2) * (W/nf + 0.18u)'
+ ps='2*int((nf+2)/2) * (W/nf + 0.18u)' nrd='0.18u / W' nrs='0.18u / W' sa=0 sb=0 sd=0 m=1 par=1
XMNc3 n3 p3 VSS VSS nfet_03v3 L=0.28u W=1u nf=1 ad='int((nf+1)/2) * W/nf * 0.18u' as='int((nf+2)/2) * W/nf * 0.18u' pd='2*int((nf+1)/2) * (W/nf + 0.18u)'
+ ps='2*int((nf+2)/2) * (W/nf + 0.18u)' nrd='0.18u / W' nrs='0.18u / W' sa=0 sb=0 sd=0 m=1 par=1
XMNd3 p3 n3 VSS VSS nfet_03v3 L=0.28u W=1u nf=1 ad='int((nf+1)/2) * W/nf * 0.18u' as='int((nf+2)/2) * W/nf * 0.18u' pd='2*int((nf+1)/2) * (W/nf + 0.18u)'
+ ps='2*int((nf+2)/2) * (W/nf + 0.18u)' nrd='0.18u / W' nrs='0.18u / W' sa=0 sb=0 sd=0 m=1 par=1
XMPc3 n3 p3 VR VR pfet_03v3 L=0.28u W=2u nf=1 ad='int((nf+1)/2) * W/nf * 0.18u' as='int((nf+2)/2) * W/nf * 0.18u' pd='2*int((nf+1)/2) * (W/nf + 0.18u)'
+ ps='2*int((nf+2)/2) * (W/nf + 0.18u)' nrd='0.18u / W' nrs='0.18u / W' sa=0 sb=0 sd=0 m=1 par=1
XMPd3 p3 n3 VR VR pfet_03v3 L=0.28u W=2u nf=1 ad='int((nf+1)/2) * W/nf * 0.18u' as='int((nf+2)/2) * W/nf * 0.18u' pd='2*int((nf+1)/2) * (W/nf + 0.18u)'
+ ps='2*int((nf+2)/2) * (W/nf + 0.18u)' nrd='0.18u / W' nrs='0.18u / W' sa=0 sb=0 sd=0 m=1 par=1
XMNa4 p4 p3 VSS VSS nfet_03v3 L=0.28u W=8u nf=2 ad='int((nf+1)/2) * W/nf * 0.18u' as='int((nf+2)/2) * W/nf * 0.18u' pd='2*int((nf+1)/2) * (W/nf + 0.18u)'
+ ps='2*int((nf+2)/2) * (W/nf + 0.18u)' nrd='0.18u / W' nrs='0.18u / W' sa=0 sb=0 sd=0 m=1 par=1
XMNb4 n4 n3 VSS VSS nfet_03v3 L=0.28u W=8u nf=2 ad='int((nf+1)/2) * W/nf * 0.18u' as='int((nf+2)/2) * W/nf * 0.18u' pd='2*int((nf+1)/2) * (W/nf + 0.18u)'
+ ps='2*int((nf+2)/2) * (W/nf + 0.18u)' nrd='0.18u / W' nrs='0.18u / W' sa=0 sb=0 sd=0 m=1 par=1
XMPa4 p4 p3 VR VR pfet_03v3 L=0.28u W=12u nf=4 ad='int((nf+1)/2) * W/nf * 0.18u' as='int((nf+2)/2) * W/nf * 0.18u' pd='2*int((nf+1)/2) * (W/nf + 0.18u)'
+ ps='2*int((nf+2)/2) * (W/nf + 0.18u)' nrd='0.18u / W' nrs='0.18u / W' sa=0 sb=0 sd=0 m=1 par=1
XMPb4 n4 n3 VR VR pfet_03v3 L=0.28u W=12u nf=4 ad='int((nf+1)/2) * W/nf * 0.18u' as='int((nf+2)/2) * W/nf * 0.18u' pd='2*int((nf+1)/2) * (W/nf + 0.18u)'
+ ps='2*int((nf+2)/2) * (W/nf + 0.18u)' nrd='0.18u / W' nrs='0.18u / W' sa=0 sb=0 sd=0 m=1 par=1
XMNc4 p4 n4 VSS VSS nfet_03v3 L=0.28u W=1u nf=1 ad='int((nf+1)/2) * W/nf * 0.18u' as='int((nf+2)/2) * W/nf * 0.18u' pd='2*int((nf+1)/2) * (W/nf + 0.18u)'
+ ps='2*int((nf+2)/2) * (W/nf + 0.18u)' nrd='0.18u / W' nrs='0.18u / W' sa=0 sb=0 sd=0 m=1 par=1
XMNd4 n4 p4 VSS VSS nfet_03v3 L=0.28u W=1u nf=1 ad='int((nf+1)/2) * W/nf * 0.18u' as='int((nf+2)/2) * W/nf * 0.18u' pd='2*int((nf+1)/2) * (W/nf + 0.18u)'
+ ps='2*int((nf+2)/2) * (W/nf + 0.18u)' nrd='0.18u / W' nrs='0.18u / W' sa=0 sb=0 sd=0 m=1 par=1
XMPc4 p4 n4 VR VR pfet_03v3 L=0.28u W=2u nf=1 ad='int((nf+1)/2) * W/nf * 0.18u' as='int((nf+2)/2) * W/nf * 0.18u' pd='2*int((nf+1)/2) * (W/nf + 0.18u)'
+ ps='2*int((nf+2)/2) * (W/nf + 0.18u)' nrd='0.18u / W' nrs='0.18u / W' sa=0 sb=0 sd=0 m=1 par=1
XMPd4 n4 p4 VR VR pfet_03v3 L=0.28u W=2u nf=1 ad='int((nf+1)/2) * W/nf * 0.18u' as='int((nf+2)/2) * W/nf * 0.18u' pd='2*int((nf+1)/2) * (W/nf + 0.18u)'
+ ps='2*int((nf+2)/2) * (W/nf + 0.18u)' nrd='0.18u / W' nrs='0.18u / W' sa=0 sb=0 sd=0 m=1 par=1
XMK1 n1 kh VSS VSS nfet_03v3 L=0.28u W=8u nf=2 ad='int((nf+1)/2) * W/nf * 0.18u' as='int((nf+2)/2) * W/nf * 0.18u' pd='2*int((nf+1)/2) * (W/nf + 0.18u)'
+ ps='2*int((nf+2)/2) * (W/nf + 0.18u)' nrd='0.18u / W' nrs='0.18u / W' sa=0 sb=0 sd=0 m=1 par=1
XMKD1 p1 VSS VSS VSS nfet_03v3 L=0.28u W=8u nf=2 ad='int((nf+1)/2) * W/nf * 0.18u' as='int((nf+2)/2) * W/nf * 0.18u' pd='2*int((nf+1)/2) * (W/nf + 0.18u)'
+ ps='2*int((nf+2)/2) * (W/nf + 0.18u)' nrd='0.18u / W' nrs='0.18u / W' sa=0 sb=0 sd=0 m=1 par=1
XMK2 n2 kl VSS VSS nfet_03v3 L=0.28u W=8u nf=2 ad='int((nf+1)/2) * W/nf * 0.18u' as='int((nf+2)/2) * W/nf * 0.18u' pd='2*int((nf+1)/2) * (W/nf + 0.18u)'
+ ps='2*int((nf+2)/2) * (W/nf + 0.18u)' nrd='0.18u / W' nrs='0.18u / W' sa=0 sb=0 sd=0 m=1 par=1
XMKD2 p2 VSS VSS VSS nfet_03v3 L=0.28u W=8u nf=2 ad='int((nf+1)/2) * W/nf * 0.18u' as='int((nf+2)/2) * W/nf * 0.18u' pd='2*int((nf+1)/2) * (W/nf + 0.18u)'
+ ps='2*int((nf+2)/2) * (W/nf + 0.18u)' nrd='0.18u / W' nrs='0.18u / W' sa=0 sb=0 sd=0 m=1 par=1
.ends

* expanding   symbol:  inv_lo1.sym # of pins=4
** sym_path: /home/noritsuna/GPS/xschem/inv_lo1.sym
** sch_path: /home/noritsuna/GPS/xschem/inv_lo1.sch
.subckt inv_lo1 A Y VDD VSS
*.ipin A
*.opin Y
*.iopin VDD
*.iopin VSS
XMN Y A VSS VSS nfet_03v3 L=0.28u W=2u nf=1 ad='int((nf+1)/2) * W/nf * 0.18u' as='int((nf+2)/2) * W/nf * 0.18u' pd='2*int((nf+1)/2) * (W/nf + 0.18u)'
+ ps='2*int((nf+2)/2) * (W/nf + 0.18u)' nrd='0.18u / W' nrs='0.18u / W' sa=0 sb=0 sd=0 m=1 par=1
XMP Y A VDD VDD pfet_03v3 L=0.28u W=4u nf=1 ad='int((nf+1)/2) * W/nf * 0.18u' as='int((nf+2)/2) * W/nf * 0.18u' pd='2*int((nf+1)/2) * (W/nf + 0.18u)'
+ ps='2*int((nf+2)/2) * (W/nf + 0.18u)' nrd='0.18u / W' nrs='0.18u / W' sa=0 sb=0 sd=0 m=1 par=1
.ends

* expanding   symbol:  inv_lo2.sym # of pins=4
** sym_path: /home/noritsuna/GPS/xschem/inv_lo2.sym
** sch_path: /home/noritsuna/GPS/xschem/inv_lo2.sch
.subckt inv_lo2 A Y VDD VSS
*.ipin A
*.opin Y
*.iopin VDD
*.iopin VSS
XMN Y A VSS VSS nfet_03v3 L=0.28u W=6u nf=2 ad='int((nf+1)/2) * W/nf * 0.18u' as='int((nf+2)/2) * W/nf * 0.18u' pd='2*int((nf+1)/2) * (W/nf + 0.18u)'
+ ps='2*int((nf+2)/2) * (W/nf + 0.18u)' nrd='0.18u / W' nrs='0.18u / W' sa=0 sb=0 sd=0 m=1 par=1
XMP Y A VDD VDD pfet_03v3 L=0.28u W=12u nf=4 ad='int((nf+1)/2) * W/nf * 0.18u' as='int((nf+2)/2) * W/nf * 0.18u' pd='2*int((nf+1)/2) * (W/nf + 0.18u)'
+ ps='2*int((nf+2)/2) * (W/nf + 0.18u)' nrd='0.18u / W' nrs='0.18u / W' sa=0 sb=0 sd=0 m=1 par=1
.ends

* expanding   symbol:  nand2.sym # of pins=5
** sym_path: /home/noritsuna/GPS/xschem/nand2.sym
** sch_path: /home/noritsuna/GPS/xschem/nand2.sch
.subckt nand2 A B Y VDD VSS
*.ipin A
*.ipin B
*.opin Y
*.iopin VDD
*.iopin VSS
XMN1 Y A n1 VSS nfet_03v3 L=0.28u W=2u nf=1 ad='int((nf+1)/2) * W/nf * 0.18u' as='int((nf+2)/2) * W/nf * 0.18u' pd='2*int((nf+1)/2) * (W/nf + 0.18u)'
+ ps='2*int((nf+2)/2) * (W/nf + 0.18u)' nrd='0.18u / W' nrs='0.18u / W' sa=0 sb=0 sd=0 m=1 par=1
XMN2 n1 B VSS VSS nfet_03v3 L=0.28u W=2u nf=1 ad='int((nf+1)/2) * W/nf * 0.18u' as='int((nf+2)/2) * W/nf * 0.18u' pd='2*int((nf+1)/2) * (W/nf + 0.18u)'
+ ps='2*int((nf+2)/2) * (W/nf + 0.18u)' nrd='0.18u / W' nrs='0.18u / W' sa=0 sb=0 sd=0 m=1 par=1
XMP1 Y A VDD VDD pfet_03v3 L=0.28u W=2u nf=1 ad='int((nf+1)/2) * W/nf * 0.18u' as='int((nf+2)/2) * W/nf * 0.18u' pd='2*int((nf+1)/2) * (W/nf + 0.18u)'
+ ps='2*int((nf+2)/2) * (W/nf + 0.18u)' nrd='0.18u / W' nrs='0.18u / W' sa=0 sb=0 sd=0 m=1 par=1
XMP2 Y B VDD VDD pfet_03v3 L=0.28u W=2u nf=1 ad='int((nf+1)/2) * W/nf * 0.18u' as='int((nf+2)/2) * W/nf * 0.18u' pd='2*int((nf+1)/2) * (W/nf + 0.18u)'
+ ps='2*int((nf+2)/2) * (W/nf + 0.18u)' nrd='0.18u / W' nrs='0.18u / W' sa=0 sb=0 sd=0 m=1 par=1
.ends

* expanding   symbol:  nor2.sym # of pins=5
** sym_path: /home/noritsuna/GPS/xschem/nor2.sym
** sch_path: /home/noritsuna/GPS/xschem/nor2.sch
.subckt nor2 A B Y VDD VSS
*.ipin A
*.ipin B
*.opin Y
*.iopin VDD
*.iopin VSS
XMN1 Y A VSS VSS nfet_03v3 L=0.28u W=1u nf=1 ad='int((nf+1)/2) * W/nf * 0.18u' as='int((nf+2)/2) * W/nf * 0.18u' pd='2*int((nf+1)/2) * (W/nf + 0.18u)'
+ ps='2*int((nf+2)/2) * (W/nf + 0.18u)' nrd='0.18u / W' nrs='0.18u / W' sa=0 sb=0 sd=0 m=1 par=1
XMN2 Y B VSS VSS nfet_03v3 L=0.28u W=1u nf=1 ad='int((nf+1)/2) * W/nf * 0.18u' as='int((nf+2)/2) * W/nf * 0.18u' pd='2*int((nf+1)/2) * (W/nf + 0.18u)'
+ ps='2*int((nf+2)/2) * (W/nf + 0.18u)' nrd='0.18u / W' nrs='0.18u / W' sa=0 sb=0 sd=0 m=1 par=1
XMP1 n1 A VDD VDD pfet_03v3 L=0.28u W=4u nf=1 ad='int((nf+1)/2) * W/nf * 0.18u' as='int((nf+2)/2) * W/nf * 0.18u' pd='2*int((nf+1)/2) * (W/nf + 0.18u)'
+ ps='2*int((nf+2)/2) * (W/nf + 0.18u)' nrd='0.18u / W' nrs='0.18u / W' sa=0 sb=0 sd=0 m=1 par=1
XMP2 Y B n1 VDD pfet_03v3 L=0.28u W=4u nf=1 ad='int((nf+1)/2) * W/nf * 0.18u' as='int((nf+2)/2) * W/nf * 0.18u' pd='2*int((nf+1)/2) * (W/nf + 0.18u)'
+ ps='2*int((nf+2)/2) * (W/nf + 0.18u)' nrd='0.18u / W' nrs='0.18u / W' sa=0 sb=0 sd=0 m=1 par=1
.ends
* NGSPICE file created from vco_ring4_flat.ext - technology: gf180mcuD

.subckt vco_ring4_flat VSS VDD VCTRL B0 B1 LOIP LOIN LOQP LOQN VR
X0 VR.t226 VSS cap_mim_2f0_m4m5_noshield c_width=5u c_length=5u
X1 a_9525_52239# a_9449_57629# VR.t9 VR.t8 pfet_03v3 ad=0.795p pd=3.53u as=0.795p ps=3.53u w=3u l=0.28u
X2 a_15609_57629# a_9849_52239# VSS VSS nfet_03v3 ad=1.06p pd=4.53u as=1.06p ps=4.53u w=4u l=0.28u
X3 VR.t226 VSS cap_mim_2f0_m4m5_noshield c_width=5u c_length=5u
X4 VSS a_10429_78629# LOQN VSS nfet_03v3 ad=1.335p pd=6.89u as=0.795p ps=3.53u w=3u l=0.28u
X5 a_25065_27002# a_18787_27249# a_25065_30860# VR.t217 pfet_03v3 ad=1.78p pd=8.89u as=1.78p ps=8.89u w=4u l=0.28u
X6 a_30000_3486# a_30840_1364# VSS ppolyf_u_1k r_width=1u r_length=10u
X7 VR.t226 VSS cap_mim_2f0_m4m5_noshield c_width=5u c_length=5u
X8 a_22169_56859# VSS VSS VSS nfet_03v3 ad=1.06p pd=4.53u as=1.06p ps=4.53u w=4u l=0.28u
X9 VR.t191 a_22169_56859# a_15933_56649# VR.t190 pfet_03v3 ad=0.795p pd=3.53u as=0.795p ps=3.53u w=3u l=0.28u
X10 VR.t70 a_10429_27389# LOIN VR.t69 pfet_03v3 ad=0.795p pd=3.53u as=0.795p ps=3.53u w=3u l=0.28u
X11 a_9773_56649# a_9449_57629# VSS VSS nfet_03v3 ad=0.445p pd=2.89u as=0.445p ps=2.89u w=1u l=0.28u
X12 VR.t226 VSS cap_mim_2f0_m4m5_noshield c_width=5u c_length=5u
X13 a_15933_56649# a_22169_56859# VR.t193 VR.t192 pfet_03v3 ad=0.795p pd=3.53u as=0.795p ps=3.53u w=3u l=0.28u
X14 VR.t30 a_9773_56649# a_9849_56859# VR.t29 pfet_03v3 ad=0.795p pd=3.53u as=0.795p ps=3.53u w=3u l=0.28u
X15 a_8697_11960# a_18269_13109# VR.t225 VDD pfet_03v3 ad=2.225p pd=10.89u as=1.325p ps=5.53u w=5u l=0.28u
X16 a_25065_27002# a_17107_27249# VSS VSS nfet_03v3 ad=0.445p pd=2.89u as=0.445p ps=2.89u w=1u l=0.28u
X17 a_32905_77900# a_25065_27002# a_32760_77900# VSS nfet_03v3 ad=0.89p pd=4.89u as=0.89p ps=4.89u w=2u l=0.28u
X18 LOQN a_10429_78629# VSS VSS nfet_03v3 ad=0.795p pd=3.53u as=1.335p ps=6.89u w=3u l=0.28u
X19 VR.t84 a_9849_52239# a_15609_57629# VR.t83 pfet_03v3 ad=0.795p pd=3.53u as=0.795p ps=3.53u w=3u l=0.28u
X20 a_25065_78242# a_17107_78489# VSS VSS nfet_03v3 ad=0.445p pd=2.89u as=0.445p ps=2.89u w=1u l=0.28u
X21 VR.t226 VSS cap_mim_2f0_m4m5_noshield c_width=5u c_length=5u
X22 VSS a_3709_27389# LOIP VSS nfet_03v3 ad=1.335p pd=6.89u as=0.795p ps=3.53u w=3u l=0.28u
X23 a_22169_56859# a_9849_52239# VSS VSS nfet_03v3 ad=0.445p pd=2.89u as=0.445p ps=2.89u w=1u l=0.28u
X24 VDD VR.t2 VSS ppolyf_u_1k r_width=2u r_length=5u
X25 VR.t74 a_10429_27389# LOIN VR.t73 pfet_03v3 ad=1.335p pd=6.89u as=0.795p ps=3.53u w=3u l=0.28u
X26 a_40745_27002# a_9449_53149# VSS VSS nfet_03v3 ad=0.445p pd=2.89u as=0.445p ps=2.89u w=1u l=0.28u
X27 a_17225_26660# a_18787_27249# VR.t216 VR.t215 pfet_03v3 ad=0.89p pd=4.89u as=0.89p ps=4.89u w=2u l=0.28u
X28 a_9449_57629# a_15609_57629# VSS VSS nfet_03v3 ad=1.06p pd=4.53u as=1.78p ps=8.89u w=4u l=0.28u
X29 LOQP a_3709_78629# VR.t45 VR.t44 pfet_03v3 ad=0.795p pd=3.53u as=1.335p ps=6.89u w=3u l=0.28u
X30 a_32905_30860# a_17225_26660# VR.t201 VR.t200 pfet_03v3 ad=1.78p pd=8.89u as=1.78p ps=8.89u w=4u l=0.28u
X31 LOIN a_10429_27389# VR.t68 VR.t67 pfet_03v3 ad=0.795p pd=3.53u as=1.335p ps=6.89u w=3u l=0.28u
X32 a_9773_52029# a_32905_77900# VSS VSS nfet_03v3 ad=0.445p pd=2.89u as=0.445p ps=2.89u w=1u l=0.28u
X33 a_17225_77900# a_13025_65300# VR.t204 VR.t203 pfet_03v3 ad=0.89p pd=4.89u as=0.89p ps=4.89u w=2u l=0.28u
X34 VR.t88 a_9849_52239# a_15609_57629# VR.t87 pfet_03v3 ad=0.795p pd=3.53u as=0.795p ps=3.53u w=3u l=0.28u
X35 a_3709_78629# a_15609_57629# VSS VSS nfet_03v3 ad=0.89p pd=4.89u as=0.89p ps=4.89u w=2u l=0.28u
X36 VR.t226 VSS cap_mim_2f0_m4m5_noshield c_width=5u c_length=5u
X37 VR.t226 VSS cap_mim_2f0_m4m5_noshield c_width=5u c_length=5u
X38 a_17107_27249# a_22169_56859# VSS VSS nfet_03v3 ad=0.89p pd=4.89u as=0.89p ps=4.89u w=2u l=0.28u
X39 a_15933_56649# a_15609_57629# VSS VSS nfet_03v3 ad=0.445p pd=2.89u as=0.445p ps=2.89u w=1u l=0.28u
X40 a_28320_3486# a_27480_1364# VSS ppolyf_u_1k r_width=1u r_length=10u
X41 VR.t226 VSS cap_mim_2f0_m4m5_noshield c_width=5u c_length=5u
X42 a_9849_52239# a_22169_56859# VR.t185 VR.t184 pfet_03v3 ad=0.89p pd=4.89u as=0.89p ps=4.89u w=2u l=0.28u
X43 a_4409_13109.t11 VCTRL a_21840_1180# VSS nfet_03v3 ad=1.325p pd=5.53u as=2.225p ps=10.89u w=5u l=0.5u
X44 VR.t40 a_3709_27389# LOIP VR.t39 pfet_03v3 ad=1.335p pd=6.89u as=0.795p ps=3.53u w=3u l=0.28u
X45 a_3709_78629# a_15609_57629# VR.t58 VR.t57 pfet_03v3 ad=1.78p pd=8.89u as=1.78p ps=8.89u w=4u l=0.28u
X46 VR.t226 VSS cap_mim_2f0_m4m5_noshield c_width=5u c_length=5u
X47 a_30000_3486# a_29160_1364# VSS ppolyf_u_1k r_width=1u r_length=10u
X48 a_31680_3486# a_32520_1364# VSS ppolyf_u_1k r_width=1u r_length=10u
X49 a_18269_13109# B0 VSS VSS nfet_03v3 ad=0.445p pd=2.89u as=0.445p ps=2.89u w=1u l=0.28u
X50 a_26640_3486# a_27480_1364# VSS ppolyf_u_1k r_width=1u r_length=10u
X51 VR.t15 a_9449_57629# a_9525_52239# VR.t14 pfet_03v3 ad=1.335p pd=6.89u as=0.795p ps=3.53u w=3u l=0.28u
X52 VSS a_9849_52239# a_15609_57629# VSS nfet_03v3 ad=1.78p pd=8.89u as=1.06p ps=4.53u w=4u l=0.28u
X53 a_10429_78629# a_15933_56649# VSS VSS nfet_03v3 ad=0.89p pd=4.89u as=0.89p ps=4.89u w=2u l=0.28u
X54 a_15933_56649# a_22169_56859# VR.t189 VR.t188 pfet_03v3 ad=0.795p pd=3.53u as=1.335p ps=6.89u w=3u l=0.28u
X55 a_9849_56859# a_9773_56649# VR.t28 VR.t27 pfet_03v3 ad=0.795p pd=3.53u as=0.795p ps=3.53u w=3u l=0.28u
X56 VR.t226 VSS cap_mim_2f0_m4m5_noshield c_width=5u c_length=5u
X57 a_4809_11960.t3 a_4409_13109.t16 VDD VDD pfet_03v3 ad=1.325p pd=5.53u as=1.325p ps=5.53u w=5u l=0.28u
X58 a_18787_27249# a_9849_52239# VSS VSS nfet_03v3 ad=0.89p pd=4.89u as=0.89p ps=4.89u w=2u l=0.28u
X59 a_31680_3486# a_30840_1364# VSS ppolyf_u_1k r_width=1u r_length=10u
X60 a_15933_56649# a_15609_57629# VR.t66 VR.t65 pfet_03v3 ad=0.89p pd=4.89u as=0.89p ps=4.89u w=2u l=0.28u
X61 VSS a_10429_27389# LOIN VSS nfet_03v3 ad=1.335p pd=6.89u as=0.795p ps=3.53u w=3u l=0.28u
X62 a_10429_78629# a_15933_56649# VR.t167 VR.t166 pfet_03v3 ad=1.78p pd=8.89u as=1.78p ps=8.89u w=4u l=0.28u
X63 LOQP a_3709_78629# VSS VSS nfet_03v3 ad=0.795p pd=3.53u as=1.335p ps=6.89u w=3u l=0.28u
X64 a_4809_11960.t11 a_4409_13109.t88 VDD VDD pfet_03v3 ad=1.325p pd=5.53u as=1.325p ps=5.53u w=5u l=0.28u
X65 VSS a_22169_56859# a_15933_56649# VSS nfet_03v3 ad=1.06p pd=4.53u as=1.06p ps=4.53u w=4u l=0.28u
X66 a_17225_26660# a_17107_27249# VR.t118 VR.t117 pfet_03v3 ad=0.89p pd=4.89u as=0.89p ps=4.89u w=2u l=0.28u
X67 VR.t226 VSS cap_mim_2f0_m4m5_noshield c_width=5u c_length=5u
X68 VR.t226 VSS cap_mim_2f0_m4m5_noshield c_width=5u c_length=5u
X69 LOIP a_3709_27389# VR.t34 VR.t33 pfet_03v3 ad=0.795p pd=3.53u as=1.335p ps=6.89u w=3u l=0.28u
X70 VR.t176 a_22469_13109.t17 a_4809_11960.t2 VDD pfet_03v3 ad=1.325p pd=5.53u as=1.325p ps=5.53u w=5u l=0.28u
X71 a_17225_77900# a_17107_78489# VR.t135 VR.t134 pfet_03v3 ad=0.89p pd=4.89u as=0.89p ps=4.89u w=2u l=0.28u
X72 VR.t226 VSS cap_mim_2f0_m4m5_noshield c_width=5u c_length=5u
X73 VR.t221 a_18269_13109# a_8697_11960# VDD pfet_03v3 ad=1.325p pd=5.53u as=1.325p ps=5.53u w=5u l=0.28u
X74 VDD a_4409_13109.t21 VR.t202 VDD pfet_03v3 ad=1.325p pd=5.53u as=1.325p ps=5.53u w=5u l=0.28u
X75 LOIN a_10429_27389# VSS VSS nfet_03v3 ad=0.795p pd=3.53u as=1.335p ps=6.89u w=3u l=0.28u
X76 a_4809_11960.t2 a_22469_13109.t12 VR.t148 VDD pfet_03v3 ad=1.325p pd=5.53u as=1.325p ps=5.53u w=5u l=0.28u
X77 a_33360_3486# a_17225_26660# VSS ppolyf_u_1k r_width=1u r_length=10u
X78 VR.t198 a_22469_13109.t49 a_4809_11960.t1 VDD pfet_03v3 ad=1.325p pd=5.53u as=1.325p ps=5.53u w=5u l=0.28u
X79 a_15933_56649# a_22169_56859# VSS VSS nfet_03v3 ad=1.06p pd=4.53u as=1.78p ps=8.89u w=4u l=0.28u
X80 a_9849_52239# a_9773_52029# VSS VSS nfet_03v3 ad=1.06p pd=4.53u as=1.06p ps=4.53u w=4u l=0.28u
X81 a_28320_3486# a_29160_1364# VSS ppolyf_u_1k r_width=1u r_length=10u
X82 VR.t222 a_18269_13109# a_8697_11960# VDD pfet_03v3 ad=1.325p pd=5.53u as=1.325p ps=5.53u w=5u l=0.28u
X83 VDD a_4409_13109.t93 VR.t78 VDD pfet_03v3 ad=1.325p pd=5.53u as=1.325p ps=5.53u w=5u l=0.28u
X84 a_22169_56859# a_9525_52239# VSS VSS nfet_03v3 ad=1.06p pd=4.53u as=1.06p ps=4.53u w=4u l=0.28u
X85 a_9849_56859# VSS VSS VSS nfet_03v3 ad=1.06p pd=4.53u as=1.78p ps=8.89u w=4u l=0.28u
X86 a_4809_11960.t2 a_22469_13109.t4 VR.t18 VDD pfet_03v3 ad=1.325p pd=5.53u as=1.325p ps=5.53u w=5u l=0.28u
X87 a_4809_11960.t1 a_22469_13109.t44 VR.t210 VDD pfet_03v3 ad=1.325p pd=5.53u as=1.325p ps=5.53u w=5u l=0.28u
X88 a_8697_11960# a_18269_13109# VR.t220 VDD pfet_03v3 ad=1.325p pd=5.53u as=1.325p ps=5.53u w=5u l=0.28u
X89 a_9449_53149# a_26640_1364# VSS VSS nfet_03v3 ad=0.445p pd=2.89u as=0.445p ps=2.89u w=1u l=0.28u
X90 a_25065_82100# a_17107_78489# VR.t137 VR.t136 pfet_03v3 ad=1.78p pd=8.89u as=1.78p ps=8.89u w=4u l=0.28u
X91 VR.t226 VSS cap_mim_2f0_m4m5_noshield c_width=5u c_length=5u
X92 VDD a_4409_13109.t37 VR.t183 VDD pfet_03v3 ad=1.325p pd=5.53u as=1.325p ps=5.53u w=5u l=0.28u
X93 VR.t226 VSS cap_mim_2f0_m4m5_noshield c_width=5u c_length=5u
X94 a_32905_77900# a_27060_1364# VR.t139 VR.t138 pfet_03v3 ad=0.89p pd=4.89u as=0.89p ps=4.89u w=2u l=0.28u
X95 a_4809_11960.t2 a_22469_13109.t22 VR.t179 VDD pfet_03v3 ad=1.325p pd=5.53u as=1.325p ps=5.53u w=5u l=0.28u
X96 a_9849_52239# a_22169_56859# VSS VSS nfet_03v3 ad=0.445p pd=2.89u as=0.445p ps=2.89u w=1u l=0.28u
X97 a_27060_3486# a_27900_1364# VSS ppolyf_u_1k r_width=1u r_length=10u
X98 VR.t226 VSS cap_mim_2f0_m4m5_noshield c_width=5u c_length=5u
X99 a_33360_3486# a_32520_1364# VSS ppolyf_u_1k r_width=1u r_length=10u
X100 VDD a_4409_13109.t67 VR.t149 VDD pfet_03v3 ad=1.325p pd=5.53u as=1.325p ps=5.53u w=5u l=0.28u
X101 a_17107_78489# a_9449_57629# VSS VSS nfet_03v3 ad=0.89p pd=4.89u as=0.89p ps=4.89u w=2u l=0.28u
X102 a_8697_11960# a_18269_13109# VR.t218 VDD pfet_03v3 ad=1.325p pd=5.53u as=1.325p ps=5.53u w=5u l=0.28u
X103 VR.t158 a_4409_13109.t26 VDD VDD pfet_03v3 ad=1.325p pd=5.53u as=1.325p ps=5.53u w=5u l=0.28u
X104 VDD a_4409_13109.t7 a_4409_13109.t6 VDD pfet_03v3 ad=1.325p pd=5.53u as=1.325p ps=5.53u w=5u l=0.28u
X105 a_9773_52029# a_32905_77900# VR.t42 VR.t41 pfet_03v3 ad=0.89p pd=4.89u as=0.89p ps=4.89u w=2u l=0.28u
X106 VR.t175 a_22469_13109.t11 a_4809_11960.t2 VDD pfet_03v3 ad=1.325p pd=5.53u as=1.325p ps=5.53u w=5u l=0.28u
X107 a_4809_11960.t1 a_22469_13109.t36 VR.t182 VDD pfet_03v3 ad=1.325p pd=5.53u as=1.325p ps=5.53u w=5u l=0.28u
X108 a_10429_27389# a_9525_52239# VSS VSS nfet_03v3 ad=0.89p pd=4.89u as=0.89p ps=4.89u w=2u l=0.28u
X109 a_9849_56859# a_9525_52239# VSS VSS nfet_03v3 ad=0.445p pd=2.89u as=0.445p ps=2.89u w=1u l=0.28u
X110 VDD a_4409_13109.t109 VR.t92 VDD pfet_03v3 ad=1.325p pd=5.53u as=1.325p ps=5.53u w=5u l=0.28u
X111 a_9449_57629# a_9773_56649# VR.t20 VR.t19 pfet_03v3 ad=0.89p pd=4.89u as=0.89p ps=4.89u w=2u l=0.28u
X112 VSS a_9773_56649# a_9849_56859# VSS nfet_03v3 ad=1.78p pd=8.89u as=1.06p ps=4.53u w=4u l=0.28u
X113 a_4809_11960.t22 a_4409_13109.t62 VDD VDD pfet_03v3 ad=1.325p pd=5.53u as=1.325p ps=5.53u w=5u l=0.28u
X114 a_9849_52239# a_9849_56859# VR.t108 VR.t107 pfet_03v3 ad=0.795p pd=3.53u as=0.795p ps=3.53u w=3u l=0.28u
X115 VR.t60 a_15609_57629# a_9449_57629# VR.t59 pfet_03v3 ad=0.795p pd=3.53u as=0.795p ps=3.53u w=3u l=0.28u
X116 a_4809_11960.t1 a_22469_13109.t54 VR.t207 VDD pfet_03v3 ad=1.325p pd=5.53u as=1.325p ps=5.53u w=5u l=0.28u
X117 VDD a_4409_13109.t15 a_4809_11960.t3 VDD pfet_03v3 ad=1.325p pd=5.53u as=1.325p ps=5.53u w=5u l=0.28u
X118 a_4809_11960.t2 a_22469_13109.t20 VR.t178 VDD pfet_03v3 ad=1.325p pd=5.53u as=1.325p ps=5.53u w=5u l=0.28u
X119 VDD a_4409_13109.t45 a_8697_11960# VDD pfet_03v3 ad=1.325p pd=5.53u as=1.325p ps=5.53u w=5u l=0.28u
X120 VDD a_4409_13109.t139 VR.t157 VDD pfet_03v3 ad=1.325p pd=5.53u as=1.325p ps=5.53u w=5u l=0.28u
X121 VR.t226 VSS cap_mim_2f0_m4m5_noshield c_width=5u c_length=5u
X122 a_17107_78489# a_9449_57629# VR.t11 VR.t10 pfet_03v3 ad=1.78p pd=8.89u as=1.78p ps=8.89u w=4u l=0.28u
X123 a_4809_11960.t2 a_22469_13109.t6 VR.t17 VDD pfet_03v3 ad=1.325p pd=5.53u as=1.325p ps=5.53u w=5u l=0.28u
X124 a_8697_11960# a_18269_13109# VR.t219 VDD pfet_03v3 ad=1.325p pd=5.53u as=1.325p ps=5.53u w=5u l=0.28u
X125 VR.t126 a_9525_52239# a_22169_56859# VR.t125 pfet_03v3 ad=0.795p pd=3.53u as=0.795p ps=3.53u w=3u l=0.28u
X126 VR.t226 VSS cap_mim_2f0_m4m5_noshield c_width=5u c_length=5u
X127 VR.t131 a_4409_13109.t98 VDD VDD pfet_03v3 ad=1.325p pd=5.53u as=1.325p ps=5.53u w=5u l=0.28u
X128 VDD a_4409_13109.t2 a_4409_13109.t1 VDD pfet_03v3 ad=1.325p pd=5.53u as=1.325p ps=5.53u w=5u l=0.28u
X129 a_4809_11960.t26 a_4409_13109.t24 VDD VDD pfet_03v3 ad=1.325p pd=5.53u as=1.325p ps=5.53u w=5u l=0.28u
X130 VDD a_4409_13109.t53 VR.t102 VDD pfet_03v3 ad=1.325p pd=5.53u as=1.325p ps=5.53u w=5u l=0.28u
X131 a_3709_27389# a_9849_56859# VR.t104 VR.t103 pfet_03v3 ad=1.78p pd=8.89u as=1.78p ps=8.89u w=4u l=0.28u
X132 VR.t180 a_22469_13109.t43 a_4809_11960.t1 VDD pfet_03v3 ad=1.325p pd=5.53u as=1.325p ps=5.53u w=5u l=0.28u
X133 VDD a_4409_13109.t83 VR.t141 VDD pfet_03v3 ad=1.325p pd=5.53u as=1.325p ps=5.53u w=5u l=0.28u
X134 VR.t1 a_22469_13109.t9 a_4809_11960.t2 VDD pfet_03v3 ad=1.325p pd=5.53u as=1.325p ps=5.53u w=5u l=0.28u
X135 VR.t218 a_18269_13109# a_8697_11960# VDD pfet_03v3 ad=1.325p pd=5.53u as=2.225p ps=10.89u w=5u l=0.28u
X136 a_4809_11960.t14 a_4409_13109.t42 VDD VDD pfet_03v3 ad=1.325p pd=5.53u as=1.325p ps=5.53u w=5u l=0.28u
X137 a_4409_13109.t6 a_4409_13109.t5 VDD VDD pfet_03v3 ad=1.325p pd=5.53u as=1.325p ps=5.53u w=5u l=0.28u
X138 a_4809_11960.t18 a_4409_13109.t134 VDD VDD pfet_03v3 ad=1.325p pd=5.53u as=1.325p ps=5.53u w=5u l=0.28u
X139 VR.t202 a_4409_13109.t22 VDD VDD pfet_03v3 ad=1.325p pd=5.53u as=1.325p ps=5.53u w=5u l=0.28u
X140 VDD a_4409_13109.t87 a_4809_11960.t11 VDD pfet_03v3 ad=1.325p pd=5.53u as=1.325p ps=5.53u w=5u l=0.28u
X141 VR.t212 a_22469_13109.t27 a_4809_11960.t2 VDD pfet_03v3 ad=1.325p pd=5.53u as=1.325p ps=5.53u w=5u l=0.28u
X142 a_4809_11960.t1 a_22469_13109.t52 VR.t213 VDD pfet_03v3 ad=1.325p pd=5.53u as=1.325p ps=5.53u w=5u l=0.28u
X143 VDD a_4409_13109.t13 VR.t32 VDD pfet_03v3 ad=2.225p pd=10.89u as=1.325p ps=5.53u w=5u l=0.28u
X144 VDD a_4409_13109.t117 a_8697_11960# VDD pfet_03v3 ad=1.325p pd=5.53u as=1.325p ps=5.53u w=5u l=0.28u
X145 VDD a_4409_13109.t43 VR.t91 VDD pfet_03v3 ad=1.325p pd=5.53u as=1.325p ps=5.53u w=5u l=0.28u
X146 VR.t156 a_4409_13109.t72 VDD VDD pfet_03v3 ad=1.325p pd=5.53u as=1.325p ps=5.53u w=5u l=0.28u
X147 a_4809_11960.t1 a_22469_13109.t38 VR.t147 VDD pfet_03v3 ad=1.325p pd=5.53u as=1.325p ps=5.53u w=5u l=0.28u
X148 VDD a_4409_13109.t31 a_4809_11960.t9 VDD pfet_03v3 ad=1.325p pd=5.53u as=1.325p ps=5.53u w=5u l=0.28u
X149 a_8697_11960# a_4409_13109.t58 VDD VDD pfet_03v3 ad=1.325p pd=5.53u as=1.325p ps=5.53u w=5u l=0.28u
X150 VR.t130 a_9525_52239# a_22169_56859# VR.t129 pfet_03v3 ad=0.795p pd=3.53u as=0.795p ps=3.53u w=3u l=0.28u
X151 a_4809_11960.t10 a_4409_13109.t96 VDD VDD pfet_03v3 ad=1.325p pd=5.53u as=1.325p ps=5.53u w=5u l=0.28u
X152 VDD a_4409_13109.t125 VR.t146 VDD pfet_03v3 ad=1.325p pd=5.53u as=1.325p ps=5.53u w=5u l=0.28u
X153 VSS a_9449_57629# a_9525_52239# VSS nfet_03v3 ad=1.06p pd=4.53u as=1.06p ps=4.53u w=4u l=0.28u
X154 VDD a_4409_13109.t155 VR.t155 VDD pfet_03v3 ad=1.325p pd=5.53u as=1.325p ps=5.53u w=5u l=0.28u
X155 a_4809_11960.t2 a_22469_13109.t16 VR.t176 VDD pfet_03v3 ad=1.325p pd=5.53u as=1.325p ps=5.53u w=5u l=0.28u
X156 VSS a_9449_53149# a_9525_52239# VSS nfet_03v3 ad=1.06p pd=4.53u as=1.06p ps=4.53u w=4u l=0.28u
X157 VR.t197 a_22469_13109.t41 a_4809_11960.t1 VDD pfet_03v3 ad=1.325p pd=5.53u as=1.325p ps=5.53u w=5u l=0.28u
X158 VDD a_4409_13109.t17 VR.t16 VDD pfet_03v3 ad=1.325p pd=5.53u as=1.325p ps=5.53u w=5u l=0.28u
X159 LOIP a_3709_27389# VSS VSS nfet_03v3 ad=0.795p pd=3.53u as=1.335p ps=6.89u w=3u l=0.28u
X160 VR.t142 a_4409_13109.t34 VDD VDD pfet_03v3 ad=1.325p pd=5.53u as=1.325p ps=5.53u w=5u l=0.28u
X161 VDD a_4409_13109.t61 a_4809_11960.t22 VDD pfet_03v3 ad=1.325p pd=5.53u as=1.325p ps=5.53u w=5u l=0.28u
X162 a_4809_11960.t31 a_4409_13109.t114 VDD VDD pfet_03v3 ad=1.325p pd=5.53u as=1.325p ps=5.53u w=5u l=0.28u
X163 a_4809_11960.t2 a_22469_13109.t2 VR.t53 VDD pfet_03v3 ad=2.225p pd=10.89u as=1.325p ps=5.53u w=5u l=0.28u
X164 a_4409_13109.t1 a_4409_13109.t0 VDD VDD pfet_03v3 ad=1.325p pd=5.53u as=1.325p ps=5.53u w=5u l=0.28u
X165 a_8697_11960# a_18269_13109# VR.t221 VDD pfet_03v3 ad=1.325p pd=5.53u as=1.325p ps=5.53u w=5u l=0.28u
X166 VR.t78 a_4409_13109.t94 VDD VDD pfet_03v3 ad=1.325p pd=5.53u as=1.325p ps=5.53u w=5u l=0.28u
X167 VR.t112 a_9849_56859# a_9849_52239# VR.t111 pfet_03v3 ad=0.795p pd=3.53u as=0.795p ps=3.53u w=3u l=0.28u
X168 VR.t52 a_22469_13109.t59 a_4809_11960.t0 VDD pfet_03v3 ad=1.325p pd=5.53u as=1.325p ps=5.53u w=5u l=0.28u
X169 a_4809_11960.t5 a_4409_13109.t20 VDD VDD pfet_03v3 ad=1.325p pd=5.53u as=1.325p ps=5.53u w=5u l=0.28u
X170 VDD a_4409_13109.t85 VR.t75 VDD pfet_03v3 ad=2.225p pd=10.89u as=1.325p ps=5.53u w=5u l=0.28u
X171 VR.t177 a_22469_13109.t25 a_4809_11960.t2 VDD pfet_03v3 ad=1.325p pd=5.53u as=1.325p ps=5.53u w=5u l=0.28u
X172 a_4809_11960.t8 a_4409_13109.t50 VDD VDD pfet_03v3 ad=1.325p pd=5.53u as=1.325p ps=5.53u w=5u l=0.28u
X173 VDD a_4409_13109.t115 VR.t161 VDD pfet_03v3 ad=1.325p pd=5.53u as=1.325p ps=5.53u w=5u l=0.28u
X174 VR.t160 a_4409_13109.t144 VDD VDD pfet_03v3 ad=1.325p pd=5.53u as=1.325p ps=5.53u w=5u l=0.28u
X175 VSS a_9849_56859# a_9849_52239# VSS nfet_03v3 ad=1.06p pd=4.53u as=1.06p ps=4.53u w=4u l=0.28u
X176 VR.t18 a_22469_13109.t5 a_4809_11960.t2 VDD pfet_03v3 ad=1.325p pd=5.53u as=1.325p ps=5.53u w=5u l=0.28u
X177 a_4809_11960.t20 a_4409_13109.t70 VDD VDD pfet_03v3 ad=1.325p pd=5.53u as=1.325p ps=5.53u w=5u l=0.28u
X178 VR.t226 VSS cap_mim_2f0_m4m5_noshield c_width=5u c_length=5u
X179 VR.t226 VSS cap_mim_2f0_m4m5_noshield c_width=5u c_length=5u
X180 VDD a_4409_13109.t103 a_4809_11960.t6 VDD pfet_03v3 ad=1.325p pd=5.53u as=1.325p ps=5.53u w=5u l=0.28u
X181 a_8697_11960# a_4409_13109.t130 VDD VDD pfet_03v3 ad=1.325p pd=5.53u as=1.325p ps=5.53u w=5u l=0.28u
X182 a_4809_11960.t2 a_22469_13109.t28 VR.t211 VDD pfet_03v3 ad=1.325p pd=5.53u as=1.325p ps=5.53u w=5u l=0.28u
X183 VDD a_4409_13109.t29 VR.t76 VDD pfet_03v3 ad=1.325p pd=5.53u as=1.325p ps=5.53u w=5u l=0.28u
X184 a_4809_11960.t13 a_4409_13109.t56 VDD VDD pfet_03v3 ad=1.325p pd=5.53u as=1.325p ps=5.53u w=5u l=0.28u
X185 VR.t64 a_15609_57629# a_9449_57629# VR.t63 pfet_03v3 ad=1.335p pd=6.89u as=0.795p ps=3.53u w=3u l=0.28u
X186 a_4809_11960.t1 a_22469_13109.t48 VR.t198 VDD pfet_03v3 ad=1.325p pd=5.53u as=1.325p ps=5.53u w=5u l=0.28u
X187 VDD a_4409_13109.t89 VR.t140 VDD pfet_03v3 ad=1.325p pd=5.53u as=1.325p ps=5.53u w=5u l=0.28u
X188 a_4809_11960.t2 a_22469_13109.t14 VR.t181 VDD pfet_03v3 ad=1.325p pd=5.53u as=1.325p ps=5.53u w=5u l=0.28u
X189 VSS a_9773_52029# a_9849_52239# VSS nfet_03v3 ad=1.78p pd=8.89u as=1.06p ps=4.53u w=4u l=0.28u
X190 VDD a_4409_13109.t41 a_4809_11960.t14 VDD pfet_03v3 ad=1.325p pd=5.53u as=1.325p ps=5.53u w=5u l=0.28u
X191 VR.t149 a_4409_13109.t68 VDD VDD pfet_03v3 ad=1.325p pd=5.53u as=1.325p ps=5.53u w=5u l=0.28u
X192 VR.t154 a_4409_13109.t106 VDD VDD pfet_03v3 ad=1.325p pd=5.53u as=1.325p ps=5.53u w=5u l=0.28u
X193 VDD a_4409_13109.t133 a_4809_11960.t18 VDD pfet_03v3 ad=1.325p pd=5.53u as=1.325p ps=5.53u w=5u l=0.28u
X194 a_4809_11960.t1 a_22469_13109.t34 VR.t196 VDD pfet_03v3 ad=2.225p pd=10.89u as=1.325p ps=5.53u w=5u l=0.28u
X195 VDD a_4409_13109.t59 VR.t150 VDD pfet_03v3 ad=1.325p pd=5.53u as=1.325p ps=5.53u w=5u l=0.28u
X196 a_9773_56649# a_15933_56649# VR.t171 VR.t170 pfet_03v3 ad=0.795p pd=3.53u as=0.795p ps=3.53u w=3u l=0.28u
X197 a_8697_11960# a_18269_13109# VR.t222 VDD pfet_03v3 ad=1.325p pd=5.53u as=1.325p ps=5.53u w=5u l=0.28u
X198 VDD a_4409_13109.t27 a_4809_11960.t30 VDD pfet_03v3 ad=1.325p pd=5.53u as=1.325p ps=5.53u w=5u l=0.28u
X199 a_4809_11960.t15 a_4409_13109.t92 VDD VDD pfet_03v3 ad=1.325p pd=5.53u as=1.325p ps=5.53u w=5u l=0.28u
X200 a_17080_77900# a_13025_65300# VSS VSS nfet_03v3 ad=0.89p pd=4.89u as=0.89p ps=4.89u w=2u l=0.28u
X201 a_4809_11960.t2 a_22469_13109.t32 VR.t174 VDD pfet_03v3 ad=1.325p pd=5.53u as=1.325p ps=5.53u w=5u l=0.28u
X202 a_9525_52239# a_9449_53149# VSS VSS nfet_03v3 ad=1.06p pd=4.53u as=1.78p ps=8.89u w=4u l=0.28u
X203 VR.t199 a_22469_13109.t57 a_4809_11960.t1 VDD pfet_03v3 ad=1.325p pd=5.53u as=1.325p ps=5.53u w=5u l=0.28u
X204 VR.t16 a_4409_13109.t18 VDD VDD pfet_03v3 ad=1.325p pd=5.53u as=1.325p ps=5.53u w=5u l=0.28u
X205 a_25065_30860# a_17107_27249# VR.t116 VR.t115 pfet_03v3 ad=1.78p pd=8.89u as=1.78p ps=8.89u w=4u l=0.28u
X206 a_4809_11960.t34 a_4409_13109.t122 VDD VDD pfet_03v3 ad=1.325p pd=5.53u as=1.325p ps=5.53u w=5u l=0.28u
X207 VR.t226 VSS cap_mim_2f0_m4m5_noshield c_width=5u c_length=5u
X208 VR.t182 a_22469_13109.t37 a_4809_11960.t1 VDD pfet_03v3 ad=1.325p pd=5.53u as=1.325p ps=5.53u w=5u l=0.28u
X209 a_4809_11960.t7 a_4409_13109.t48 VDD VDD pfet_03v3 ad=1.325p pd=5.53u as=1.325p ps=5.53u w=5u l=0.28u
X210 VDD a_4409_13109.t77 a_4809_11960.t29 VDD pfet_03v3 ad=1.325p pd=5.53u as=1.325p ps=5.53u w=5u l=0.28u
X211 a_9773_56649# a_9449_57629# VR.t5 VR.t4 pfet_03v3 ad=0.89p pd=4.89u as=0.89p ps=4.89u w=2u l=0.28u
X212 a_4809_11960.t21 a_4409_13109.t142 VDD VDD pfet_03v3 ad=1.325p pd=5.53u as=1.325p ps=5.53u w=5u l=0.28u
X213 VSS a_9525_52239# a_22169_56859# VSS nfet_03v3 ad=1.78p pd=8.89u as=1.06p ps=4.53u w=4u l=0.28u
X214 VR.t53 a_22469_13109.t3 a_4809_11960.t2 VDD pfet_03v3 ad=1.325p pd=5.53u as=1.325p ps=5.53u w=5u l=0.28u
X215 a_9849_52239# a_9849_56859# VR.t106 VR.t105 pfet_03v3 ad=0.795p pd=3.53u as=1.335p ps=6.89u w=3u l=0.28u
X216 a_4809_11960.t0 a_22469_13109.t60 VR.t0 VDD pfet_03v3 ad=1.325p pd=5.53u as=1.325p ps=5.53u w=5u l=0.28u
X217 a_4809_11960.t19 a_4409_13109.t36 VDD VDD pfet_03v3 ad=1.325p pd=5.53u as=1.325p ps=5.53u w=5u l=0.28u
X218 VDD a_4409_13109.t63 VR.t145 VDD pfet_03v3 ad=1.325p pd=5.53u as=1.325p ps=5.53u w=5u l=0.28u
X219 VDD a_4409_13109.t101 VR.t159 VDD pfet_03v3 ad=1.325p pd=5.53u as=1.325p ps=5.53u w=5u l=0.28u
X220 a_9849_56859# a_9773_56649# VSS VSS nfet_03v3 ad=1.06p pd=4.53u as=1.06p ps=4.53u w=4u l=0.28u
X221 a_4809_11960.t28 a_4409_13109.t128 VDD VDD pfet_03v3 ad=1.325p pd=5.53u as=1.325p ps=5.53u w=5u l=0.28u
X222 VDD a_4409_13109.t51 a_8697_11960# VDD pfet_03v3 ad=1.325p pd=5.53u as=1.325p ps=5.53u w=5u l=0.28u
X223 VR.t101 a_4409_13109.t80 VDD VDD pfet_03v3 ad=1.325p pd=5.53u as=1.325p ps=5.53u w=5u l=0.28u
X224 a_25065_27002# a_18787_27249# VSS VSS nfet_03v3 ad=0.445p pd=2.89u as=0.445p ps=2.89u w=1u l=0.28u
X225 a_9849_52239# a_9849_56859# VSS VSS nfet_03v3 ad=1.06p pd=4.53u as=1.78p ps=8.89u w=4u l=0.28u
X226 VR.t178 a_22469_13109.t21 a_4809_11960.t2 VDD pfet_03v3 ad=1.325p pd=5.53u as=1.325p ps=5.53u w=5u l=0.28u
X227 a_4809_11960.t1 a_22469_13109.t46 VR.t206 VDD pfet_03v3 ad=1.325p pd=5.53u as=1.325p ps=5.53u w=5u l=0.28u
X228 VDD a_4409_13109.t113 a_4809_11960.t31 VDD pfet_03v3 ad=1.325p pd=5.53u as=1.325p ps=5.53u w=5u l=0.28u
X229 VR.t157 a_4409_13109.t140 VDD VDD pfet_03v3 ad=1.325p pd=5.53u as=1.325p ps=5.53u w=5u l=0.28u
X230 VDD a_4409_13109.t39 a_8697_11960# VDD pfet_03v3 ad=1.325p pd=5.53u as=1.325p ps=5.53u w=5u l=0.28u
X231 a_40745_27002# a_9449_53149# VR.t152 VR.t151 pfet_03v3 ad=0.89p pd=4.89u as=0.89p ps=4.89u w=2u l=0.28u
X232 a_4809_11960.t24 a_4409_13109.t66 VDD VDD pfet_03v3 ad=1.325p pd=5.53u as=1.325p ps=5.53u w=5u l=0.28u
X233 VDD a_4409_13109.t131 VR.t153 VDD pfet_03v3 ad=1.325p pd=5.53u as=1.325p ps=5.53u w=5u l=0.28u
X234 a_25065_78242# a_13025_65300# VSS VSS nfet_03v3 ad=0.445p pd=2.89u as=0.445p ps=2.89u w=1u l=0.28u
X235 VR.t17 a_22469_13109.t7 a_4809_11960.t2 VDD pfet_03v3 ad=1.325p pd=5.53u as=1.325p ps=5.53u w=5u l=0.28u
X236 a_28740_3486# a_27900_1364# VSS ppolyf_u_1k r_width=1u r_length=10u
X237 VR.t219 a_18269_13109# a_8697_11960# VDD pfet_03v3 ad=1.325p pd=5.53u as=1.325p ps=5.53u w=5u l=0.28u
X238 VDD a_4409_13109.t99 a_4809_11960.t27 VDD pfet_03v3 ad=1.325p pd=5.53u as=1.325p ps=5.53u w=5u l=0.28u
X239 a_22169_56859# a_9525_52239# VR.t124 VR.t123 pfet_03v3 ad=0.795p pd=3.53u as=0.795p ps=3.53u w=3u l=0.28u
X240 a_9849_56859# a_9525_52239# VR.t122 VR.t121 pfet_03v3 ad=0.89p pd=4.89u as=0.89p ps=4.89u w=2u l=0.28u
X241 a_4809_11960.t1 a_22469_13109.t64 VR.t208 VDD pfet_03v3 ad=1.325p pd=5.53u as=1.325p ps=5.53u w=5u l=0.28u
X242 VDD a_4409_13109.t25 VR.t158 VDD pfet_03v3 ad=1.325p pd=5.53u as=1.325p ps=5.53u w=5u l=0.28u
X243 VR.t102 a_4409_13109.t54 VDD VDD pfet_03v3 ad=1.325p pd=5.53u as=1.325p ps=5.53u w=5u l=0.28u
X244 VR.t140 a_4409_13109.t90 VDD VDD pfet_03v3 ad=1.325p pd=5.53u as=1.325p ps=5.53u w=5u l=0.28u
X245 a_4809_11960.t2 a_22469_13109.t30 VR.t214 VDD pfet_03v3 ad=1.325p pd=5.53u as=1.325p ps=5.53u w=5u l=0.28u
X246 a_4809_11960.t32 a_4409_13109.t120 VDD VDD pfet_03v3 ad=1.325p pd=5.53u as=1.325p ps=5.53u w=5u l=0.28u
X247 VDD a_4409_13109.t149 a_4809_11960.t33 VDD pfet_03v3 ad=1.325p pd=5.53u as=1.325p ps=5.53u w=5u l=0.28u
X248 a_22469_13109.t1 B1 VDD VDD pfet_03v3 ad=0.89p pd=4.89u as=0.89p ps=4.89u w=2u l=0.28u
X249 a_4809_11960.t2 a_22469_13109.t10 VR.t175 VDD pfet_03v3 ad=1.325p pd=5.53u as=1.325p ps=5.53u w=5u l=0.28u
X250 VR.t196 a_22469_13109.t35 a_4809_11960.t1 VDD pfet_03v3 ad=1.325p pd=5.53u as=1.325p ps=5.53u w=5u l=0.28u
X251 VDD a_4409_13109.t75 VR.t77 VDD pfet_03v3 ad=1.325p pd=5.53u as=1.325p ps=5.53u w=5u l=0.28u
X252 VR.t226 VSS cap_mim_2f0_m4m5_noshield c_width=5u c_length=5u
X253 a_4809_11960.t30 a_4409_13109.t28 VDD VDD pfet_03v3 ad=1.325p pd=5.53u as=1.325p ps=5.53u w=5u l=0.28u
X254 VDD a_4409_13109.t55 a_4809_11960.t13 VDD pfet_03v3 ad=1.325p pd=5.53u as=1.325p ps=5.53u w=5u l=0.28u
X255 a_4809_11960.t23 a_4409_13109.t108 VDD VDD pfet_03v3 ad=1.325p pd=5.53u as=1.325p ps=5.53u w=5u l=0.28u
X256 VDD a_4409_13109.t135 VR.t54 VDD pfet_03v3 ad=1.325p pd=5.53u as=1.325p ps=5.53u w=5u l=0.28u
X257 VR.t174 a_22469_13109.t33 a_4809_11960.t2 VDD pfet_03v3 ad=1.325p pd=5.53u as=2.225p ps=10.89u w=5u l=0.28u
X258 VDD a_4409_13109.t123 a_8697_11960# VDD pfet_03v3 ad=1.325p pd=5.53u as=1.325p ps=5.53u w=5u l=0.28u
X259 VR.t31 a_4409_13109.t152 VDD VDD pfet_03v3 ad=1.325p pd=5.53u as=1.325p ps=5.53u w=5u l=0.28u
X260 a_9773_56649# a_15933_56649# VR.t163 VR.t162 pfet_03v3 ad=0.795p pd=3.53u as=0.795p ps=3.53u w=3u l=0.28u
X261 VR.t213 a_22469_13109.t53 a_4809_11960.t1 VDD pfet_03v3 ad=1.325p pd=5.53u as=1.325p ps=5.53u w=5u l=0.28u
X262 VR.t32 a_4409_13109.t14 VDD VDD pfet_03v3 ad=1.325p pd=5.53u as=1.325p ps=5.53u w=5u l=0.28u
X263 VR.t114 a_9849_56859# a_9849_52239# VR.t113 pfet_03v3 ad=1.335p pd=6.89u as=0.795p ps=3.53u w=3u l=0.28u
X264 VR.t3 a_22469_13109.t19 a_4809_11960.t2 VDD pfet_03v3 ad=1.325p pd=5.53u as=1.325p ps=5.53u w=5u l=0.28u
X265 a_30420_3486# a_29580_1364# VSS ppolyf_u_1k r_width=1u r_length=10u
X266 VR.t91 a_4409_13109.t44 VDD VDD pfet_03v3 ad=1.325p pd=5.53u as=1.325p ps=5.53u w=5u l=0.28u
X267 VDD a_4409_13109.t73 a_4809_11960.t12 VDD pfet_03v3 ad=1.325p pd=5.53u as=1.325p ps=5.53u w=5u l=0.28u
X268 VDD a_4409_13109.t111 a_8697_11960# VDD pfet_03v3 ad=1.325p pd=5.53u as=1.325p ps=5.53u w=5u l=0.28u
X269 a_4809_11960.t4 a_4409_13109.t138 VDD VDD pfet_03v3 ad=1.325p pd=5.53u as=1.325p ps=5.53u w=5u l=0.28u
X270 a_32100_3486# a_32940_1364# VSS ppolyf_u_1k r_width=1u r_length=10u
X271 VR.t147 a_22469_13109.t39 a_4809_11960.t1 VDD pfet_03v3 ad=1.325p pd=5.53u as=1.325p ps=5.53u w=5u l=0.28u
X272 VR.t145 a_4409_13109.t64 VDD VDD pfet_03v3 ad=1.325p pd=5.53u as=1.325p ps=5.53u w=5u l=0.28u
X273 VR.t220 a_18269_13109# a_8697_11960# VDD pfet_03v3 ad=1.325p pd=5.53u as=1.325p ps=5.53u w=5u l=0.28u
X274 a_4809_11960.t9 a_4409_13109.t32 VDD VDD pfet_03v3 ad=1.325p pd=5.53u as=1.325p ps=5.53u w=5u l=0.28u
X275 a_22169_56859# a_9525_52239# VR.t128 VR.t127 pfet_03v3 ad=0.795p pd=3.53u as=0.795p ps=3.53u w=3u l=0.28u
X276 VDD a_4409_13109.t97 VR.t131 VDD pfet_03v3 ad=1.325p pd=5.53u as=1.325p ps=5.53u w=5u l=0.28u
X277 VR.t146 a_4409_13109.t126 VDD VDD pfet_03v3 ad=1.325p pd=5.53u as=1.325p ps=5.53u w=5u l=0.28u
X278 VR.t226 VSS cap_mim_2f0_m4m5_noshield c_width=5u c_length=5u
X279 a_4809_11960.t1 a_22469_13109.t62 VR.t43 VDD pfet_03v3 ad=1.325p pd=5.53u as=1.325p ps=5.53u w=5u l=0.28u
X280 VDD a_4409_13109.t23 a_4809_11960.t26 VDD pfet_03v3 ad=1.325p pd=5.53u as=1.325p ps=5.53u w=5u l=0.28u
X281 a_8697_11960# a_4409_13109.t52 VDD VDD pfet_03v3 ad=1.325p pd=5.53u as=1.325p ps=5.53u w=5u l=0.28u
X282 a_4809_11960.t1 a_22469_13109.t42 VR.t180 VDD pfet_03v3 ad=1.325p pd=5.53u as=1.325p ps=5.53u w=5u l=0.28u
X283 a_4809_11960.t25 a_4409_13109.t82 VDD VDD pfet_03v3 ad=1.325p pd=5.53u as=1.325p ps=5.53u w=5u l=0.28u
X284 VDD a_4409_13109.t147 VR.t143 VDD pfet_03v3 ad=1.325p pd=5.53u as=1.325p ps=5.53u w=5u l=0.28u
X285 a_4809_11960.t2 a_22469_13109.t8 VR.t1 VDD pfet_03v3 ad=1.325p pd=5.53u as=1.325p ps=5.53u w=5u l=0.28u
X286 VDD a_4409_13109.t35 a_4809_11960.t19 VDD pfet_03v3 ad=1.325p pd=5.53u as=1.325p ps=5.53u w=5u l=0.28u
X287 a_4809_11960.t27 a_4409_13109.t100 VDD VDD pfet_03v3 ad=1.325p pd=5.53u as=1.325p ps=5.53u w=5u l=0.28u
X288 VDD a_4409_13109.t127 a_4809_11960.t28 VDD pfet_03v3 ad=1.325p pd=5.53u as=1.325p ps=5.53u w=5u l=0.28u
X289 VR.t208 a_22469_13109.t65 a_4809_11960.t1 VDD pfet_03v3 ad=1.325p pd=5.53u as=2.225p ps=10.89u w=5u l=0.28u
X290 a_8697_11960# a_18269_13109# VR.t223 VDD pfet_03v3 ad=1.325p pd=5.53u as=1.325p ps=5.53u w=5u l=0.28u
X291 a_9449_53149# a_17225_26660# VSS VSS nfet_03v3 ad=0.445p pd=2.89u as=0.445p ps=2.89u w=1u l=0.28u
X292 VR.t75 a_4409_13109.t86 VDD VDD pfet_03v3 ad=1.325p pd=5.53u as=1.325p ps=5.53u w=5u l=0.28u
X293 a_4809_11960.t2 a_22469_13109.t26 VR.t212 VDD pfet_03v3 ad=1.325p pd=5.53u as=1.325p ps=5.53u w=5u l=0.28u
X294 VR.t209 a_22469_13109.t51 a_4809_11960.t1 VDD pfet_03v3 ad=1.325p pd=5.53u as=1.325p ps=5.53u w=5u l=0.28u
X295 VR.t161 a_4409_13109.t116 VDD VDD pfet_03v3 ad=1.325p pd=5.53u as=1.325p ps=5.53u w=5u l=0.28u
X296 VDD a_4409_13109.t145 a_4809_11960.t16 VDD pfet_03v3 ad=1.325p pd=5.53u as=1.325p ps=5.53u w=5u l=0.28u
X297 a_4409_13109.t9 a_4409_13109.t8 VDD VDD pfet_03v3 ad=1.325p pd=5.53u as=1.325p ps=5.53u w=5u l=0.28u
X298 VDD a_4409_13109.t71 VR.t156 VDD pfet_03v3 ad=1.325p pd=5.53u as=1.325p ps=5.53u w=5u l=0.28u
X299 VR.t54 a_4409_13109.t136 VDD VDD pfet_03v3 ad=1.325p pd=5.53u as=1.325p ps=5.53u w=5u l=0.28u
X300 a_32905_77900# a_25065_27002# VR.t133 VR.t132 pfet_03v3 ad=0.89p pd=4.89u as=0.89p ps=4.89u w=2u l=0.28u
X301 a_4809_11960.t6 a_4409_13109.t104 VDD VDD pfet_03v3 ad=1.325p pd=5.53u as=1.325p ps=5.53u w=5u l=0.28u
X302 VR.t226 VSS cap_mim_2f0_m4m5_noshield c_width=5u c_length=5u
X303 VR.t211 a_22469_13109.t29 a_4809_11960.t2 VDD pfet_03v3 ad=1.325p pd=5.53u as=1.325p ps=5.53u w=5u l=0.28u
X304 VR.t76 a_4409_13109.t30 VDD VDD pfet_03v3 ad=1.325p pd=5.53u as=1.325p ps=5.53u w=5u l=0.28u
X305 VDD a_4409_13109.t57 a_8697_11960# VDD pfet_03v3 ad=1.325p pd=5.53u as=1.325p ps=5.53u w=5u l=0.28u
X306 VDD a_4409_13109.t95 a_4809_11960.t10 VDD pfet_03v3 ad=1.325p pd=5.53u as=1.325p ps=5.53u w=5u l=0.28u
X307 a_8697_11960# a_4409_13109.t124 VDD VDD pfet_03v3 ad=1.325p pd=5.53u as=1.325p ps=5.53u w=5u l=0.28u
X308 a_9449_57629# a_15609_57629# VR.t62 VR.t61 pfet_03v3 ad=0.795p pd=3.53u as=0.795p ps=3.53u w=3u l=0.28u
X309 a_4809_11960.t12 a_4409_13109.t74 VDD VDD pfet_03v3 ad=1.325p pd=5.53u as=1.325p ps=5.53u w=5u l=0.28u
X310 a_4809_11960.t17 a_4409_13109.t154 VDD VDD pfet_03v3 ad=1.325p pd=5.53u as=1.325p ps=5.53u w=5u l=0.28u
X311 VR.t181 a_22469_13109.t15 a_4809_11960.t2 VDD pfet_03v3 ad=1.325p pd=5.53u as=1.325p ps=5.53u w=5u l=0.28u
X312 VR.t226 VSS cap_mim_2f0_m4m5_noshield c_width=5u c_length=5u
X313 a_4809_11960.t1 a_22469_13109.t40 VR.t197 VDD pfet_03v3 ad=1.325p pd=5.53u as=1.325p ps=5.53u w=5u l=0.28u
X314 VDD a_4409_13109.t107 a_4809_11960.t23 VDD pfet_03v3 ad=1.325p pd=5.53u as=1.325p ps=5.53u w=5u l=0.28u
X315 VDD a_4409_13109.t33 VR.t142 VDD pfet_03v3 ad=1.325p pd=5.53u as=1.325p ps=5.53u w=5u l=0.28u
X316 VR.t150 a_4409_13109.t60 VDD VDD pfet_03v3 ad=1.325p pd=5.53u as=1.325p ps=5.53u w=5u l=0.28u
X317 VR.t169 a_15933_56649# a_9773_56649# VR.t168 pfet_03v3 ad=0.795p pd=3.53u as=0.795p ps=3.53u w=3u l=0.28u
X318 a_9525_52239# a_9849_56859# VSS VSS nfet_03v3 ad=0.445p pd=2.89u as=0.445p ps=2.89u w=1u l=0.28u
X319 a_4809_11960.t1 a_22469_13109.t58 VR.t52 VDD pfet_03v3 ad=1.325p pd=5.53u as=1.325p ps=5.53u w=5u l=0.28u
X320 a_8697_11960# a_18269_13109# VR.t224 VDD pfet_03v3 ad=1.325p pd=5.53u as=1.325p ps=5.53u w=5u l=0.28u
X321 VDD a_4409_13109.t19 a_4809_11960.t5 VDD pfet_03v3 ad=1.325p pd=5.53u as=1.325p ps=5.53u w=5u l=0.28u
X322 a_4809_11960.t2 a_22469_13109.t24 VR.t177 VDD pfet_03v3 ad=1.325p pd=5.53u as=1.325p ps=5.53u w=5u l=0.28u
X323 VDD a_4409_13109.t49 a_4809_11960.t8 VDD pfet_03v3 ad=1.325p pd=5.53u as=1.325p ps=5.53u w=5u l=0.28u
X324 a_4809_11960.t29 a_4409_13109.t78 VDD VDD pfet_03v3 ad=1.325p pd=5.53u as=1.325p ps=5.53u w=5u l=0.28u
X325 a_4409_13109.t1 a_4409_13109.t3 VDD VDD pfet_03v3 ad=1.325p pd=5.53u as=1.325p ps=5.53u w=5u l=0.28u
X326 VDD a_4409_13109.t143 VR.t160 VDD pfet_03v3 ad=1.325p pd=5.53u as=1.325p ps=5.53u w=5u l=0.28u
X327 VDD a_4409_13109.t69 a_4809_11960.t20 VDD pfet_03v3 ad=1.325p pd=5.53u as=1.325p ps=5.53u w=5u l=0.28u
X328 VR.t0 a_22469_13109.t61 a_4809_11960.t1 VDD pfet_03v3 ad=1.325p pd=5.53u as=1.325p ps=5.53u w=5u l=0.28u
X329 VR.t159 a_4409_13109.t102 VDD VDD pfet_03v3 ad=1.325p pd=5.53u as=1.325p ps=5.53u w=5u l=0.28u
X330 VDD a_4409_13109.t129 a_8697_11960# VDD pfet_03v3 ad=1.325p pd=5.53u as=1.325p ps=5.53u w=5u l=0.28u
X331 VSS a_15609_57629# a_9449_57629# VSS nfet_03v3 ad=1.06p pd=4.53u as=1.06p ps=4.53u w=4u l=0.28u
X332 VR.t47 a_3709_78629# LOQP VR.t46 pfet_03v3 ad=0.795p pd=3.53u as=0.795p ps=3.53u w=3u l=0.28u
X333 a_4809_11960.t16 a_4409_13109.t146 VDD VDD pfet_03v3 ad=1.325p pd=5.53u as=1.325p ps=5.53u w=5u l=0.28u
X334 a_17225_77900# a_17107_78489# a_17080_77900# VSS nfet_03v3 ad=0.89p pd=4.89u as=0.89p ps=4.89u w=2u l=0.28u
X335 VR.t206 a_22469_13109.t47 a_4809_11960.t1 VDD pfet_03v3 ad=1.325p pd=5.53u as=1.325p ps=5.53u w=5u l=0.28u
X336 VR.t148 a_22469_13109.t13 a_4809_11960.t2 VDD pfet_03v3 ad=1.325p pd=5.53u as=1.325p ps=5.53u w=5u l=0.28u
X337 VR.t226 VSS cap_mim_2f0_m4m5_noshield c_width=5u c_length=5u
X338 a_8697_11960# a_4409_13109.t40 VDD VDD pfet_03v3 ad=1.325p pd=5.53u as=1.325p ps=5.53u w=5u l=0.28u
X339 VDD a_4409_13109.t105 VR.t154 VDD pfet_03v3 ad=1.325p pd=5.53u as=1.325p ps=5.53u w=5u l=0.28u
X340 VR.t153 a_4409_13109.t132 VDD VDD pfet_03v3 ad=1.325p pd=5.53u as=1.325p ps=5.53u w=5u l=0.28u
X341 a_17107_27249# a_22169_56859# VR.t187 VR.t186 pfet_03v3 ad=1.78p pd=8.89u as=1.78p ps=8.89u w=4u l=0.28u
X342 LOQN a_10429_78629# VR.t98 VR.t97 pfet_03v3 ad=0.795p pd=3.53u as=0.795p ps=3.53u w=3u l=0.28u
X343 VR.t173 a_15933_56649# a_9773_56649# VR.t172 pfet_03v3 ad=0.795p pd=3.53u as=0.795p ps=3.53u w=3u l=0.28u
X344 VR.t223 a_18269_13109# a_8697_11960# VDD pfet_03v3 ad=1.325p pd=5.53u as=1.325p ps=5.53u w=5u l=0.28u
X345 VDD a_4409_13109.t91 a_4809_11960.t15 VDD pfet_03v3 ad=1.325p pd=5.53u as=1.325p ps=5.53u w=5u l=0.28u
X346 VR.t214 a_22469_13109.t31 a_4809_11960.t2 VDD pfet_03v3 ad=1.325p pd=5.53u as=1.325p ps=5.53u w=5u l=0.28u
X347 a_4809_11960.t1 a_22469_13109.t56 VR.t199 VDD pfet_03v3 ad=1.325p pd=5.53u as=1.325p ps=5.53u w=5u l=0.28u
X348 VDD a_4409_13109.t121 a_4809_11960.t34 VDD pfet_03v3 ad=1.325p pd=5.53u as=1.325p ps=5.53u w=5u l=0.28u
X349 a_4809_11960.t33 a_4409_13109.t150 VDD VDD pfet_03v3 ad=1.325p pd=5.53u as=1.325p ps=5.53u w=5u l=0.28u
X350 a_21840_1180# VCTRL a_4409_13109.t11 VSS nfet_03v3 ad=1.325p pd=5.53u as=1.325p ps=5.53u w=5u l=0.5u
X351 VDD a_4409_13109.t47 a_4809_11960.t7 VDD pfet_03v3 ad=1.325p pd=5.53u as=1.325p ps=5.53u w=5u l=0.28u
X352 VR.t77 a_4409_13109.t76 VDD VDD pfet_03v3 ad=1.325p pd=5.53u as=1.325p ps=5.53u w=5u l=0.28u
X353 VDD a_4409_13109.t141 a_4809_11960.t21 VDD pfet_03v3 ad=1.325p pd=5.53u as=1.325p ps=5.53u w=5u l=0.28u
X354 VR.t226 VSS cap_mim_2f0_m4m5_noshield c_width=5u c_length=5u
X355 a_9525_52239# a_9849_56859# VR.t110 VR.t109 pfet_03v3 ad=0.89p pd=4.89u as=0.89p ps=4.89u w=2u l=0.28u
X356 VSS a_15933_56649# a_9773_56649# VSS nfet_03v3 ad=1.78p pd=8.89u as=1.06p ps=4.53u w=4u l=0.28u
X357 a_9849_56859# a_9773_56649# VR.t22 VR.t21 pfet_03v3 ad=0.795p pd=3.53u as=0.795p ps=3.53u w=3u l=0.28u
X358 a_32100_3486# a_31260_1364# VSS ppolyf_u_1k r_width=1u r_length=10u
X359 VDD a_4409_13109.t79 VR.t101 VDD pfet_03v3 ad=1.325p pd=5.53u as=1.325p ps=5.53u w=5u l=0.28u
X360 a_33780_3486# a_25065_27002# VSS ppolyf_u_1k r_width=1u r_length=10u
X361 VR.t210 a_22469_13109.t45 a_4809_11960.t1 VDD pfet_03v3 ad=1.325p pd=5.53u as=1.325p ps=5.53u w=5u l=0.28u
X362 a_8697_11960# a_4409_13109.t112 VDD VDD pfet_03v3 ad=1.325p pd=5.53u as=1.325p ps=5.53u w=5u l=0.28u
X363 VR.t183 a_4409_13109.t38 VDD VDD pfet_03v3 ad=1.325p pd=5.53u as=1.325p ps=5.53u w=5u l=0.28u
X364 VDD a_4409_13109.t65 a_4809_11960.t24 VDD pfet_03v3 ad=1.325p pd=5.53u as=1.325p ps=5.53u w=5u l=0.28u
X365 a_17080_26660# a_18787_27249# VSS VSS nfet_03v3 ad=0.89p pd=4.89u as=0.89p ps=4.89u w=2u l=0.28u
X366 a_27060_3486# a_27060_1364# VSS ppolyf_u_1k r_width=1u r_length=10u
X367 VR.t179 a_22469_13109.t23 a_4809_11960.t2 VDD pfet_03v3 ad=1.325p pd=5.53u as=1.325p ps=5.53u w=5u l=0.28u
X368 VR.t226 VSS cap_mim_2f0_m4m5_noshield c_width=5u c_length=5u
X369 VR.t43 a_22469_13109.t63 a_4809_11960.t1 VDD pfet_03v3 ad=1.325p pd=5.53u as=1.325p ps=5.53u w=5u l=0.28u
X370 a_28740_3486# a_29580_1364# VSS ppolyf_u_1k r_width=1u r_length=10u
X371 VDD a_4409_13109.t119 a_4809_11960.t32 VDD pfet_03v3 ad=1.325p pd=5.53u as=1.325p ps=5.53u w=5u l=0.28u
X372 VR.t143 a_4409_13109.t148 VDD VDD pfet_03v3 ad=1.325p pd=5.53u as=1.325p ps=5.53u w=5u l=0.28u
X373 LOQP a_3709_78629# VR.t49 VR.t48 pfet_03v3 ad=0.795p pd=3.53u as=0.795p ps=3.53u w=3u l=0.28u
X374 VR.t226 VSS cap_mim_2f0_m4m5_noshield c_width=5u c_length=5u
X375 VR.t226 VSS cap_mim_2f0_m4m5_noshield c_width=5u c_length=5u
X376 a_32760_77900# a_27060_1364# VSS VSS nfet_03v3 ad=0.89p pd=4.89u as=0.89p ps=4.89u w=2u l=0.28u
X377 VDD a_4409_13109.t151 VR.t31 VDD pfet_03v3 ad=1.325p pd=5.53u as=1.325p ps=5.53u w=5u l=0.28u
X378 a_21840_1180# VSS VSS ppolyf_u_1k r_width=2u r_length=4u
X379 a_4809_11960.t2 a_22469_13109.t18 VR.t3 VDD pfet_03v3 ad=1.325p pd=5.53u as=1.325p ps=5.53u w=5u l=0.28u
X380 VR.t92 a_4409_13109.t110 VDD VDD pfet_03v3 ad=1.325p pd=5.53u as=1.325p ps=5.53u w=5u l=0.28u
X381 VDD a_4409_13109.t137 a_4809_11960.t4 VDD pfet_03v3 ad=1.325p pd=5.53u as=1.325p ps=5.53u w=5u l=0.28u
X382 a_18787_27249# a_9849_52239# VR.t90 VR.t89 pfet_03v3 ad=1.78p pd=8.89u as=1.78p ps=8.89u w=4u l=0.28u
X383 a_30420_3486# a_31260_1364# VSS ppolyf_u_1k r_width=1u r_length=10u
X384 VR.t195 a_22169_56859# a_15933_56649# VR.t194 pfet_03v3 ad=1.335p pd=6.89u as=0.795p ps=3.53u w=3u l=0.28u
X385 a_9449_57629# a_15609_57629# VR.t56 VR.t55 pfet_03v3 ad=0.795p pd=3.53u as=1.335p ps=6.89u w=3u l=0.28u
X386 a_33780_3486# a_32940_1364# VSS ppolyf_u_1k r_width=1u r_length=10u
X387 VR.t207 a_22469_13109.t55 a_4809_11960.t1 VDD pfet_03v3 ad=1.325p pd=5.53u as=1.325p ps=5.53u w=5u l=0.28u
X388 VDD a_4409_13109.t81 a_4809_11960.t25 VDD pfet_03v3 ad=1.325p pd=5.53u as=1.325p ps=5.53u w=5u l=0.28u
X389 a_9449_53149# a_26640_1364# a_32905_30860# VR.t144 pfet_03v3 ad=1.78p pd=8.89u as=1.78p ps=8.89u w=4u l=0.28u
X390 VR.t224 a_18269_13109# a_8697_11960# VDD pfet_03v3 ad=1.325p pd=5.53u as=1.325p ps=5.53u w=5u l=0.28u
X391 a_27060_1364# VSS cap_mim_2f0_m4m5_noshield c_width=5u c_length=5u
X392 VR.t141 a_4409_13109.t84 VDD VDD pfet_03v3 ad=1.325p pd=5.53u as=2.225p ps=10.89u w=5u l=0.28u
X393 a_4809_11960.t1 a_22469_13109.t50 VR.t209 VDD pfet_03v3 ad=1.325p pd=5.53u as=1.325p ps=5.53u w=5u l=0.28u
X394 a_13025_65300# a_9773_56649# VSS VSS nfet_03v3 ad=0.89p pd=4.89u as=0.89p ps=4.89u w=2u l=0.28u
X395 a_22469_13109.t0 B1 VSS VSS nfet_03v3 ad=0.445p pd=2.89u as=0.445p ps=2.89u w=1u l=0.28u
X396 VDD a_4409_13109.t10 a_4409_13109.t9 VDD pfet_03v3 ad=1.325p pd=5.53u as=1.325p ps=5.53u w=5u l=0.28u
X397 VSS VSS a_9849_56859# VSS nfet_03v3 ad=1.06p pd=4.53u as=1.06p ps=4.53u w=4u l=0.28u
X398 a_25065_78242# a_13025_65300# a_25065_82100# VR.t205 pfet_03v3 ad=1.78p pd=8.89u as=1.78p ps=8.89u w=4u l=0.28u
X399 VR.t226 VSS cap_mim_2f0_m4m5_noshield c_width=5u c_length=5u
X400 a_3709_27389# a_9849_56859# VSS VSS nfet_03v3 ad=0.89p pd=4.89u as=0.89p ps=4.89u w=2u l=0.28u
X401 a_15609_57629# a_15933_56649# VSS VSS nfet_03v3 ad=0.445p pd=2.89u as=0.445p ps=2.89u w=1u l=0.28u
X402 VSS a_3709_78629# LOQP VSS nfet_03v3 ad=1.335p pd=6.89u as=0.795p ps=3.53u w=3u l=0.28u
X403 VDD a_4409_13109.t153 a_4809_11960.t17 VDD pfet_03v3 ad=1.325p pd=5.53u as=1.325p ps=5.53u w=5u l=0.28u
X404 a_22169_56859# a_9849_52239# VR.t82 VR.t81 pfet_03v3 ad=0.89p pd=4.89u as=0.89p ps=4.89u w=2u l=0.28u
X405 VR.t96 a_10429_78629# LOQN VR.t95 pfet_03v3 ad=0.795p pd=3.53u as=0.795p ps=3.53u w=3u l=0.28u
X406 a_9525_52239# a_9449_57629# VSS VSS nfet_03v3 ad=1.06p pd=4.53u as=1.78p ps=8.89u w=4u l=0.28u
X407 VR.t155 a_4409_13109.t156 VDD VDD pfet_03v3 ad=1.325p pd=5.53u as=2.225p ps=10.89u w=5u l=0.28u
X408 VR.t225 a_18269_13109# a_8697_11960# VDD pfet_03v3 ad=1.325p pd=5.53u as=1.325p ps=5.53u w=5u l=0.28u
X409 a_13025_65300# a_9773_56649# VR.t24 VR.t23 pfet_03v3 ad=1.78p pd=8.89u as=1.78p ps=8.89u w=4u l=0.28u
X410 VDD a_4409_13109.t4 a_4409_13109.t1 VDD pfet_03v3 ad=1.325p pd=5.53u as=1.325p ps=5.53u w=5u l=0.28u
X411 VR.t226 VSS cap_mim_2f0_m4m5_noshield c_width=5u c_length=5u
X412 VR.t36 a_3709_27389# LOIP VR.t35 pfet_03v3 ad=0.795p pd=3.53u as=0.795p ps=3.53u w=3u l=0.28u
X413 VSS VSS a_22169_56859# VSS nfet_03v3 ad=1.78p pd=8.89u as=1.06p ps=4.53u w=4u l=0.28u
X414 a_15609_57629# a_9849_52239# VR.t80 VR.t79 pfet_03v3 ad=0.795p pd=3.53u as=0.795p ps=3.53u w=3u l=0.28u
X415 a_9773_56649# a_15933_56649# VSS VSS nfet_03v3 ad=1.06p pd=4.53u as=1.06p ps=4.53u w=4u l=0.28u
X416 VR.t13 a_9449_57629# a_9525_52239# VR.t12 pfet_03v3 ad=0.795p pd=3.53u as=0.795p ps=3.53u w=3u l=0.28u
X417 LOIN a_10429_27389# VR.t72 VR.t71 pfet_03v3 ad=0.795p pd=3.53u as=0.795p ps=3.53u w=3u l=0.28u
X418 VR.t226 VSS cap_mim_2f0_m4m5_noshield c_width=5u c_length=5u
X419 a_9449_57629# a_9773_56649# VSS VSS nfet_03v3 ad=0.445p pd=2.89u as=0.445p ps=2.89u w=1u l=0.28u
X420 VR.t100 a_10429_78629# LOQN VR.t99 pfet_03v3 ad=1.335p pd=6.89u as=0.795p ps=3.53u w=3u l=0.28u
X421 a_8697_11960# a_4409_13109.t46 VDD VDD pfet_03v3 ad=1.325p pd=5.53u as=1.325p ps=5.53u w=5u l=0.28u
X422 a_18269_13109# B0 VDD VDD pfet_03v3 ad=0.89p pd=4.89u as=0.89p ps=4.89u w=2u l=0.28u
X423 LOQN a_10429_78629# VR.t94 VR.t93 pfet_03v3 ad=0.795p pd=3.53u as=1.335p ps=6.89u w=3u l=0.28u
X424 VR.t226 VSS cap_mim_2f0_m4m5_noshield c_width=5u c_length=5u
X425 a_15609_57629# a_9849_52239# VR.t86 VR.t85 pfet_03v3 ad=0.795p pd=3.53u as=0.795p ps=3.53u w=3u l=0.28u
X426 VR.t226 VSS cap_mim_2f0_m4m5_noshield c_width=5u c_length=5u
X427 a_17225_26660# a_17107_27249# a_17080_26660# VSS nfet_03v3 ad=0.89p pd=4.89u as=0.89p ps=4.89u w=2u l=0.28u
X428 VR.t26 a_9773_56649# a_9849_56859# VR.t25 pfet_03v3 ad=0.795p pd=3.53u as=0.795p ps=3.53u w=3u l=0.28u
X429 a_15609_57629# a_15933_56649# VR.t165 VR.t164 pfet_03v3 ad=0.89p pd=4.89u as=0.89p ps=4.89u w=2u l=0.28u
X430 a_21840_1180# VCTRL a_4409_13109.t12 VSS nfet_03v3 ad=2.225p pd=10.89u as=1.325p ps=5.53u w=5u l=0.5u
X431 a_9525_52239# a_9449_57629# VR.t7 VR.t6 pfet_03v3 ad=0.795p pd=3.53u as=1.335p ps=6.89u w=3u l=0.28u
X432 LOIP a_3709_27389# VR.t38 VR.t37 pfet_03v3 ad=0.795p pd=3.53u as=0.795p ps=3.53u w=3u l=0.28u
X433 a_8697_11960# a_4409_13109.t118 VDD VDD pfet_03v3 ad=1.325p pd=5.53u as=1.325p ps=5.53u w=5u l=0.28u
X434 a_26640_1364# VSS cap_mim_2f0_m4m5_noshield c_width=5u c_length=5u
X435 a_4409_13109.t12 VCTRL a_21840_1180# VSS nfet_03v3 ad=1.325p pd=5.53u as=1.325p ps=5.53u w=5u l=0.5u
X436 a_10429_27389# a_9525_52239# VR.t120 VR.t119 pfet_03v3 ad=1.78p pd=8.89u as=1.78p ps=8.89u w=4u l=0.28u
X437 VR.t51 a_3709_78629# LOQP VR.t50 pfet_03v3 ad=1.335p pd=6.89u as=0.795p ps=3.53u w=3u l=0.28u
X438 VR.t226 VSS cap_mim_2f0_m4m5_noshield c_width=5u c_length=5u
X439 a_26640_3486# a_26640_1364# VSS ppolyf_u_1k r_width=1u r_length=10u
C0 a_18269_13109# a_17225_26660# 0.36274f
C1 a_31654_69300# VR 0.60202f
C2 a_27060_1364# a_15933_56649# 0.43237f
C3 a_27060_1364# a_17225_26660# 0.03437f
C4 B0 B1 3.15736f
C5 LOIN VDD 0.23873f
C6 B0 VR 0.10689f
C7 a_17080_26660# a_17107_27249# 0.03269f
C8 a_14154_56560# VR 0.35048f
C9 a_17225_26660# a_18787_27249# 0.58736f
C10 a_25214_78182# a_25065_78242# 0.01511f
C11 a_25214_30800# VR 0.60202f
C12 a_13174_39340# a_3709_27389# 0.02481f
C13 a_27060_1364# a_28740_3486# 0.05175f
C14 a_9773_56649# a_13025_65300# 0.09387f
C15 a_26894_30800# VR 0.58576f
C16 a_9449_53149# a_9773_56649# 0.08075f
C17 a_9849_56859# a_3709_27389# 0.76032f
C18 a_25065_27002# a_26894_26942# 0.01149f
C19 a_9849_52239# a_26064_56560# 0.01076f
C20 a_9449_53149# a_32905_30860# 0.38839f
C21 a_3709_78629# VDD 0.25314f
C22 a_25065_27002# a_26894_30800# 0.04066f
C23 a_16964_77840# a_17080_77900# 0.01998f
C24 a_9449_57629# a_17104_52179# 0.01671f
C25 a_33780_3486# a_33360_3486# 0.1684f
C26 a_25065_30860# VR 0.89698f
C27 a_3709_27389# VDD 0.25314f
C28 a_13025_65300# a_13174_69300# 0.0476f
C29 a_10429_78629# a_17225_77900# 0.15737f
C30 a_15609_57629# a_9773_52029# 0.43741f
C31 a_26484_30800# VR 0.58512f
C32 a_25065_27002# a_32760_77900# 0.02811f
C33 a_25065_27002# a_25065_30860# 0.38839f
C34 a_9449_53149# a_22169_56859# 0.13404f
C35 a_9849_52239# a_24794_56560# 0.0276f
C36 a_25065_27002# a_26484_30800# 0.02019f
C37 a_26484_82040# a_25065_78242# 0.02019f
C38 LOIN a_40745_27002# 0.04359f
C39 a_9849_56859# VR 6.03771f
C40 a_17107_78489# VDD 0.25314f
C41 VCTRL a_26640_1364# 0.12506f
C42 a_9449_53149# a_9849_52239# 0.26957f
C43 B1 VDD 1.16976f
C44 VR VDD 37.1254f
C45 a_9525_52239# VR 5.92211f
C46 a_25065_27002# VDD 1.31292f
C47 a_29160_1364# a_29580_1364# 0.1684f
C48 a_24384_56560# VR 0.36665f
C49 a_16964_26600# a_17225_26660# 0.01291f
C50 a_9449_53149# a_26640_1364# 0.6947f
C51 a_8697_11960# a_20924_11900# 0.0514f
C52 a_13025_65300# LOQN 0.08129f
C53 a_32520_1364# a_31260_1364# 0.01209f
C54 a_11140_82040# VR 0.50376f
C55 a_12400_52179# a_9849_56859# 0.01532f
C56 a_23128_56799# VR 0.49566f
C57 VCTRL a_18269_13109# 0.03851f
C58 a_26640_1364# a_22796_1120# 0.0139f
C59 LOIN a_17107_27249# 0.125f
C60 a_24804_30800# a_17107_27249# 0.01563f
C61 a_16964_30660# a_17225_26660# 0.01168f
C62 VCTRL a_27060_1364# 0.03623f
C63 a_17107_78489# a_17080_77900# 0.03744f
C64 a_3709_78629# LOQP 0.74949f
C65 a_10244_82040# VR 0.50376f
C66 a_8697_11960# LOIP 0.09408f
C67 a_9849_56859# a_15834_52282# 0.01411f
C68 a_3709_27389# LOQP 0.03971f
C69 a_30544_56560# a_15933_56649# 0.01137f
C70 a_40745_27002# VR 0.84414f
C71 a_27060_1364# a_9449_53149# 0.0412f
C72 a_26640_1364# a_21840_1180# 0.45175f
C73 a_37814_18340# VDD 0.3476f
C74 a_25065_82100# a_25214_82040# 0.0476f
C75 a_37404_18340# VDD 0.36569f
C76 a_10429_78629# a_3709_78629# 2.97906f
C77 B0 a_26640_1364# 0.0312f
C78 a_34734_81900# VR 0.35048f
C79 a_9773_56649# a_9849_56859# 0.36423f
C80 a_11504_52179# a_9525_52239# 0.01811f
C81 a_33780_3486# a_17225_26660# 0.0513f
C82 a_19334_39340# a_10429_27389# 0.02481f
C83 a_40484_30800# VR 0.36569f
C84 a_28320_3486# a_27060_3486# 0.01209f
C85 VR LOQP 2.96078f
C86 a_9773_56649# VDD 0.25314f
C87 a_31654_18340# VDD 0.3476f
C88 a_17080_26660# a_17374_26600# 0.01069f
C89 a_34324_81900# VR 0.36374f
C90 a_22169_56859# a_9849_56859# 0.4705f
C91 a_9773_56649# a_9525_52239# 1.29254f
C92 a_25065_27002# LOQP 0.04067f
C93 a_9525_52239# a_15424_52282# 0.01104f
C94 a_28740_3486# a_30000_3486# 0.01209f
C95 a_22284_13271# VR 0.01175f
C96 a_27060_1364# a_21840_1180# 0.0555f
C97 LOIN a_10429_27389# 0.55754f
C98 a_22169_56859# VDD 0.25314f
C99 a_10429_78629# a_17107_78489# 0.07489f
C100 B0 a_18269_13109# 0.27231f
C101 a_24804_82040# a_25214_82040# 0.0129f
C102 B1 a_17107_27249# 0.84235f
C103 a_17107_27249# VR 4.25672f
C104 a_10429_78629# VR 3.59065f
C105 a_9264_56799# VR 0.49566f
C106 B0 a_27060_1364# 0.03676f
C107 a_32905_77900# a_32760_77900# 0.1904f
C108 a_22169_56859# a_9525_52239# 0.25599f
C109 a_9849_52239# a_9849_56859# 1.34672f
C110 a_4224_13271# VDD 0.75357f
C111 a_25065_27002# a_17107_27249# 0.0546f
C112 a_25065_27002# a_10429_78629# 0.03514f
C113 a_20924_11900# VR 0.01634f
C114 a_15609_57629# a_9449_57629# 1.62928f
C115 a_19334_69300# a_18924_69300# 0.0129f
C116 a_9773_52029# VR 1.99048f
C117 a_3709_27389# LOIP 0.55754f
C118 a_9849_52239# VDD 0.25314f
C119 B0 a_31244_18340# 0.01161f
C120 a_25065_27002# a_9773_52029# 0.03901f
C121 a_25084_43400# VR 0.63535f
C122 a_4420_82040# VR 0.50376f
C123 a_32905_77900# a_32644_77840# 0.01292f
C124 a_9849_52239# a_9525_52239# 0.82043f
C125 a_9849_56859# LOQN 0.03563f
C126 a_15933_56649# a_30954_56560# 0.022f
C127 a_40484_82040# VR 0.36569f
C128 a_26640_1364# VDD 0.43618f
C129 a_10429_27389# a_3709_27389# 1.32722f
C130 a_27060_1364# a_32760_77900# 0.04098f
C131 a_9449_53149# a_17225_26660# 0.13046f
C132 B1 LOIP 0.16791f
C133 a_19334_43400# VR 0.60202f
C134 VR LOIP 2.28205f
C135 VDD LOQN 0.79123f
C136 a_26894_30800# a_18787_27249# 0.01196f
C137 a_34734_30800# VR 0.58576f
C138 a_9449_57629# a_19754_52282# 0.01371f
C139 a_27900_1364# a_29160_1364# 0.01209f
C140 a_25065_27002# LOIP 0.04457f
C141 a_25065_30860# a_18787_27249# 0.10248f
C142 a_31654_69300# a_31244_69300# 0.0129f
C143 B1 a_10429_27389# 0.24074f
C144 a_27060_3486# a_26640_3486# 0.1684f
C145 a_17225_77900# a_17374_81900# 0.02238f
C146 a_10429_27389# VR 2.99104f
C147 a_26484_30800# a_18787_27249# 0.01245f
C148 a_18269_13109# VDD 6.77622f
C149 a_34324_30800# VR 0.58512f
C150 a_13025_65300# a_25065_82100# 0.10248f
C151 a_27060_1364# VDD 1.25522f
C152 a_22169_56859# LOQP 0.08783f
C153 a_31244_18340# VDD 0.36569f
C154 a_9773_56649# a_9773_52029# 0.0297f
C155 a_13025_65300# a_13174_65240# 0.02481f
C156 a_18787_27249# VDD 0.25314f
C157 a_9849_52239# LOQP 0.08097f
C158 a_17107_78489# a_25065_78242# 0.02056f
C159 a_22169_56859# a_17107_27249# 0.39952f
C160 a_32905_77900# a_34734_81900# 0.0199f
C161 a_25065_78242# VR 0.8238f
C162 a_22284_11900# VDD 0.70298f
C163 a_22169_56859# a_9773_52029# 1.14174f
C164 a_40894_78182# a_9773_52029# 0.01511f
C165 a_9773_56649# a_18000_52179# 0.01042f
C166 a_26484_82040# VR 0.58512f
C167 a_40894_82040# VR 0.3476f
C168 a_25214_26942# a_25065_27002# 0.01386f
C169 a_27716_13271# VDD 0.69733f
C170 a_9849_52239# a_9773_52029# 0.44657f
C171 a_18924_69300# VR 0.63535f
C172 a_26894_82040# a_25065_78242# 0.04066f
C173 a_13025_65300# a_19054_81900# 0.01027f
C174 a_16964_77840# a_17225_77900# 0.01292f
C175 a_9449_57629# a_17107_78489# 0.09387f
C176 a_10429_78629# LOQN 0.72286f
C177 a_9849_56859# a_15933_56649# 0.08706f
C178 a_27060_1364# LOQP 0.04113f
C179 a_34324_30800# a_32905_30860# 0.04818f
C180 a_9449_57629# VR 6.9417f
C181 a_32905_77900# a_9773_52029# 0.06039f
C182 a_26894_82040# a_26484_82040# 0.0129f
C183 a_40894_30800# VR 0.3476f
C184 a_9773_52029# LOQN 0.04457f
C185 a_15933_56649# VDD 0.25314f
C186 a_18084_11900# VDD 0.70783f
C187 a_17225_26660# VDD 0.50629f
C188 a_15609_57629# a_3709_78629# 0.44597f
C189 a_17080_26660# a_19054_26600# 0.01988f
C190 a_30840_1364# a_31260_1364# 0.1684f
C191 a_15609_57629# a_34874_52282# 0.01149f
C192 a_9525_52239# a_15933_56649# 0.1125f
C193 a_18787_27249# LOQP 0.04527f
C194 a_9849_56859# a_22704_51940# 0.01877f
C195 B1 a_17080_26660# 0.1304f
C196 a_32905_77900# a_40484_82040# 0.01161f
C197 a_31680_3486# a_32100_3486# 0.1684f
C198 a_17225_77900# a_3709_78629# 0.0391f
C199 a_27060_1364# a_10429_78629# 1.42302f
C200 a_26640_1364# LOIP 0.03447f
C201 a_26640_1364# a_34734_30800# 0.01196f
C202 a_16784_11900# VDD 0.75817f
C203 a_27060_1364# a_9773_52029# 0.03901f
C204 a_25494_43400# a_17107_27249# 0.0476f
C205 a_16964_81900# a_17225_77900# 0.01168f
C206 a_9449_53149# a_33054_26942# 0.01386f
C207 VCTRL a_21840_1180# 0.38172f
C208 a_17374_81900# VR 0.35048f
C209 a_18787_27249# a_17107_27249# 0.35856f
C210 a_26640_1364# a_34324_30800# 0.01245f
C211 a_30544_52179# a_15933_56649# 0.01287f
C212 a_15609_57629# VR 6.73949f
C213 VCTRL B0 0.09523f
C214 a_25494_43400# a_25084_43400# 0.0129f
C215 a_17107_78489# a_17225_77900# 0.9294f
C216 a_15609_57629# a_25065_27002# 0.03649f
C217 a_18269_13109# LOIP 0.03522f
C218 a_17225_77900# VR 1.30723f
C219 a_27060_1364# LOIP 0.03901f
C220 a_19334_69300# a_17107_78489# 0.0476f
C221 a_18644_30660# VR 0.36374f
C222 a_12064_56560# VR 0.36295f
C223 a_19334_69300# VR 0.60202f
C224 a_9449_57629# a_9773_56649# 1.27839f
C225 a_21840_1180# a_22796_1120# 0.08666f
C226 a_28320_3486# a_28740_3486# 0.1684f
C227 a_30420_3486# a_30000_3486# 0.1684f
C228 a_13744_56560# a_9849_56859# 0.01162f
C229 a_17374_30660# VR 0.35048f
C230 a_8697_11960# VR 7.13158f
C231 a_10808_56799# VR 0.49417f
C232 a_33194_52282# a_15933_56649# 0.01296f
C233 a_10429_78629# a_15933_56649# 0.44358f
C234 a_17225_26660# a_17107_27249# 0.98665f
C235 a_9449_57629# a_9849_52239# 0.90614f
C236 a_4224_11900# VDD 0.75817f
C237 LOIN B1 0.12432f
C238 VCTRL VDD 2.75229f
C239 LOIN VR 3.40752f
C240 a_24804_30800# VR 0.63502f
C241 a_15933_56649# a_9773_52029# 0.38915f
C242 a_9449_53149# a_9849_56859# 0.10322f
C243 a_12474_56560# a_9525_52239# 0.02374f
C244 a_15609_57629# a_9773_56649# 0.29473f
C245 LOIN a_25065_27002# 0.08239f
C246 a_31654_39340# a_18787_27249# 0.02481f
C247 a_3524_82040# VR 0.50376f
C248 a_9773_56649# a_21434_52282# 0.01149f
C249 a_13025_65300# VDD 0.25314f
C250 a_9449_53149# VDD 0.50629f
C251 a_27060_1364# a_29580_1364# 0.03728f
C252 a_16784_13271# VDD 0.75357f
C253 a_19054_30660# VR 0.35048f
C254 a_9449_53149# a_9525_52239# 0.19586f
C255 a_17107_78489# a_3709_78629# 0.07343f
C256 a_19054_77840# a_17080_77900# 0.01988f
C257 a_15609_57629# a_22169_56859# 0.20677f
C258 a_3709_78629# VR 3.56427f
C259 a_27060_1364# a_29160_1364# 0.01551f
C260 a_17225_26660# LOIP 0.04457f
C261 a_32905_77900# a_33054_77840# 0.01991f
C262 B1 a_3709_27389# 0.24074f
C263 a_3709_27389# VR 2.75496f
C264 a_16964_81900# VR 0.36293f
C265 a_25494_69300# a_3709_78629# 0.0476f
C266 a_15609_57629# a_9849_52239# 0.28807f
C267 a_9449_57629# a_18634_56560# 0.02195f
C268 a_25065_30860# a_25214_30800# 0.0476f
C269 a_27480_1364# a_27900_1364# 0.1684f
C270 a_13025_65300# a_17080_77900# 0.04098f
C271 a_14154_56560# a_9849_56859# 0.01988f
C272 a_18924_43400# a_19334_43400# 0.0129f
C273 a_12764_43400# VR 0.63535f
C274 a_25840_52179# a_22169_56859# 0.01042f
C275 a_26484_30800# a_26894_30800# 0.0129f
C276 a_17107_78489# VR 3.2991f
C277 a_26640_1364# a_21680_1120# 0.01454f
C278 B1 VR 1.12713f
C279 a_9449_53149# a_40745_27002# 0.06039f
C280 B0 VDD 2.67263f
C281 a_31654_14482# a_18269_13109# 0.01511f
C282 a_15609_57629# LOQN 0.08708f
C283 B1 a_25065_27002# 2.11766f
C284 a_25065_27002# VR 2.95131f
C285 a_25065_30860# a_26484_30800# 0.04818f
C286 a_24944_52179# a_22169_56859# 0.01077f
C287 a_17225_77900# LOQN 0.88105f
C288 a_25494_69300# VR 0.60202f
C289 a_9449_53149# a_40484_30800# 0.01161f
C290 a_32644_77840# a_32760_77900# 0.01998f
C291 a_17080_26660# a_18787_27249# 0.02889f
C292 a_9449_53149# LOQP 0.04457f
C293 a_25065_78242# a_26894_78182# 0.01149f
C294 a_26894_82040# VR 0.58576f
C295 a_15609_57629# a_27060_1364# 0.03649f
C296 a_24944_52179# a_9849_52239# 0.01937f
C297 a_25084_69300# VR 0.63535f
C298 a_13025_65300# a_10429_78629# 0.11818f
C299 a_21584_56799# VR 0.49566f
C300 a_9849_56859# VDD 0.25314f
C301 a_25065_82100# a_25065_78242# 0.38839f
C302 a_25084_69300# a_25494_69300# 0.0129f
C303 B1 a_37404_18340# 0.01161f
C304 a_9449_53149# a_9773_52029# 0.08312f
C305 a_9525_52239# a_9849_56859# 3.53981f
C306 LOIN a_26640_1364# 0.07796f
C307 a_9449_57629# a_15933_56649# 0.98862f
C308 a_18269_13109# a_8697_11960# 0.91962f
C309 a_20314_56560# VR 0.35048f
C310 a_17374_26600# a_17225_26660# 0.01991f
C311 a_9525_52239# VDD 0.25314f
C312 VCTRL LOIP 0.07673f
C313 a_25065_82100# a_26484_82040# 0.04818f
C314 a_9773_56649# VR 5.13671f
C315 a_32905_30860# VR 0.89698f
C316 a_10160_52179# a_9849_52239# 0.01367f
C317 a_30840_1364# a_29580_1364# 0.01209f
C318 a_27060_1364# a_27900_1364# 0.04778f
C319 a_16964_26600# a_17080_26660# 0.01998f
C320 a_31654_69300# a_10429_78629# 0.0476f
C321 a_17080_26660# a_17225_26660# 0.1904f
C322 a_9449_53149# a_34734_30800# 0.04066f
C323 a_13174_69300# VR 0.60202f
C324 a_22169_56859# VR 5.83325f
C325 a_32644_30800# VR 0.63502f
C326 LOIN a_27060_1364# 0.03437f
C327 a_25065_27002# a_22169_56859# 0.03676f
C328 a_3709_78629# LOQN 0.32708f
C329 a_9449_53149# a_34324_30800# 0.02019f
C330 a_12764_69300# VR 0.63535f
C331 a_9849_52239# VR 5.53175f
C332 a_15609_57629# a_15933_56649# 1.84197f
C333 LOIN a_18787_27249# 0.07792f
C334 a_9449_57629# a_18224_56560# 0.0104f
C335 a_25065_27002# a_9849_52239# 0.64584f
C336 B1 a_26640_1364# 0.07204f
C337 a_9849_56859# LOQP 0.08428f
C338 a_26640_1364# VR 1.02175f
C339 a_17080_77900# a_17374_77840# 0.01069f
C340 a_25065_30860# a_17107_27249# 0.0727f
C341 a_32905_77900# VR 2.37373f
C342 a_27716_11900# VDD 0.70298f
C343 a_17107_78489# LOQN 0.65441f
C344 a_26640_1364# a_25065_27002# 0.03618f
C345 B0 LOIP 0.03882f
C346 a_4420_30800# VR 0.50376f
C347 a_19054_30660# a_18787_27249# 0.01027f
C348 VR LOQN 5.77402f
C349 VDD LOQP 1.04438f
C350 a_25065_27002# a_32905_77900# 0.88735f
C351 a_32520_1364# a_32940_1364# 0.1684f
C352 a_13025_65300# a_25065_78242# 0.69929f
C353 a_19904_56560# VR 0.36279f
C354 a_9773_56649# a_20314_56560# 0.01991f
C355 a_9525_52239# LOQP 0.08678f
C356 a_25065_27002# LOQN 0.03873f
C357 a_33054_30800# VR 0.60202f
C358 a_22284_13271# VDD 0.69733f
C359 a_32644_81900# VR 0.36293f
C360 a_15609_57629# a_30544_56560# 0.011f
C361 a_9849_56859# a_14154_52282# 0.01101f
C362 a_17225_26660# a_17374_30660# 0.02238f
C363 a_3524_30800# VR 0.50376f
C364 a_18084_11900# a_8697_11960# 0.05586f
C365 a_31244_43400# VR 0.63535f
C366 a_13025_65300# a_26484_82040# 0.01245f
C367 a_9849_56859# a_9773_52029# 0.12609f
C368 a_18269_13109# VR 1.11996f
C369 a_17107_27249# VDD 0.25314f
C370 a_10429_78629# VDD 0.23364f
C371 B1 a_27060_1364# 0.03437f
C372 a_18634_56560# VR 0.34967f
C373 a_27060_1364# VR 2.01385f
C374 a_31654_43400# VR 0.60202f
C375 a_20924_11900# VDD 0.70783f
C376 a_9773_52029# VDD 0.50629f
C377 a_27060_1364# a_25065_27002# 8.40438f
C378 a_9525_52239# a_14154_52282# 0.01269f
C379 a_9849_56859# a_13744_52282# 0.01492f
C380 a_25494_43400# VR 0.60202f
C381 a_33360_3486# a_32100_3486# 0.01209f
C382 a_9525_52239# a_9773_52029# 0.13282f
C383 B1 a_18787_27249# 0.07001f
C384 a_33054_81900# VR 0.35048f
C385 a_18787_27249# VR 3.84347f
C386 LOIN a_17225_26660# 0.96861f
C387 a_9773_56649# a_9849_52239# 0.79929f
C388 a_25065_27002# a_18787_27249# 0.73404f
C389 a_22284_11900# VR 0.01601f
C390 a_12764_69300# a_13174_69300# 0.0129f
C391 VDD LOIP 3.74418f
C392 a_19054_30660# a_17225_26660# 0.0199f
C393 a_9849_52239# a_22169_56859# 2.8884f
C394 a_26640_1364# a_32905_30860# 0.10248f
C395 a_11140_30800# VR 0.50376f
C396 a_10429_27389# a_9849_56859# 0.09182f
C397 a_27594_52282# a_9849_52239# 0.01297f
C398 a_19054_81900# a_17225_77900# 0.0199f
C399 a_9773_56649# a_19904_56560# 0.01102f
C400 a_10429_27389# VDD 0.25314f
C401 a_19334_65240# a_17107_78489# 0.02481f
C402 a_33054_30800# a_32905_30860# 0.0476f
C403 a_10244_30800# VR 0.50376f
C404 a_27060_1364# a_27480_1364# 0.03212f
C405 a_10429_27389# a_9525_52239# 0.25037f
C406 a_31244_69300# VR 0.63535f
C407 a_22169_56859# LOQN 0.03494f
C408 a_34734_77840# a_32760_77900# 0.01988f
C409 a_10429_78629# LOQP 0.04159f
C410 a_17107_27249# LOQP 0.04332f
C411 a_9773_56649# a_18634_56560# 0.01265f
C412 a_18269_13109# a_31654_18340# 0.02481f
C413 a_27744_56799# VR 0.49566f
C414 a_33054_30800# a_32644_30800# 0.0129f
C415 a_13025_65300# a_17225_77900# 0.54617f
C416 B1 a_17225_26660# 0.39399f
C417 a_15933_56649# VR 6.52472f
C418 a_40745_27002# a_40894_26942# 0.01511f
C419 a_17225_26660# VR 2.64384f
C420 a_18084_11900# VR 0.01692f
C421 a_25065_27002# a_15933_56649# 0.12831f
C422 a_15609_57629# a_32634_56560# 0.01993f
C423 a_27060_1364# a_22169_56859# 0.03676f
C424 a_25065_27002# a_17225_26660# 0.19807f
C425 a_25214_82040# VR 0.60202f
C426 a_26474_56560# VR 0.35048f
C427 a_13174_43400# a_3709_27389# 0.0476f
C428 a_16784_11900# VR 0.0136f
C429 a_16964_30660# VR 0.36293f
C430 a_22169_56859# a_18787_27249# 0.18361f
C431 a_22169_56859# a_29274_52282# 0.01149f
C432 a_18924_43400# VR 0.63535f
C433 a_27060_1364# a_9849_52239# 0.15888f
C434 a_25065_82100# a_17107_78489# 0.0727f
C435 a_21680_1120# a_21840_1180# 0.07454f
C436 a_31654_65240# a_10429_78629# 0.02481f
C437 a_25065_82100# VR 0.89698f
C438 a_32644_81900# a_32905_77900# 0.01206f
C439 a_9449_53149# a_34734_26942# 0.01149f
C440 a_30544_56560# VR 0.36281f
C441 a_13174_43400# a_12764_43400# 0.0129f
C442 a_18269_13109# a_26640_1364# 0.0261f
C443 a_32760_77900# a_33054_77840# 0.01069f
C444 a_9449_57629# a_9849_56859# 1.05786f
C445 a_27060_1364# a_26640_1364# 6.01525f
C446 a_9849_52239# a_18787_27249# 0.29158f
C447 a_13174_43400# VR 0.60202f
C448 a_10429_27389# LOQP 0.04527f
C449 a_27060_1364# a_32905_77900# 0.31626f
C450 a_27060_1364# LOQN 0.03622f
C451 a_18224_56560# VR 0.36377f
C452 a_9449_57629# VDD 0.25314f
C453 a_29288_56799# VR 0.4924f
C454 LOIN a_9449_53149# 0.12837f
C455 a_33780_3486# a_25065_27002# 0.05175f
C456 a_9449_57629# a_9525_52239# 0.36711f
C457 a_33054_81900# a_32905_77900# 0.0228f
C458 a_24804_82040# a_17107_78489# 0.0155f
C459 a_17107_27249# a_25494_39340# 0.02481f
C460 a_24804_82040# VR 0.63502f
C461 a_32940_1364# a_17225_26660# 0.04189f
C462 a_31244_43400# a_31654_43400# 0.0129f
C463 a_16968_56799# VR 0.49417f
C464 a_9773_56649# a_15933_56649# 0.42958f
C465 a_27060_1364# a_18269_13109# 0.03167f
C466 a_31680_3486# a_30420_3486# 0.01209f
C467 a_17225_26660# a_32905_30860# 0.0727f
C468 a_13025_65300# a_3709_78629# 0.07698f
C469 a_27744_56799# a_22169_56859# 0.01125f
C470 a_13744_56560# VR 0.36281f
C471 a_26064_56560# VR 0.36281f
C472 a_19054_81900# VR 0.35048f
C473 a_22169_56859# a_15933_56649# 0.60826f
C474 a_22169_56859# a_23600_51940# 0.01352f
C475 VR a_32224_56560# 0.36279f
C476 a_18787_27249# a_31654_43400# 0.0476f
C477 a_17225_26660# a_32644_30800# 0.0155f
C478 a_27060_1364# a_18787_27249# 0.03937f
C479 a_18644_81900# VR 0.36374f
C480 a_15609_57629# VDD 0.25314f
C481 a_40745_27002# a_40894_30800# 0.02481f
C482 a_24794_56560# VR 0.3476f
C483 a_26474_56560# a_22169_56859# 0.02177f
C484 a_10429_78629# a_25065_78242# 0.09129f
C485 VCTRL VR 0.18663f
C486 a_12474_56560# VR 0.34967f
C487 a_10429_27389# a_19334_43400# 0.0476f
C488 a_9849_52239# a_15933_56649# 0.97875f
C489 a_13025_65300# a_17107_78489# 0.24193f
C490 VR a_30954_56560# 0.35048f
C491 a_34324_30800# a_34734_30800# 0.0129f
C492 a_13025_65300# VR 4.0233f
C493 B1 a_9449_53149# 0.29724f
C494 a_24804_30800# a_25214_30800# 0.0129f
C495 a_9449_53149# VR 1.89024f
C496 a_15609_57629# a_31440_52179# 0.01128f
C497 a_26640_1364# a_17225_26660# 0.08834f
C498 a_9449_53149# a_25065_27002# 0.0412f
C499 a_9525_52239# a_12064_56560# 0.01438f
C500 a_17374_77840# a_17225_77900# 0.01991f
C501 a_40894_82040# a_9773_52029# 0.02481f
C502 a_15933_56649# LOQN 0.03873f
C503 a_32634_56560# VR 0.35048f
C504 a_8697_11960# VDD 8.02736f
C505 a_26894_82040# a_13025_65300# 0.01196f
C506 a_33360_3486# a_17225_26660# 0.01166f
C507 a_17080_77900# a_17225_77900# 0.1904f
C508 a_25494_65240# a_3709_78629# 0.02481f
C509 a_15424_56799# VR 0.49566f
R0 VR.n174 VR.t93 272.822
R1 VR.t99 VR.n227 272.822
R2 VR.n177 VR.t44 272.822
R3 VR.t50 VR.n221 272.822
R4 VR.n180 VR.t67 272.822
R5 VR.t73 VR.n313 272.822
R6 VR.n183 VR.t33 272.822
R7 VR.t39 VR.n307 272.822
R8 VR.t93 VR.t95 127.862
R9 VR.t97 VR.t99 127.862
R10 VR.t44 VR.t46 127.862
R11 VR.t48 VR.t50 127.862
R12 VR.t67 VR.t69 127.862
R13 VR.t71 VR.t73 127.862
R14 VR.t33 VR.t35 127.862
R15 VR.t37 VR.t39 127.862
R16 VR.t188 VR.t190 104.719
R17 VR.t190 VR.t79 104.719
R18 VR.t79 VR.t83 104.719
R19 VR.t85 VR.t87 104.719
R20 VR.t87 VR.t192 104.719
R21 VR.t192 VR.t194 104.719
R22 VR.t105 VR.t111 104.719
R23 VR.t111 VR.t123 104.719
R24 VR.t123 VR.t125 104.719
R25 VR.t127 VR.t129 104.719
R26 VR.t129 VR.t107 104.719
R27 VR.t107 VR.t113 104.719
R28 VR.t55 VR.t59 104.719
R29 VR.t59 VR.t162 104.719
R30 VR.t162 VR.t168 104.719
R31 VR.t170 VR.t172 104.719
R32 VR.t172 VR.t61 104.719
R33 VR.t61 VR.t63 104.719
R34 VR.t6 VR.t12 104.719
R35 VR.t12 VR.t21 104.719
R36 VR.t21 VR.t25 104.719
R37 VR.t27 VR.t29 104.719
R38 VR.t29 VR.t8 104.719
R39 VR.t8 VR.t14 104.719
R40 VR.n13 VR.n31 1.76837
R41 VR.n15 VR.n31 1.76837
R42 VR.n9 VR.n33 1.76837
R43 VR.n11 VR.n33 1.76837
R44 VR.n5 VR.n35 1.76837
R45 VR.n7 VR.n35 1.76837
R46 VR.n1 VR.n37 1.76837
R47 VR.n3 VR.n37 1.76837
R48 VR.n174 VR.n224 66.2717
R49 VR.n227 VR.n224 66.2717
R50 VR.n177 VR.n218 66.2717
R51 VR.n221 VR.n218 66.2717
R52 VR.n180 VR.n310 66.2717
R53 VR.n313 VR.n310 66.2717
R54 VR.n183 VR.n304 66.2717
R55 VR.n307 VR.n304 66.2717
R56 VR.n174 VR.n226 66.2111
R57 VR.n227 VR.n226 66.2111
R58 VR.n177 VR.n220 66.2111
R59 VR.n221 VR.n220 66.2111
R60 VR.n180 VR.n312 66.2111
R61 VR.n313 VR.n312 66.2111
R62 VR.n183 VR.n306 66.2111
R63 VR.n307 VR.n306 66.2111
R64 VR.t95 VR.n228 63.931
R65 VR.n228 VR.t97 63.931
R66 VR.t46 VR.n222 63.931
R67 VR.n222 VR.t48 63.931
R68 VR.t69 VR.n314 63.931
R69 VR.n314 VR.t71 63.931
R70 VR.t35 VR.n308 63.931
R71 VR.n308 VR.t37 63.931
R72 VR.n62 VR.n148 55.7918
R73 VR.n77 VR.n149 55.7918
R74 VR.n83 VR.n151 55.7918
R75 VR.n86 VR.n153 55.7918
R76 VR.n95 VR.n154 55.7918
R77 VR.n98 VR.n155 55.7918
R78 VR.n101 VR.n156 55.7918
R79 VR.n128 VR.n157 55.7918
R80 VR.n131 VR.n158 55.7918
R81 VR.n134 VR.n159 55.7918
R82 VR.n137 VR.n160 55.7918
R83 VR.n23 VR.n22 1.07373
R84 VR.n161 VR.n241 55.7313
R85 VR.n162 VR.n318 55.7313
R86 VR.n26 VR.n25 1.07373
R87 VR.n163 VR.n252 55.7313
R88 VR.n29 VR.n28 1.07373
R89 VR.n164 VR.n259 55.7313
R90 VR.n165 VR.n323 55.7313
R91 VR.n166 VR.n328 55.7313
R92 VR.n167 VR.n333 55.7313
R93 VR.n168 VR.n390 55.7313
R94 VR.n169 VR.n385 55.7313
R95 VR.n170 VR.n380 55.7313
R96 VR.n171 VR.n376 55.7313
R97 VR.t83 VR.n366 52.3599
R98 VR.n366 VR.t85 52.3599
R99 VR.t125 VR.n357 52.3599
R100 VR.n357 VR.t127 52.3599
R101 VR.t168 VR.n348 52.3599
R102 VR.n348 VR.t170 52.3599
R103 VR.t25 VR.n339 52.3599
R104 VR.n339 VR.t27 52.3599
R105 VR.n65 VR.n185 47.3111
R106 VR.n68 VR.n186 47.3111
R107 VR.n71 VR.n187 47.3111
R108 VR.n74 VR.n188 47.3111
R109 VR.n80 VR.n189 47.3111
R110 VR.n89 VR.n190 47.3111
R111 VR.n92 VR.n191 47.3111
R112 VR.n104 VR.n192 47.3111
R113 VR.n107 VR.n193 47.3111
R114 VR.n110 VR.n194 47.3111
R115 VR.n113 VR.n195 47.3111
R116 VR.n116 VR.n196 47.3111
R117 VR.n119 VR.n197 47.3111
R118 VR.n122 VR.n198 47.3111
R119 VR.n125 VR.n199 47.3111
R120 VR.n140 VR.n200 47.3111
R121 VR.n201 VR.n235 47.2505
R122 VR.n202 VR.n231 47.2505
R123 VR.n203 VR.n400 47.2505
R124 VR.n204 VR.n396 47.2505
R125 VR.n205 VR.n248 47.2505
R126 VR.n206 VR.n297 47.2505
R127 VR.n207 VR.n293 47.2505
R128 VR.n208 VR.n371 47.2505
R129 VR.n209 VR.n367 47.2505
R130 VR.n210 VR.n362 47.2505
R131 VR.n211 VR.n358 47.2505
R132 VR.n212 VR.n353 47.2505
R133 VR.n213 VR.n349 47.2505
R134 VR.n214 VR.n344 47.2505
R135 VR.n215 VR.n340 47.2505
R136 VR.n216 VR.n407 47.2505
R137 VR.n22 VR.n147 45.2772
R138 VR.n241 VR.n148 45.2772
R139 VR.n318 VR.n149 45.2772
R140 VR.n25 VR.n150 45.2772
R141 VR.n252 VR.n151 45.2772
R142 VR.n28 VR.n152 45.2772
R143 VR.n259 VR.n153 45.2772
R144 VR.n323 VR.n154 45.2772
R145 VR.n328 VR.n155 45.2772
R146 VR.n333 VR.n156 45.2772
R147 VR.n390 VR.n157 45.2772
R148 VR.n385 VR.n158 45.2772
R149 VR.n380 VR.n159 45.2772
R150 VR.n376 VR.n160 45.2772
R151 VR.n62 VR.n161 45.2371
R152 VR.n77 VR.n162 45.2371
R153 VR.n83 VR.n163 45.2371
R154 VR.n86 VR.n164 45.2371
R155 VR.n95 VR.n165 45.2371
R156 VR.n98 VR.n166 45.2371
R157 VR.n101 VR.n167 45.2371
R158 VR.n128 VR.n168 45.2371
R159 VR.n131 VR.n169 45.2371
R160 VR.n134 VR.n170 45.2371
R161 VR.n137 VR.n171 45.2371
R162 VR.n235 VR.n185 40.8435
R163 VR.n231 VR.n186 40.8435
R164 VR.n400 VR.n187 40.8435
R165 VR.n396 VR.n188 40.8435
R166 VR.n248 VR.n189 40.8435
R167 VR.n297 VR.n190 40.8435
R168 VR.n293 VR.n191 40.8435
R169 VR.n371 VR.n192 40.8435
R170 VR.n367 VR.n193 40.8435
R171 VR.n362 VR.n194 40.8435
R172 VR.n358 VR.n195 40.8435
R173 VR.n353 VR.n196 40.8435
R174 VR.n349 VR.n197 40.8435
R175 VR.n344 VR.n198 40.8435
R176 VR.n340 VR.n199 40.8435
R177 VR.n407 VR.n200 40.8435
R178 VR.n65 VR.n201 40.7981
R179 VR.n68 VR.n202 40.7981
R180 VR.n71 VR.n203 40.7981
R181 VR.n74 VR.n204 40.7981
R182 VR.n80 VR.n205 40.7981
R183 VR.n89 VR.n206 40.7981
R184 VR.n92 VR.n207 40.7981
R185 VR.n104 VR.n208 40.7981
R186 VR.n107 VR.n209 40.7981
R187 VR.n110 VR.n210 40.7981
R188 VR.n113 VR.n211 40.7981
R189 VR.n116 VR.n212 40.7981
R190 VR.n119 VR.n213 40.7981
R191 VR.n122 VR.n214 40.7981
R192 VR.n125 VR.n215 40.7981
R193 VR.n140 VR.n216 40.7981
R194 VR.n20 VR.t2 15.3541
R195 VR.n217 VR.t226 11.9381
R196 VR.n230 VR.n223 11.0797
R197 VR.n316 VR.n309 11.0797
R198 VR.n384 VR.n379 10.9377
R199 VR.n375 VR.n337 9.28389
R200 VR VR.n411 9.23773
R201 VR.n394 VR.n393 8.16573
R202 VR.n389 VR.n388 8.16573
R203 VR.n384 VR.n383 8.16573
R204 VR.n230 VR.n229 8.05572
R205 VR.n316 VR.n315 8.05572
R206 VR.n258 VR.n251 7.52403
R207 VR.n302 VR.n17 7.22637
R208 VR.n322 VR.n317 7.10037
R209 VR.n236 VR.t204 6.93035
R210 VR.n232 VR.t135 6.93035
R211 VR.n401 VR.t139 6.93035
R212 VR.n397 VR.t133 6.93035
R213 VR.n249 VR.t152 6.93035
R214 VR.n298 VR.t216 6.93035
R215 VR.n294 VR.t118 6.93035
R216 VR.n372 VR.t165 6.93035
R217 VR.n368 VR.t66 6.93035
R218 VR.n363 VR.t82 6.93035
R219 VR.n359 VR.t185 6.93035
R220 VR.n354 VR.t5 6.93035
R221 VR.n350 VR.t20 6.93035
R222 VR.n345 VR.t122 6.93035
R223 VR.n341 VR.t110 6.93035
R224 VR.n408 VR.t42 6.93035
R225 VR.n51 VR.t195 6.30328
R226 VR.n49 VR.t189 6.30328
R227 VR.n54 VR.t114 6.30328
R228 VR.n52 VR.t106 6.30328
R229 VR.n58 VR.t64 6.30328
R230 VR.n56 VR.t56 6.30328
R231 VR.n60 VR.t15 6.30328
R232 VR.n338 VR.t7 6.30328
R233 VR.n42 VR.t100 6.10958
R234 VR.n41 VR.t94 6.10958
R235 VR.n44 VR.t51 6.10958
R236 VR.n43 VR.t45 6.10958
R237 VR.n46 VR.t74 6.10958
R238 VR.n45 VR.t68 6.10958
R239 VR.n48 VR.t40 6.10958
R240 VR.n47 VR.t34 6.10958
R241 VR.n287 VR.t141 5.95626
R242 VR.n280 VR.t32 5.95626
R243 VR.n274 VR.t155 5.89952
R244 VR.n267 VR.t75 5.89952
R245 VR.n247 VR.n246 5.89846
R246 VR.n405 VR.n395 5.89467
R247 VR.n240 VR.n239 5.83546
R248 VR.n51 VR.t193 5.68495
R249 VR.n50 VR.t86 5.68495
R250 VR.n50 VR.t80 5.68495
R251 VR.n54 VR.t108 5.68495
R252 VR.n53 VR.t128 5.68495
R253 VR.n53 VR.t124 5.68495
R254 VR.n58 VR.t62 5.68495
R255 VR.n57 VR.t171 5.68495
R256 VR.n57 VR.t163 5.68495
R257 VR.n60 VR.t9 5.68495
R258 VR.n59 VR.t28 5.68495
R259 VR.n59 VR.t22 5.68495
R260 VR.n17 VR.n172 5.65467
R261 VR.n42 VR.t98 5.49125
R262 VR.n44 VR.t49 5.49125
R263 VR.n46 VR.t72 5.49125
R264 VR.n48 VR.t38 5.49125
R265 VR.n287 VR.t101 5.26198
R266 VR.n288 VR.t77 5.26198
R267 VR.n289 VR.t156 5.26198
R268 VR.n290 VR.t149 5.26198
R269 VR.n291 VR.t145 5.26198
R270 VR.n292 VR.t150 5.26198
R271 VR.n39 VR.t102 5.26198
R272 VR.n286 VR.t91 5.26198
R273 VR.n285 VR.t183 5.26198
R274 VR.n284 VR.t142 5.26198
R275 VR.n283 VR.t76 5.26198
R276 VR.n282 VR.t158 5.26198
R277 VR.n281 VR.t202 5.26198
R278 VR.n280 VR.t16 5.26198
R279 VR.n17 VR.n217 5.2133
R280 VR.n274 VR.t31 5.20524
R281 VR.n275 VR.t143 5.20524
R282 VR.n276 VR.t160 5.20524
R283 VR.n277 VR.t157 5.20524
R284 VR.n278 VR.t54 5.20524
R285 VR.n279 VR.t153 5.20524
R286 VR.n40 VR.t146 5.20524
R287 VR.n273 VR.t161 5.20524
R288 VR.n272 VR.t92 5.20524
R289 VR.n271 VR.t154 5.20524
R290 VR.n270 VR.t159 5.20524
R291 VR.n269 VR.t131 5.20524
R292 VR.n268 VR.t78 5.20524
R293 VR.n267 VR.t140 5.20524
R294 VR.n266 VR.n19 5.0954
R295 VR.n217 VR.n40 4.9694
R296 VR.n64 VR.n236 4.95693
R297 VR.n67 VR.n232 4.95693
R298 VR.n70 VR.n401 4.95693
R299 VR.n73 VR.n397 4.95693
R300 VR.n79 VR.n249 4.95693
R301 VR.n88 VR.n298 4.95693
R302 VR.n91 VR.n294 4.95693
R303 VR.n103 VR.n372 4.95693
R304 VR.n106 VR.n368 4.95693
R305 VR.n109 VR.n363 4.95693
R306 VR.n112 VR.n359 4.95693
R307 VR.n115 VR.n354 4.95693
R308 VR.n118 VR.n350 4.95693
R309 VR.n121 VR.n345 4.95693
R310 VR.n124 VR.n341 4.95693
R311 VR.n139 VR.n408 4.95693
R312 VR.n236 VR.n66 4.78336
R313 VR.n232 VR.n69 4.78336
R314 VR.n41 VR.n175 4.78336
R315 VR.n173 VR.n42 4.78336
R316 VR.n43 VR.n178 4.78336
R317 VR.n176 VR.n44 4.78336
R318 VR.n401 VR.n72 4.78336
R319 VR.n397 VR.n75 4.78336
R320 VR.n249 VR.n81 4.78336
R321 VR.n298 VR.n90 4.78336
R322 VR.n294 VR.n93 4.78336
R323 VR.n45 VR.n181 4.78336
R324 VR.n179 VR.n46 4.78336
R325 VR.n47 VR.n184 4.78336
R326 VR.n182 VR.n48 4.78336
R327 VR.n372 VR.n105 4.78336
R328 VR.n368 VR.n108 4.78336
R329 VR.n49 VR.n12 4.78336
R330 VR.n14 VR.n51 4.78336
R331 VR.n363 VR.n111 4.78336
R332 VR.n359 VR.n114 4.78336
R333 VR.n52 VR.n8 4.78336
R334 VR.n10 VR.n54 4.78336
R335 VR.n354 VR.n117 4.78336
R336 VR.n350 VR.n120 4.78336
R337 VR.n56 VR.n4 4.78336
R338 VR.n6 VR.n58 4.78336
R339 VR.n345 VR.n123 4.78336
R340 VR.n341 VR.n126 4.78336
R341 VR.n0 VR.n338 4.78336
R342 VR.n2 VR.n60 4.78336
R343 VR.n408 VR.n141 4.78336
R344 VR.n327 VR.n326 4.78023
R345 VR.n332 VR.n331 4.78023
R346 VR.n337 VR.n336 4.78023
R347 VR.n411 VR.n410 4.75923
R348 VR.n217 VR.n39 4.6544
R349 VR.n266 VR.n21 4.52967
R350 VR.n31 VR.n16 2.18222
R351 VR.n33 VR.n55 2.18222
R352 VR.n35 VR.n143 2.18222
R353 VR.n322 VR.n321 3.65523
R354 VR.n242 VR.t137 3.62993
R355 VR.n319 VR.t104 3.62993
R356 VR.n253 VR.t201 3.62993
R357 VR.n260 VR.t116 3.62993
R358 VR.n324 VR.t120 3.62993
R359 VR.n329 VR.t187 3.62993
R360 VR.n334 VR.t90 3.62993
R361 VR.n391 VR.t167 3.62993
R362 VR.n386 VR.t58 3.62993
R363 VR.n381 VR.t11 3.62993
R364 VR.n377 VR.t24 3.62993
R365 VR.n303 VR.n265 3.55047
R366 VR.n327 VR.n322 3.54447
R367 VR.n240 VR.n230 3.5285
R368 VR.n247 VR.n240 3.5285
R369 VR.n265 VR.n258 3.5213
R370 VR.n142 VR.n59 3.45738
R371 VR.n50 VR.n16 3.39305
R372 VR.n53 VR.n16 3.39305
R373 VR.n57 VR.n55 3.39305
R374 VR.n406 VR.n247 3.33357
R375 VR.n146 VR.t196 3.14483
R376 VR.n144 VR.t225 3.08809
R377 VR.n145 VR.t53 3.08809
R378 VR.n19 VR.t208 3.0476
R379 VR.n19 VR.t43 3.01465
R380 VR.n19 VR.t0 3.01465
R381 VR.n19 VR.t52 3.01465
R382 VR.n19 VR.t199 3.01465
R383 VR.n19 VR.t207 3.01465
R384 VR.n19 VR.t213 3.01465
R385 VR.n18 VR.t209 3.01465
R386 VR.n18 VR.t198 3.01465
R387 VR.n18 VR.t206 3.01465
R388 VR.n18 VR.t210 3.01465
R389 VR.n146 VR.t180 3.01465
R390 VR.n146 VR.t197 3.01465
R391 VR.n146 VR.t147 3.01465
R392 VR.n146 VR.t182 3.01465
R393 VR.n17 VR.n266 3.0011
R394 VR.n172 VR.t218 2.99086
R395 VR.n21 VR.t174 2.99086
R396 VR.n172 VR.t219 2.95791
R397 VR.n172 VR.t220 2.95791
R398 VR.n144 VR.t221 2.95791
R399 VR.n144 VR.t222 2.95791
R400 VR.n144 VR.t223 2.95791
R401 VR.n144 VR.t224 2.95791
R402 VR.n21 VR.t214 2.95791
R403 VR.n21 VR.t211 2.95791
R404 VR.n21 VR.t212 2.95791
R405 VR.n21 VR.t177 2.95791
R406 VR.n21 VR.t179 2.95791
R407 VR.n21 VR.t178 2.95791
R408 VR.n20 VR.t3 2.95791
R409 VR.n20 VR.t176 2.95791
R410 VR.n20 VR.t181 2.95791
R411 VR.n20 VR.t148 2.95791
R412 VR.n145 VR.t175 2.95791
R413 VR.n145 VR.t1 2.95791
R414 VR.n145 VR.t17 2.95791
R415 VR.n145 VR.t18 2.95791
R416 VR.n411 VR.n406 2.79447
R417 VR.n389 VR.n384 2.7725
R418 VR.n394 VR.n389 2.7725
R419 VR.n395 VR.n375 2.76934
R420 VR.n337 VR.n332 2.7653
R421 VR.n332 VR.n327 2.7653
R422 VR.n317 VR.n303 2.66847
R423 VR.n246 VR.n244 2.5407
R424 VR.n239 VR.n234 2.5407
R425 VR.n404 VR.n399 2.5407
R426 VR.n257 VR.n255 2.5407
R427 VR.n264 VR.n262 2.5407
R428 VR.n301 VR.n296 2.5407
R429 VR.n258 VR.n257 2.51296
R430 VR.n265 VR.n264 2.51296
R431 VR.n61 VR.n242 2.42166
R432 VR.n76 VR.n319 2.42166
R433 VR.n82 VR.n253 2.42166
R434 VR.n85 VR.n260 2.42166
R435 VR.n94 VR.n324 2.42166
R436 VR.n97 VR.n329 2.42166
R437 VR.n100 VR.n334 2.42166
R438 VR.n127 VR.n391 2.42166
R439 VR.n130 VR.n386 2.42166
R440 VR.n133 VR.n381 2.42166
R441 VR.n136 VR.n377 2.42166
R442 VR.n16 VR.n374 2.38326
R443 VR.n16 VR.n370 2.38326
R444 VR.n16 VR.n365 2.38326
R445 VR.n16 VR.n361 2.38326
R446 VR.n55 VR.n356 2.38326
R447 VR.n55 VR.n352 2.38326
R448 VR.n143 VR.n347 2.38326
R449 VR.n143 VR.n343 2.38326
R450 VR.n242 VR.n63 2.35657
R451 VR.n319 VR.n78 2.35657
R452 VR.n253 VR.n84 2.35657
R453 VR.n260 VR.n87 2.35657
R454 VR.n324 VR.n96 2.35657
R455 VR.n329 VR.n99 2.35657
R456 VR.n334 VR.n102 2.35657
R457 VR.n391 VR.n129 2.35657
R458 VR.n386 VR.n132 2.35657
R459 VR.n381 VR.n135 2.35657
R460 VR.n377 VR.n138 2.35657
R461 VR.n246 VR.n245 2.28877
R462 VR.n239 VR.n238 2.28877
R463 VR.n404 VR.n403 2.28877
R464 VR.n257 VR.n256 2.28877
R465 VR.n264 VR.n263 2.28877
R466 VR.n301 VR.n300 2.28877
R467 VR.n142 VR.n37 2.24406
R468 VR.n395 VR.n394 1.94157
R469 VR.n15 VR.n14 0.0123767
R470 VR.n13 VR.n12 0.0123767
R471 VR.n11 VR.n10 0.0123767
R472 VR.n9 VR.n8 0.0123767
R473 VR.n7 VR.n6 0.0123767
R474 VR.n5 VR.n4 0.0123767
R475 VR.n3 VR.n2 0.0123767
R476 VR.n1 VR.n0 0.0123767
R477 VR.n39 VR.n286 1.73621
R478 VR.n40 VR.n273 1.73621
R479 VR.n32 VR.n14 1.58468
R480 VR.n32 VR.n12 1.58468
R481 VR.n34 VR.n10 1.58468
R482 VR.n34 VR.n8 1.58468
R483 VR.n36 VR.n6 1.58468
R484 VR.n36 VR.n4 1.58468
R485 VR.n38 VR.n2 1.58468
R486 VR.n38 VR.n0 1.58468
R487 VR.n263 VR.n28 1.52819
R488 VR.n286 VR.n285 1.38907
R489 VR.n273 VR.n272 1.38907
R490 VR.n40 VR.n279 1.38907
R491 VR.n39 VR.n292 1.38907
R492 VR.n405 VR.n404 1.32496
R493 VR.n302 VR.n301 1.32496
R494 VR.n229 VR.n173 1.27781
R495 VR.n229 VR.n175 1.27781
R496 VR.n223 VR.n176 1.27781
R497 VR.n223 VR.n178 1.27781
R498 VR.n315 VR.n179 1.27781
R499 VR.n315 VR.n181 1.27781
R500 VR.n309 VR.n182 1.27781
R501 VR.n309 VR.n184 1.27781
R502 VR.n24 VR.n147 1.21033
R503 VR.t205 VR.n23 2.39699
R504 VR.n244 VR.n148 1.2605
R505 VR.n161 VR.n243 1.2605
R506 VR.n238 VR.n185 1.2605
R507 VR.n201 VR.n237 1.2605
R508 VR.n234 VR.n186 1.2605
R509 VR.n202 VR.n233 1.2605
R510 VR.n403 VR.n187 1.2605
R511 VR.n203 VR.n402 1.2605
R512 VR.n399 VR.n188 1.2605
R513 VR.n204 VR.n398 1.2605
R514 VR.n321 VR.n149 1.2605
R515 VR.n162 VR.n320 1.2605
R516 VR.n251 VR.n189 1.2605
R517 VR.n205 VR.n250 1.2605
R518 VR.n27 VR.n150 1.21033
R519 VR.t144 VR.n26 2.39699
R520 VR.n255 VR.n151 1.2605
R521 VR.n163 VR.n254 1.2605
R522 VR.n30 VR.n152 1.21033
R523 VR.t217 VR.n29 2.39699
R524 VR.n262 VR.n153 1.2605
R525 VR.n164 VR.n261 1.2605
R526 VR.n300 VR.n190 1.2605
R527 VR.n206 VR.n299 1.2605
R528 VR.n296 VR.n191 1.2605
R529 VR.n207 VR.n295 1.2605
R530 VR.n326 VR.n154 1.2605
R531 VR.n165 VR.n325 1.2605
R532 VR.n331 VR.n155 1.2605
R533 VR.n166 VR.n330 1.2605
R534 VR.n336 VR.n156 1.2605
R535 VR.n167 VR.n335 1.2605
R536 VR.n374 VR.n192 1.2605
R537 VR.n208 VR.n373 1.2605
R538 VR.n370 VR.n193 1.2605
R539 VR.n209 VR.n369 1.2605
R540 VR.n365 VR.n194 1.2605
R541 VR.n210 VR.n364 1.2605
R542 VR.n361 VR.n195 1.2605
R543 VR.n211 VR.n360 1.2605
R544 VR.n356 VR.n196 1.2605
R545 VR.n212 VR.n355 1.2605
R546 VR.n352 VR.n197 1.2605
R547 VR.n213 VR.n351 1.2605
R548 VR.n347 VR.n198 1.2605
R549 VR.n214 VR.n346 1.2605
R550 VR.n343 VR.n199 1.2605
R551 VR.n215 VR.n342 1.2605
R552 VR.n393 VR.n157 1.2605
R553 VR.n168 VR.n392 1.2605
R554 VR.n388 VR.n158 1.2605
R555 VR.n169 VR.n387 1.2605
R556 VR.n383 VR.n159 1.2605
R557 VR.n170 VR.n382 1.2605
R558 VR.n379 VR.n160 1.2605
R559 VR.n171 VR.n378 1.2605
R560 VR.n410 VR.n200 1.2605
R561 VR.n216 VR.n409 1.2605
R562 VR.n200 VR.t41 1.25703
R563 VR.n199 VR.t109 1.25703
R564 VR.n198 VR.t121 1.25703
R565 VR.n197 VR.t19 1.25703
R566 VR.n196 VR.t4 1.25703
R567 VR.n195 VR.t184 1.25703
R568 VR.n194 VR.t81 1.25703
R569 VR.n193 VR.t65 1.25703
R570 VR.n192 VR.t164 1.25703
R571 VR.n191 VR.t117 1.25703
R572 VR.n190 VR.t215 1.25703
R573 VR.n189 VR.t151 1.25703
R574 VR.n188 VR.t132 1.25703
R575 VR.n187 VR.t138 1.25703
R576 VR.n186 VR.t134 1.25703
R577 VR.n185 VR.t203 1.25703
R578 VR.n216 VR.t41 1.25703
R579 VR.n215 VR.t109 1.25703
R580 VR.n214 VR.t121 1.25703
R581 VR.n213 VR.t19 1.25703
R582 VR.n212 VR.t4 1.25703
R583 VR.n211 VR.t184 1.25703
R584 VR.n210 VR.t81 1.25703
R585 VR.n209 VR.t65 1.25703
R586 VR.n208 VR.t164 1.25703
R587 VR.n207 VR.t117 1.25703
R588 VR.n206 VR.t215 1.25703
R589 VR.n205 VR.t151 1.25703
R590 VR.n204 VR.t132 1.25703
R591 VR.n203 VR.t138 1.25703
R592 VR.n202 VR.t134 1.25703
R593 VR.n201 VR.t203 1.25703
R594 VR.n160 VR.t23 1.25626
R595 VR.n159 VR.t10 1.25626
R596 VR.n158 VR.t57 1.25626
R597 VR.n157 VR.t166 1.25626
R598 VR.n156 VR.t89 1.25626
R599 VR.n155 VR.t186 1.25626
R600 VR.n154 VR.t119 1.25626
R601 VR.n153 VR.t115 1.25626
R602 VR.n152 VR.t217 1.25626
R603 VR.n151 VR.t200 1.25626
R604 VR.n150 VR.t144 1.25626
R605 VR.n149 VR.t103 1.25626
R606 VR.n148 VR.t136 1.25626
R607 VR.n147 VR.t205 1.25626
R608 VR.n171 VR.t23 1.25625
R609 VR.n170 VR.t10 1.25625
R610 VR.n169 VR.t57 1.25625
R611 VR.n168 VR.t166 1.25625
R612 VR.n167 VR.t89 1.25625
R613 VR.n166 VR.t186 1.25625
R614 VR.n165 VR.t119 1.25625
R615 VR.n164 VR.t115 1.25625
R616 VR.n163 VR.t200 1.25625
R617 VR.n162 VR.t103 1.25625
R618 VR.n161 VR.t136 1.25625
R619 VR.n225 VR.n173 1.08627
R620 VR.n225 VR.n175 1.08627
R621 VR.n219 VR.n176 1.08627
R622 VR.n219 VR.n178 1.08627
R623 VR.n311 VR.n179 1.08627
R624 VR.n311 VR.n181 1.08627
R625 VR.n305 VR.n182 1.08627
R626 VR.n305 VR.n184 1.08627
R627 VR.n245 VR.n24 0.02436
R628 VR.n244 VR.n61 1.07819
R629 VR.n244 VR.n63 1.07819
R630 VR.n321 VR.n76 1.07819
R631 VR.n321 VR.n78 1.07819
R632 VR.n256 VR.n27 0.02436
R633 VR.n255 VR.n82 1.07819
R634 VR.n255 VR.n84 1.07819
R635 VR.n263 VR.n30 0.02436
R636 VR.n262 VR.n85 1.07819
R637 VR.n262 VR.n87 1.07819
R638 VR.n326 VR.n94 1.07819
R639 VR.n326 VR.n96 1.07819
R640 VR.n331 VR.n97 1.07819
R641 VR.n331 VR.n99 1.07819
R642 VR.n336 VR.n100 1.07819
R643 VR.n336 VR.n102 1.07819
R644 VR.n393 VR.n127 1.07819
R645 VR.n393 VR.n129 1.07819
R646 VR.n388 VR.n130 1.07819
R647 VR.n388 VR.n132 1.07819
R648 VR.n383 VR.n133 1.07819
R649 VR.n383 VR.n135 1.07819
R650 VR.n379 VR.n136 1.07819
R651 VR.n379 VR.n138 1.07819
R652 VR.n24 VR.n23 2.49717
R653 VR.n27 VR.n26 2.49717
R654 VR.n30 VR.n29 2.49717
R655 VR.n256 VR.n25 1.52819
R656 VR.n245 VR.n22 1.52819
R657 VR.n375 VR.n16 1.2681
R658 VR.n21 VR.n20 1.00898
R659 VR.n19 VR.n18 1.00898
R660 VR.n55 VR.n143 0.917541
R661 VR.n16 VR.n55 0.917541
R662 VR.n238 VR.n64 0.916654
R663 VR.n238 VR.n66 0.916654
R664 VR.n234 VR.n67 0.916654
R665 VR.n234 VR.n69 0.916654
R666 VR.n403 VR.n70 0.916654
R667 VR.n403 VR.n72 0.916654
R668 VR.n399 VR.n73 0.916654
R669 VR.n399 VR.n75 0.916654
R670 VR.n251 VR.n79 0.916654
R671 VR.n251 VR.n81 0.916654
R672 VR.n300 VR.n88 0.916654
R673 VR.n300 VR.n90 0.916654
R674 VR.n296 VR.n91 0.916654
R675 VR.n296 VR.n93 0.916654
R676 VR.n374 VR.n103 0.916654
R677 VR.n374 VR.n105 0.916654
R678 VR.n370 VR.n106 0.916654
R679 VR.n370 VR.n108 0.916654
R680 VR.n365 VR.n109 0.916654
R681 VR.n365 VR.n111 0.916654
R682 VR.n361 VR.n112 0.916654
R683 VR.n361 VR.n114 0.916654
R684 VR.n356 VR.n115 0.916654
R685 VR.n356 VR.n117 0.916654
R686 VR.n352 VR.n118 0.916654
R687 VR.n352 VR.n120 0.916654
R688 VR.n347 VR.n121 0.916654
R689 VR.n347 VR.n123 0.916654
R690 VR.n343 VR.n124 0.916654
R691 VR.n343 VR.n126 0.916654
R692 VR.n410 VR.n139 0.916654
R693 VR.n410 VR.n141 0.916654
R694 VR.n143 VR.n142 0.855696
R695 VR.n141 VR.n140 0.844381
R696 VR.n407 VR.n139 0.844381
R697 VR.n126 VR.n125 0.844381
R698 VR.n340 VR.n124 0.844381
R699 VR.n123 VR.n122 0.844381
R700 VR.n344 VR.n121 0.844381
R701 VR.n120 VR.n119 0.844381
R702 VR.n349 VR.n118 0.844381
R703 VR.n117 VR.n116 0.844381
R704 VR.n353 VR.n115 0.844381
R705 VR.n114 VR.n113 0.844381
R706 VR.n358 VR.n112 0.844381
R707 VR.n111 VR.n110 0.844381
R708 VR.n362 VR.n109 0.844381
R709 VR.n108 VR.n107 0.844381
R710 VR.n367 VR.n106 0.844381
R711 VR.n105 VR.n104 0.844381
R712 VR.n371 VR.n103 0.844381
R713 VR.n93 VR.n92 0.844381
R714 VR.n293 VR.n91 0.844381
R715 VR.n90 VR.n89 0.844381
R716 VR.n297 VR.n88 0.844381
R717 VR.n81 VR.n80 0.844381
R718 VR.n248 VR.n79 0.844381
R719 VR.n75 VR.n74 0.844381
R720 VR.n396 VR.n73 0.844381
R721 VR.n72 VR.n71 0.844381
R722 VR.n400 VR.n70 0.844381
R723 VR.n69 VR.n68 0.844381
R724 VR.n231 VR.n67 0.844381
R725 VR.n66 VR.n65 0.844381
R726 VR.n235 VR.n64 0.844381
R727 VR.n243 VR.n61 0.805885
R728 VR.n243 VR.n63 0.805885
R729 VR.n320 VR.n76 0.805885
R730 VR.n320 VR.n78 0.805885
R731 VR.n254 VR.n82 0.805885
R732 VR.n254 VR.n84 0.805885
R733 VR.n261 VR.n85 0.805885
R734 VR.n261 VR.n87 0.805885
R735 VR.n325 VR.n94 0.805885
R736 VR.n325 VR.n96 0.805885
R737 VR.n330 VR.n97 0.805885
R738 VR.n330 VR.n99 0.805885
R739 VR.n335 VR.n100 0.805885
R740 VR.n335 VR.n102 0.805885
R741 VR.n392 VR.n127 0.805885
R742 VR.n392 VR.n129 0.805885
R743 VR.n387 VR.n130 0.805885
R744 VR.n387 VR.n132 0.805885
R745 VR.n382 VR.n133 0.805885
R746 VR.n382 VR.n135 0.805885
R747 VR.n378 VR.n136 0.805885
R748 VR.n378 VR.n138 0.805885
R749 VR.n18 VR.n146 0.781571
R750 VR.n20 VR.n145 0.781571
R751 VR.n406 VR.n405 0.7505
R752 VR.n303 VR.n302 0.7505
R753 VR.n172 VR.n144 0.748625
R754 VR.n339 VR.n38 0.741676
R755 VR.n339 VR.n37 0.741676
R756 VR.n348 VR.n36 0.741676
R757 VR.n348 VR.n35 0.741676
R758 VR.n357 VR.n34 0.741676
R759 VR.n357 VR.n33 0.741676
R760 VR.n366 VR.n32 0.741676
R761 VR.n366 VR.n31 0.741676
R762 VR.n138 VR.n137 0.721654
R763 VR.n376 VR.n136 0.721654
R764 VR.n135 VR.n134 0.721654
R765 VR.n380 VR.n133 0.721654
R766 VR.n132 VR.n131 0.721654
R767 VR.n385 VR.n130 0.721654
R768 VR.n129 VR.n128 0.721654
R769 VR.n390 VR.n127 0.721654
R770 VR.n102 VR.n101 0.721654
R771 VR.n333 VR.n100 0.721654
R772 VR.n99 VR.n98 0.721654
R773 VR.n328 VR.n97 0.721654
R774 VR.n96 VR.n95 0.721654
R775 VR.n323 VR.n94 0.721654
R776 VR.n87 VR.n86 0.721654
R777 VR.n259 VR.n85 0.721654
R778 VR.n84 VR.n83 0.721654
R779 VR.n252 VR.n82 0.721654
R780 VR.n78 VR.n77 0.721654
R781 VR.n318 VR.n76 0.721654
R782 VR.n63 VR.n62 0.721654
R783 VR.n241 VR.n61 0.721654
R784 VR.n184 VR.n183 0.715885
R785 VR.n307 VR.n182 0.715885
R786 VR.n181 VR.n180 0.715885
R787 VR.n313 VR.n179 0.715885
R788 VR.n178 VR.n177 0.715885
R789 VR.n221 VR.n176 0.715885
R790 VR.n175 VR.n174 0.715885
R791 VR.n227 VR.n173 0.715885
R792 VR.n288 VR.n287 0.694786
R793 VR.n289 VR.n288 0.694786
R794 VR.n290 VR.n289 0.694786
R795 VR.n291 VR.n290 0.694786
R796 VR.n292 VR.n291 0.694786
R797 VR.n285 VR.n284 0.694786
R798 VR.n284 VR.n283 0.694786
R799 VR.n283 VR.n282 0.694786
R800 VR.n282 VR.n281 0.694786
R801 VR.n281 VR.n280 0.694786
R802 VR.n275 VR.n274 0.694786
R803 VR.n276 VR.n275 0.694786
R804 VR.n277 VR.n276 0.694786
R805 VR.n278 VR.n277 0.694786
R806 VR.n279 VR.n278 0.694786
R807 VR.n272 VR.n271 0.694786
R808 VR.n271 VR.n270 0.694786
R809 VR.n270 VR.n269 0.694786
R810 VR.n269 VR.n268 0.694786
R811 VR.n268 VR.n267 0.694786
R812 VR.n60 VR.n59 0.694786
R813 VR.n338 VR.n59 0.694786
R814 VR.n58 VR.n57 0.694786
R815 VR.n57 VR.n56 0.694786
R816 VR.n54 VR.n53 0.694786
R817 VR.n53 VR.n52 0.694786
R818 VR.n51 VR.n50 0.694786
R819 VR.n50 VR.n49 0.694786
R820 VR.n48 VR.n47 0.694786
R821 VR.n46 VR.n45 0.694786
R822 VR.n44 VR.n43 0.694786
R823 VR.n42 VR.n41 0.694786
R824 VR.n317 VR.n316 0.6584
R825 VR.n237 VR.n64 0.644346
R826 VR.n237 VR.n66 0.644346
R827 VR.n233 VR.n67 0.644346
R828 VR.n233 VR.n69 0.644346
R829 VR.n402 VR.n70 0.644346
R830 VR.n402 VR.n72 0.644346
R831 VR.n398 VR.n73 0.644346
R832 VR.n398 VR.n75 0.644346
R833 VR.n250 VR.n79 0.644346
R834 VR.n250 VR.n81 0.644346
R835 VR.n299 VR.n88 0.644346
R836 VR.n299 VR.n90 0.644346
R837 VR.n295 VR.n91 0.644346
R838 VR.n295 VR.n93 0.644346
R839 VR.n373 VR.n103 0.644346
R840 VR.n373 VR.n105 0.644346
R841 VR.n369 VR.n106 0.644346
R842 VR.n369 VR.n108 0.644346
R843 VR.n364 VR.n109 0.644346
R844 VR.n364 VR.n111 0.644346
R845 VR.n360 VR.n112 0.644346
R846 VR.n360 VR.n114 0.644346
R847 VR.n355 VR.n115 0.644346
R848 VR.n355 VR.n117 0.644346
R849 VR.n351 VR.n118 0.644346
R850 VR.n351 VR.n120 0.644346
R851 VR.n346 VR.n121 0.644346
R852 VR.n346 VR.n123 0.644346
R853 VR.n342 VR.n124 0.644346
R854 VR.n342 VR.n126 0.644346
R855 VR.n409 VR.n139 0.644346
R856 VR.n409 VR.n141 0.644346
R857 VR.n228 VR.n224 0.6305
R858 VR.n229 VR.n224 0.6305
R859 VR.n228 VR.n226 0.6305
R860 VR.n226 VR.n225 0.6305
R861 VR.n222 VR.n218 0.6305
R862 VR.n223 VR.n218 0.6305
R863 VR.n222 VR.n220 0.6305
R864 VR.n220 VR.n219 0.6305
R865 VR.n314 VR.n310 0.6305
R866 VR.n315 VR.n310 0.6305
R867 VR.n314 VR.n312 0.6305
R868 VR.n312 VR.n311 0.6305
R869 VR.n308 VR.n304 0.6305
R870 VR.n309 VR.n304 0.6305
R871 VR.n308 VR.n306 0.6305
R872 VR.n306 VR.n305 0.6305
R873 VR.t98 VR.t96 0.618833
R874 VR.t49 VR.t47 0.618833
R875 VR.t72 VR.t70 0.618833
R876 VR.t38 VR.t36 0.618833
R877 VR.t193 VR.t88 0.618833
R878 VR.t86 VR.t84 0.618833
R879 VR.t80 VR.t191 0.618833
R880 VR.t108 VR.t130 0.618833
R881 VR.t128 VR.t126 0.618833
R882 VR.t124 VR.t112 0.618833
R883 VR.t62 VR.t173 0.618833
R884 VR.t171 VR.t169 0.618833
R885 VR.t163 VR.t60 0.618833
R886 VR.t9 VR.t30 0.618833
R887 VR.t28 VR.t26 0.618833
R888 VR.t22 VR.t13 0.618833
R889 VR.t194 VR.n15 224.025
R890 VR.t188 VR.n13 224.025
R891 VR.t113 VR.n11 224.025
R892 VR.t105 VR.n9 224.025
R893 VR.t63 VR.n7 224.025
R894 VR.t55 VR.n5 224.025
R895 VR.t14 VR.n3 224.025
R896 VR.t6 VR.n1 224.025
R897 a_4809_11960.t2 a_4809_11960.n18 32.0765
R898 a_4809_11960.n18 a_4809_11960.n1 6.3665
R899 a_4809_11960.n4 a_4809_11960.t17 5.74913
R900 a_4809_11960.n6 a_4809_11960.t11 5.74913
R901 a_4809_11960.n0 a_4809_11960.t25 5.71479
R902 a_4809_11960.n2 a_4809_11960.t3 5.71479
R903 a_4809_11960.n4 a_4809_11960.t33 5.05484
R904 a_4809_11960.n5 a_4809_11960.t16 5.05484
R905 a_4809_11960.n5 a_4809_11960.t21 5.05484
R906 a_4809_11960.n5 a_4809_11960.t4 5.05484
R907 a_4809_11960.n8 a_4809_11960.t18 5.05484
R908 a_4809_11960.n14 a_4809_11960.t28 5.05484
R909 a_4809_11960.n11 a_4809_11960.t34 5.05484
R910 a_4809_11960.n11 a_4809_11960.t32 5.05484
R911 a_4809_11960.n13 a_4809_11960.t31 5.05484
R912 a_4809_11960.n12 a_4809_11960.t23 5.05484
R913 a_4809_11960.n7 a_4809_11960.t6 5.05484
R914 a_4809_11960.n7 a_4809_11960.t27 5.05484
R915 a_4809_11960.n6 a_4809_11960.t10 5.05484
R916 a_4809_11960.n6 a_4809_11960.t15 5.05484
R917 a_4809_11960.n0 a_4809_11960.t29 5.0205
R918 a_4809_11960.n1 a_4809_11960.t12 5.0205
R919 a_4809_11960.n1 a_4809_11960.t20 5.0205
R920 a_4809_11960.n1 a_4809_11960.t24 5.0205
R921 a_4809_11960.n9 a_4809_11960.t22 5.0205
R922 a_4809_11960.n17 a_4809_11960.t13 5.0205
R923 a_4809_11960.n10 a_4809_11960.t8 5.0205
R924 a_4809_11960.n10 a_4809_11960.t7 5.0205
R925 a_4809_11960.n16 a_4809_11960.t14 5.0205
R926 a_4809_11960.n15 a_4809_11960.t19 5.0205
R927 a_4809_11960.n3 a_4809_11960.t9 5.0205
R928 a_4809_11960.n3 a_4809_11960.t30 5.0205
R929 a_4809_11960.n2 a_4809_11960.t26 5.0205
R930 a_4809_11960.n2 a_4809_11960.t5 5.0205
R931 a_4809_11960.n18 a_4809_11960.n5 4.6865
R932 a_4809_11960.t1 a_4809_11960.t2 4.5005
R933 a_4809_11960.t0 a_4809_11960.t1 3.2507
R934 a_4809_11960.n14 a_4809_11960.n11 1.73621
R935 a_4809_11960.n17 a_4809_11960.n10 1.73621
R936 a_4809_11960.n10 a_4809_11960.n16 1.38907
R937 a_4809_11960.n11 a_4809_11960.n13 1.38907
R938 a_4809_11960.n1 a_4809_11960.n9 1.38907
R939 a_4809_11960.n5 a_4809_11960.n8 1.38907
R940 a_4809_11960.n7 a_4809_11960.n6 1.38907
R941 a_4809_11960.n12 a_4809_11960.n7 1.38907
R942 a_4809_11960.n5 a_4809_11960.n4 1.38907
R943 a_4809_11960.n3 a_4809_11960.n2 1.38907
R944 a_4809_11960.n15 a_4809_11960.n3 1.38907
R945 a_4809_11960.n1 a_4809_11960.n0 1.38907
R946 a_4809_11960.n9 a_4809_11960.n17 1.04193
R947 a_4809_11960.n16 a_4809_11960.n15 1.04193
R948 a_4809_11960.n8 a_4809_11960.n14 1.04193
R949 a_4809_11960.n13 a_4809_11960.n12 1.04193
R950 a_4409_13109.n0 a_4409_13109.t85 99.9768
R951 a_4409_13109.n37 a_4409_13109.t156 99.9768
R952 a_4409_13109.n76 a_4409_13109.t13 96.1964
R953 a_4409_13109.n113 a_4409_13109.t84 96.1964
R954 a_4409_13109.n0 a_4409_13109.t86 88.3826
R955 a_4409_13109.n1 a_4409_13109.t87 88.3826
R956 a_4409_13109.n2 a_4409_13109.t88 88.3826
R957 a_4409_13109.n3 a_4409_13109.t89 88.3826
R958 a_4409_13109.n4 a_4409_13109.t90 88.3826
R959 a_4409_13109.n5 a_4409_13109.t91 88.3826
R960 a_4409_13109.n6 a_4409_13109.t92 88.3826
R961 a_4409_13109.n7 a_4409_13109.t93 88.3826
R962 a_4409_13109.n8 a_4409_13109.t94 88.3826
R963 a_4409_13109.n9 a_4409_13109.t95 88.3826
R964 a_4409_13109.n10 a_4409_13109.t96 88.3826
R965 a_4409_13109.n11 a_4409_13109.t97 88.3826
R966 a_4409_13109.n12 a_4409_13109.t98 88.3826
R967 a_4409_13109.n13 a_4409_13109.t99 88.3826
R968 a_4409_13109.n14 a_4409_13109.t100 88.3826
R969 a_4409_13109.n15 a_4409_13109.t101 88.3826
R970 a_4409_13109.n16 a_4409_13109.t102 88.3826
R971 a_4409_13109.n17 a_4409_13109.t103 88.3826
R972 a_4409_13109.n18 a_4409_13109.t104 88.3826
R973 a_4409_13109.n19 a_4409_13109.t105 88.3826
R974 a_4409_13109.n20 a_4409_13109.t106 88.3826
R975 a_4409_13109.n21 a_4409_13109.t107 88.3826
R976 a_4409_13109.n22 a_4409_13109.t108 88.3826
R977 a_4409_13109.n23 a_4409_13109.t109 88.3826
R978 a_4409_13109.n24 a_4409_13109.t110 88.3826
R979 a_4409_13109.n25 a_4409_13109.t111 88.3826
R980 a_4409_13109.n26 a_4409_13109.t112 88.3826
R981 a_4409_13109.n27 a_4409_13109.t113 88.3826
R982 a_4409_13109.n28 a_4409_13109.t114 88.3826
R983 a_4409_13109.n29 a_4409_13109.t4 88.3826
R984 a_4409_13109.n30 a_4409_13109.t3 88.3826
R985 a_4409_13109.n31 a_4409_13109.t115 88.3826
R986 a_4409_13109.n32 a_4409_13109.t116 88.3826
R987 a_4409_13109.n33 a_4409_13109.t117 88.3826
R988 a_4409_13109.n34 a_4409_13109.t118 88.3826
R989 a_4409_13109.n35 a_4409_13109.t119 88.3826
R990 a_4409_13109.n36 a_4409_13109.t120 88.3826
R991 a_4409_13109.n73 a_4409_13109.t121 88.3826
R992 a_4409_13109.n72 a_4409_13109.t122 88.3826
R993 a_4409_13109.n71 a_4409_13109.t123 88.3826
R994 a_4409_13109.n70 a_4409_13109.t124 88.3826
R995 a_4409_13109.n69 a_4409_13109.t125 88.3826
R996 a_4409_13109.n68 a_4409_13109.t126 88.3826
R997 a_4409_13109.n67 a_4409_13109.t2 88.3826
R998 a_4409_13109.n66 a_4409_13109.t0 88.3826
R999 a_4409_13109.n65 a_4409_13109.t127 88.3826
R1000 a_4409_13109.n64 a_4409_13109.t128 88.3826
R1001 a_4409_13109.n63 a_4409_13109.t129 88.3826
R1002 a_4409_13109.n62 a_4409_13109.t130 88.3826
R1003 a_4409_13109.n61 a_4409_13109.t131 88.3826
R1004 a_4409_13109.n60 a_4409_13109.t132 88.3826
R1005 a_4409_13109.n59 a_4409_13109.t133 88.3826
R1006 a_4409_13109.n58 a_4409_13109.t134 88.3826
R1007 a_4409_13109.n57 a_4409_13109.t135 88.3826
R1008 a_4409_13109.n56 a_4409_13109.t136 88.3826
R1009 a_4409_13109.n55 a_4409_13109.t137 88.3826
R1010 a_4409_13109.n54 a_4409_13109.t138 88.3826
R1011 a_4409_13109.n53 a_4409_13109.t139 88.3826
R1012 a_4409_13109.n52 a_4409_13109.t140 88.3826
R1013 a_4409_13109.n51 a_4409_13109.t141 88.3826
R1014 a_4409_13109.n50 a_4409_13109.t142 88.3826
R1015 a_4409_13109.n49 a_4409_13109.t143 88.3826
R1016 a_4409_13109.n48 a_4409_13109.t144 88.3826
R1017 a_4409_13109.n47 a_4409_13109.t145 88.3826
R1018 a_4409_13109.n46 a_4409_13109.t146 88.3826
R1019 a_4409_13109.n45 a_4409_13109.t147 88.3826
R1020 a_4409_13109.n44 a_4409_13109.t148 88.3826
R1021 a_4409_13109.n43 a_4409_13109.t149 88.3826
R1022 a_4409_13109.n42 a_4409_13109.t150 88.3826
R1023 a_4409_13109.n41 a_4409_13109.t151 88.3826
R1024 a_4409_13109.n40 a_4409_13109.t152 88.3826
R1025 a_4409_13109.n39 a_4409_13109.t153 88.3826
R1026 a_4409_13109.n38 a_4409_13109.t154 88.3826
R1027 a_4409_13109.n37 a_4409_13109.t155 88.3826
R1028 a_4409_13109.n76 a_4409_13109.t14 84.6023
R1029 a_4409_13109.n77 a_4409_13109.t15 84.6023
R1030 a_4409_13109.n78 a_4409_13109.t16 84.6023
R1031 a_4409_13109.n79 a_4409_13109.t17 84.6023
R1032 a_4409_13109.n80 a_4409_13109.t18 84.6023
R1033 a_4409_13109.n81 a_4409_13109.t19 84.6023
R1034 a_4409_13109.n82 a_4409_13109.t20 84.6023
R1035 a_4409_13109.n83 a_4409_13109.t21 84.6023
R1036 a_4409_13109.n84 a_4409_13109.t22 84.6023
R1037 a_4409_13109.n85 a_4409_13109.t23 84.6023
R1038 a_4409_13109.n86 a_4409_13109.t24 84.6023
R1039 a_4409_13109.n87 a_4409_13109.t25 84.6023
R1040 a_4409_13109.n88 a_4409_13109.t26 84.6023
R1041 a_4409_13109.n89 a_4409_13109.t27 84.6023
R1042 a_4409_13109.n90 a_4409_13109.t28 84.6023
R1043 a_4409_13109.n91 a_4409_13109.t29 84.6023
R1044 a_4409_13109.n92 a_4409_13109.t30 84.6023
R1045 a_4409_13109.n93 a_4409_13109.t31 84.6023
R1046 a_4409_13109.n94 a_4409_13109.t32 84.6023
R1047 a_4409_13109.n95 a_4409_13109.t33 84.6023
R1048 a_4409_13109.n96 a_4409_13109.t34 84.6023
R1049 a_4409_13109.n97 a_4409_13109.t35 84.6023
R1050 a_4409_13109.n98 a_4409_13109.t36 84.6023
R1051 a_4409_13109.n99 a_4409_13109.t37 84.6023
R1052 a_4409_13109.n100 a_4409_13109.t38 84.6023
R1053 a_4409_13109.n101 a_4409_13109.t39 84.6023
R1054 a_4409_13109.n102 a_4409_13109.t40 84.6023
R1055 a_4409_13109.n103 a_4409_13109.t41 84.6023
R1056 a_4409_13109.n104 a_4409_13109.t42 84.6023
R1057 a_4409_13109.n105 a_4409_13109.t10 84.6023
R1058 a_4409_13109.n106 a_4409_13109.t8 84.6023
R1059 a_4409_13109.n107 a_4409_13109.t43 84.6023
R1060 a_4409_13109.n108 a_4409_13109.t44 84.6023
R1061 a_4409_13109.n109 a_4409_13109.t45 84.6023
R1062 a_4409_13109.n110 a_4409_13109.t46 84.6023
R1063 a_4409_13109.n111 a_4409_13109.t47 84.6023
R1064 a_4409_13109.n112 a_4409_13109.t48 84.6023
R1065 a_4409_13109.n149 a_4409_13109.t49 84.6023
R1066 a_4409_13109.n148 a_4409_13109.t50 84.6023
R1067 a_4409_13109.n147 a_4409_13109.t51 84.6023
R1068 a_4409_13109.n146 a_4409_13109.t52 84.6023
R1069 a_4409_13109.n145 a_4409_13109.t53 84.6023
R1070 a_4409_13109.n144 a_4409_13109.t54 84.6023
R1071 a_4409_13109.n143 a_4409_13109.t7 84.6023
R1072 a_4409_13109.n142 a_4409_13109.t5 84.6023
R1073 a_4409_13109.n141 a_4409_13109.t55 84.6023
R1074 a_4409_13109.n140 a_4409_13109.t56 84.6023
R1075 a_4409_13109.n139 a_4409_13109.t57 84.6023
R1076 a_4409_13109.n138 a_4409_13109.t58 84.6023
R1077 a_4409_13109.n137 a_4409_13109.t59 84.6023
R1078 a_4409_13109.n136 a_4409_13109.t60 84.6023
R1079 a_4409_13109.n135 a_4409_13109.t61 84.6023
R1080 a_4409_13109.n134 a_4409_13109.t62 84.6023
R1081 a_4409_13109.n133 a_4409_13109.t63 84.6023
R1082 a_4409_13109.n132 a_4409_13109.t64 84.6023
R1083 a_4409_13109.n131 a_4409_13109.t65 84.6023
R1084 a_4409_13109.n130 a_4409_13109.t66 84.6023
R1085 a_4409_13109.n129 a_4409_13109.t67 84.6023
R1086 a_4409_13109.n128 a_4409_13109.t68 84.6023
R1087 a_4409_13109.n127 a_4409_13109.t69 84.6023
R1088 a_4409_13109.n126 a_4409_13109.t70 84.6023
R1089 a_4409_13109.n125 a_4409_13109.t71 84.6023
R1090 a_4409_13109.n124 a_4409_13109.t72 84.6023
R1091 a_4409_13109.n123 a_4409_13109.t73 84.6023
R1092 a_4409_13109.n122 a_4409_13109.t74 84.6023
R1093 a_4409_13109.n121 a_4409_13109.t75 84.6023
R1094 a_4409_13109.n120 a_4409_13109.t76 84.6023
R1095 a_4409_13109.n119 a_4409_13109.t77 84.6023
R1096 a_4409_13109.n118 a_4409_13109.t78 84.6023
R1097 a_4409_13109.n117 a_4409_13109.t79 84.6023
R1098 a_4409_13109.n116 a_4409_13109.t80 84.6023
R1099 a_4409_13109.n115 a_4409_13109.t81 84.6023
R1100 a_4409_13109.n114 a_4409_13109.t82 84.6023
R1101 a_4409_13109.n113 a_4409_13109.t83 84.6023
R1102 a_4409_13109.n151 a_4409_13109.n75 38.8625
R1103 a_4409_13109.t1 a_4409_13109.n152 16.3265
R1104 a_4409_13109.n152 a_4409_13109.n74 12.2976
R1105 a_4409_13109.n151 a_4409_13109.n150 11.6916
R1106 a_4409_13109.n114 a_4409_13109.n113 11.5946
R1107 a_4409_13109.n115 a_4409_13109.n114 11.5946
R1108 a_4409_13109.n116 a_4409_13109.n115 11.5946
R1109 a_4409_13109.n117 a_4409_13109.n116 11.5946
R1110 a_4409_13109.n118 a_4409_13109.n117 11.5946
R1111 a_4409_13109.n119 a_4409_13109.n118 11.5946
R1112 a_4409_13109.n120 a_4409_13109.n119 11.5946
R1113 a_4409_13109.n121 a_4409_13109.n120 11.5946
R1114 a_4409_13109.n122 a_4409_13109.n121 11.5946
R1115 a_4409_13109.n123 a_4409_13109.n122 11.5946
R1116 a_4409_13109.n124 a_4409_13109.n123 11.5946
R1117 a_4409_13109.n125 a_4409_13109.n124 11.5946
R1118 a_4409_13109.n126 a_4409_13109.n125 11.5946
R1119 a_4409_13109.n127 a_4409_13109.n126 11.5946
R1120 a_4409_13109.n128 a_4409_13109.n127 11.5946
R1121 a_4409_13109.n129 a_4409_13109.n128 11.5946
R1122 a_4409_13109.n130 a_4409_13109.n129 11.5946
R1123 a_4409_13109.n131 a_4409_13109.n130 11.5946
R1124 a_4409_13109.n132 a_4409_13109.n131 11.5946
R1125 a_4409_13109.n133 a_4409_13109.n132 11.5946
R1126 a_4409_13109.n134 a_4409_13109.n133 11.5946
R1127 a_4409_13109.n135 a_4409_13109.n134 11.5946
R1128 a_4409_13109.n136 a_4409_13109.n135 11.5946
R1129 a_4409_13109.n137 a_4409_13109.n136 11.5946
R1130 a_4409_13109.n138 a_4409_13109.n137 11.5946
R1131 a_4409_13109.n139 a_4409_13109.n138 11.5946
R1132 a_4409_13109.n140 a_4409_13109.n139 11.5946
R1133 a_4409_13109.n141 a_4409_13109.n140 11.5946
R1134 a_4409_13109.n142 a_4409_13109.n141 11.5946
R1135 a_4409_13109.n143 a_4409_13109.n142 11.5946
R1136 a_4409_13109.n144 a_4409_13109.n143 11.5946
R1137 a_4409_13109.n145 a_4409_13109.n144 11.5946
R1138 a_4409_13109.n146 a_4409_13109.n145 11.5946
R1139 a_4409_13109.n147 a_4409_13109.n146 11.5946
R1140 a_4409_13109.n148 a_4409_13109.n147 11.5946
R1141 a_4409_13109.n149 a_4409_13109.n148 11.5946
R1142 a_4409_13109.n112 a_4409_13109.n111 11.5946
R1143 a_4409_13109.n111 a_4409_13109.n110 11.5946
R1144 a_4409_13109.n110 a_4409_13109.n109 11.5946
R1145 a_4409_13109.n109 a_4409_13109.n108 11.5946
R1146 a_4409_13109.n108 a_4409_13109.n107 11.5946
R1147 a_4409_13109.n107 a_4409_13109.n106 11.5946
R1148 a_4409_13109.n106 a_4409_13109.n105 11.5946
R1149 a_4409_13109.n105 a_4409_13109.n104 11.5946
R1150 a_4409_13109.n104 a_4409_13109.n103 11.5946
R1151 a_4409_13109.n103 a_4409_13109.n102 11.5946
R1152 a_4409_13109.n102 a_4409_13109.n101 11.5946
R1153 a_4409_13109.n101 a_4409_13109.n100 11.5946
R1154 a_4409_13109.n100 a_4409_13109.n99 11.5946
R1155 a_4409_13109.n99 a_4409_13109.n98 11.5946
R1156 a_4409_13109.n98 a_4409_13109.n97 11.5946
R1157 a_4409_13109.n97 a_4409_13109.n96 11.5946
R1158 a_4409_13109.n96 a_4409_13109.n95 11.5946
R1159 a_4409_13109.n95 a_4409_13109.n94 11.5946
R1160 a_4409_13109.n94 a_4409_13109.n93 11.5946
R1161 a_4409_13109.n93 a_4409_13109.n92 11.5946
R1162 a_4409_13109.n92 a_4409_13109.n91 11.5946
R1163 a_4409_13109.n91 a_4409_13109.n90 11.5946
R1164 a_4409_13109.n90 a_4409_13109.n89 11.5946
R1165 a_4409_13109.n89 a_4409_13109.n88 11.5946
R1166 a_4409_13109.n88 a_4409_13109.n87 11.5946
R1167 a_4409_13109.n87 a_4409_13109.n86 11.5946
R1168 a_4409_13109.n86 a_4409_13109.n85 11.5946
R1169 a_4409_13109.n85 a_4409_13109.n84 11.5946
R1170 a_4409_13109.n84 a_4409_13109.n83 11.5946
R1171 a_4409_13109.n83 a_4409_13109.n82 11.5946
R1172 a_4409_13109.n82 a_4409_13109.n81 11.5946
R1173 a_4409_13109.n81 a_4409_13109.n80 11.5946
R1174 a_4409_13109.n80 a_4409_13109.n79 11.5946
R1175 a_4409_13109.n79 a_4409_13109.n78 11.5946
R1176 a_4409_13109.n78 a_4409_13109.n77 11.5946
R1177 a_4409_13109.n77 a_4409_13109.n76 11.5946
R1178 a_4409_13109.n38 a_4409_13109.n37 11.5946
R1179 a_4409_13109.n39 a_4409_13109.n38 11.5946
R1180 a_4409_13109.n40 a_4409_13109.n39 11.5946
R1181 a_4409_13109.n41 a_4409_13109.n40 11.5946
R1182 a_4409_13109.n42 a_4409_13109.n41 11.5946
R1183 a_4409_13109.n43 a_4409_13109.n42 11.5946
R1184 a_4409_13109.n44 a_4409_13109.n43 11.5946
R1185 a_4409_13109.n45 a_4409_13109.n44 11.5946
R1186 a_4409_13109.n46 a_4409_13109.n45 11.5946
R1187 a_4409_13109.n47 a_4409_13109.n46 11.5946
R1188 a_4409_13109.n48 a_4409_13109.n47 11.5946
R1189 a_4409_13109.n49 a_4409_13109.n48 11.5946
R1190 a_4409_13109.n50 a_4409_13109.n49 11.5946
R1191 a_4409_13109.n51 a_4409_13109.n50 11.5946
R1192 a_4409_13109.n52 a_4409_13109.n51 11.5946
R1193 a_4409_13109.n53 a_4409_13109.n52 11.5946
R1194 a_4409_13109.n54 a_4409_13109.n53 11.5946
R1195 a_4409_13109.n55 a_4409_13109.n54 11.5946
R1196 a_4409_13109.n56 a_4409_13109.n55 11.5946
R1197 a_4409_13109.n57 a_4409_13109.n56 11.5946
R1198 a_4409_13109.n58 a_4409_13109.n57 11.5946
R1199 a_4409_13109.n59 a_4409_13109.n58 11.5946
R1200 a_4409_13109.n60 a_4409_13109.n59 11.5946
R1201 a_4409_13109.n61 a_4409_13109.n60 11.5946
R1202 a_4409_13109.n62 a_4409_13109.n61 11.5946
R1203 a_4409_13109.n63 a_4409_13109.n62 11.5946
R1204 a_4409_13109.n64 a_4409_13109.n63 11.5946
R1205 a_4409_13109.n65 a_4409_13109.n64 11.5946
R1206 a_4409_13109.n66 a_4409_13109.n65 11.5946
R1207 a_4409_13109.n67 a_4409_13109.n66 11.5946
R1208 a_4409_13109.n68 a_4409_13109.n67 11.5946
R1209 a_4409_13109.n69 a_4409_13109.n68 11.5946
R1210 a_4409_13109.n70 a_4409_13109.n69 11.5946
R1211 a_4409_13109.n71 a_4409_13109.n70 11.5946
R1212 a_4409_13109.n72 a_4409_13109.n71 11.5946
R1213 a_4409_13109.n73 a_4409_13109.n72 11.5946
R1214 a_4409_13109.n36 a_4409_13109.n35 11.5946
R1215 a_4409_13109.n35 a_4409_13109.n34 11.5946
R1216 a_4409_13109.n34 a_4409_13109.n33 11.5946
R1217 a_4409_13109.n33 a_4409_13109.n32 11.5946
R1218 a_4409_13109.n32 a_4409_13109.n31 11.5946
R1219 a_4409_13109.n31 a_4409_13109.n30 11.5946
R1220 a_4409_13109.n30 a_4409_13109.n29 11.5946
R1221 a_4409_13109.n29 a_4409_13109.n28 11.5946
R1222 a_4409_13109.n28 a_4409_13109.n27 11.5946
R1223 a_4409_13109.n27 a_4409_13109.n26 11.5946
R1224 a_4409_13109.n26 a_4409_13109.n25 11.5946
R1225 a_4409_13109.n25 a_4409_13109.n24 11.5946
R1226 a_4409_13109.n24 a_4409_13109.n23 11.5946
R1227 a_4409_13109.n23 a_4409_13109.n22 11.5946
R1228 a_4409_13109.n22 a_4409_13109.n21 11.5946
R1229 a_4409_13109.n21 a_4409_13109.n20 11.5946
R1230 a_4409_13109.n20 a_4409_13109.n19 11.5946
R1231 a_4409_13109.n19 a_4409_13109.n18 11.5946
R1232 a_4409_13109.n18 a_4409_13109.n17 11.5946
R1233 a_4409_13109.n17 a_4409_13109.n16 11.5946
R1234 a_4409_13109.n16 a_4409_13109.n15 11.5946
R1235 a_4409_13109.n15 a_4409_13109.n14 11.5946
R1236 a_4409_13109.n14 a_4409_13109.n13 11.5946
R1237 a_4409_13109.n13 a_4409_13109.n12 11.5946
R1238 a_4409_13109.n12 a_4409_13109.n11 11.5946
R1239 a_4409_13109.n11 a_4409_13109.n10 11.5946
R1240 a_4409_13109.n10 a_4409_13109.n9 11.5946
R1241 a_4409_13109.n9 a_4409_13109.n8 11.5946
R1242 a_4409_13109.n8 a_4409_13109.n7 11.5946
R1243 a_4409_13109.n7 a_4409_13109.n6 11.5946
R1244 a_4409_13109.n6 a_4409_13109.n5 11.5946
R1245 a_4409_13109.n5 a_4409_13109.n4 11.5946
R1246 a_4409_13109.n4 a_4409_13109.n3 11.5946
R1247 a_4409_13109.n3 a_4409_13109.n2 11.5946
R1248 a_4409_13109.n2 a_4409_13109.n1 11.5946
R1249 a_4409_13109.n1 a_4409_13109.n0 11.5946
R1250 a_4409_13109.t6 a_4409_13109.t1 6.5765
R1251 a_4409_13109.n150 a_4409_13109.n149 5.79756
R1252 a_4409_13109.n150 a_4409_13109.n112 5.79756
R1253 a_4409_13109.n74 a_4409_13109.n73 5.79756
R1254 a_4409_13109.n74 a_4409_13109.n36 5.79756
R1255 a_4409_13109.t9 a_4409_13109.t6 5.58517
R1256 a_4409_13109.n75 a_4409_13109.t12 3.21818
R1257 a_4409_13109.n75 a_4409_13109.t11 3.08318
R1258 a_4409_13109.n152 a_4409_13109.n151 1.4465
R1259 a_22469_13109.n31 a_22469_13109.t34 99.9768
R1260 a_22469_13109.n46 a_22469_13109.t65 99.9768
R1261 a_22469_13109.n0 a_22469_13109.t2 96.1964
R1262 a_22469_13109.n15 a_22469_13109.t33 96.1964
R1263 a_22469_13109.n31 a_22469_13109.t35 88.3826
R1264 a_22469_13109.n32 a_22469_13109.t36 88.3826
R1265 a_22469_13109.n33 a_22469_13109.t37 88.3826
R1266 a_22469_13109.n34 a_22469_13109.t38 88.3826
R1267 a_22469_13109.n35 a_22469_13109.t39 88.3826
R1268 a_22469_13109.n36 a_22469_13109.t40 88.3826
R1269 a_22469_13109.n37 a_22469_13109.t41 88.3826
R1270 a_22469_13109.n38 a_22469_13109.t42 88.3826
R1271 a_22469_13109.n39 a_22469_13109.t43 88.3826
R1272 a_22469_13109.n40 a_22469_13109.t44 88.3826
R1273 a_22469_13109.n41 a_22469_13109.t45 88.3826
R1274 a_22469_13109.n42 a_22469_13109.t46 88.3826
R1275 a_22469_13109.n43 a_22469_13109.t47 88.3826
R1276 a_22469_13109.n44 a_22469_13109.t48 88.3826
R1277 a_22469_13109.n45 a_22469_13109.t49 88.3826
R1278 a_22469_13109.n60 a_22469_13109.t50 88.3826
R1279 a_22469_13109.n59 a_22469_13109.t51 88.3826
R1280 a_22469_13109.n58 a_22469_13109.t52 88.3826
R1281 a_22469_13109.n57 a_22469_13109.t53 88.3826
R1282 a_22469_13109.n56 a_22469_13109.t54 88.3826
R1283 a_22469_13109.n55 a_22469_13109.t55 88.3826
R1284 a_22469_13109.n54 a_22469_13109.t56 88.3826
R1285 a_22469_13109.n53 a_22469_13109.t57 88.3826
R1286 a_22469_13109.n52 a_22469_13109.t58 88.3826
R1287 a_22469_13109.n51 a_22469_13109.t59 88.3826
R1288 a_22469_13109.n50 a_22469_13109.t60 88.3826
R1289 a_22469_13109.n49 a_22469_13109.t61 88.3826
R1290 a_22469_13109.n48 a_22469_13109.t62 88.3826
R1291 a_22469_13109.n47 a_22469_13109.t63 88.3826
R1292 a_22469_13109.n46 a_22469_13109.t64 88.3826
R1293 a_22469_13109.n0 a_22469_13109.t3 84.6023
R1294 a_22469_13109.n1 a_22469_13109.t4 84.6023
R1295 a_22469_13109.n2 a_22469_13109.t5 84.6023
R1296 a_22469_13109.n3 a_22469_13109.t6 84.6023
R1297 a_22469_13109.n4 a_22469_13109.t7 84.6023
R1298 a_22469_13109.n5 a_22469_13109.t8 84.6023
R1299 a_22469_13109.n6 a_22469_13109.t9 84.6023
R1300 a_22469_13109.n7 a_22469_13109.t10 84.6023
R1301 a_22469_13109.n8 a_22469_13109.t11 84.6023
R1302 a_22469_13109.n9 a_22469_13109.t12 84.6023
R1303 a_22469_13109.n10 a_22469_13109.t13 84.6023
R1304 a_22469_13109.n11 a_22469_13109.t14 84.6023
R1305 a_22469_13109.n12 a_22469_13109.t15 84.6023
R1306 a_22469_13109.n13 a_22469_13109.t16 84.6023
R1307 a_22469_13109.n14 a_22469_13109.t17 84.6023
R1308 a_22469_13109.n29 a_22469_13109.t18 84.6023
R1309 a_22469_13109.n28 a_22469_13109.t19 84.6023
R1310 a_22469_13109.n27 a_22469_13109.t20 84.6023
R1311 a_22469_13109.n26 a_22469_13109.t21 84.6023
R1312 a_22469_13109.n25 a_22469_13109.t22 84.6023
R1313 a_22469_13109.n24 a_22469_13109.t23 84.6023
R1314 a_22469_13109.n23 a_22469_13109.t24 84.6023
R1315 a_22469_13109.n22 a_22469_13109.t25 84.6023
R1316 a_22469_13109.n21 a_22469_13109.t26 84.6023
R1317 a_22469_13109.n20 a_22469_13109.t27 84.6023
R1318 a_22469_13109.n19 a_22469_13109.t28 84.6023
R1319 a_22469_13109.n18 a_22469_13109.t29 84.6023
R1320 a_22469_13109.n17 a_22469_13109.t30 84.6023
R1321 a_22469_13109.n16 a_22469_13109.t31 84.6023
R1322 a_22469_13109.n15 a_22469_13109.t32 84.6023
R1323 a_22469_13109.t0 a_22469_13109.n62 36.2525
R1324 a_22469_13109.t1 a_22469_13109.t0 17.4124
R1325 a_22469_13109.n16 a_22469_13109.n15 11.5946
R1326 a_22469_13109.n17 a_22469_13109.n16 11.5946
R1327 a_22469_13109.n18 a_22469_13109.n17 11.5946
R1328 a_22469_13109.n19 a_22469_13109.n18 11.5946
R1329 a_22469_13109.n20 a_22469_13109.n19 11.5946
R1330 a_22469_13109.n21 a_22469_13109.n20 11.5946
R1331 a_22469_13109.n22 a_22469_13109.n21 11.5946
R1332 a_22469_13109.n23 a_22469_13109.n22 11.5946
R1333 a_22469_13109.n24 a_22469_13109.n23 11.5946
R1334 a_22469_13109.n25 a_22469_13109.n24 11.5946
R1335 a_22469_13109.n26 a_22469_13109.n25 11.5946
R1336 a_22469_13109.n27 a_22469_13109.n26 11.5946
R1337 a_22469_13109.n28 a_22469_13109.n27 11.5946
R1338 a_22469_13109.n29 a_22469_13109.n28 11.5946
R1339 a_22469_13109.n14 a_22469_13109.n13 11.5946
R1340 a_22469_13109.n13 a_22469_13109.n12 11.5946
R1341 a_22469_13109.n12 a_22469_13109.n11 11.5946
R1342 a_22469_13109.n11 a_22469_13109.n10 11.5946
R1343 a_22469_13109.n10 a_22469_13109.n9 11.5946
R1344 a_22469_13109.n9 a_22469_13109.n8 11.5946
R1345 a_22469_13109.n8 a_22469_13109.n7 11.5946
R1346 a_22469_13109.n7 a_22469_13109.n6 11.5946
R1347 a_22469_13109.n6 a_22469_13109.n5 11.5946
R1348 a_22469_13109.n5 a_22469_13109.n4 11.5946
R1349 a_22469_13109.n4 a_22469_13109.n3 11.5946
R1350 a_22469_13109.n3 a_22469_13109.n2 11.5946
R1351 a_22469_13109.n2 a_22469_13109.n1 11.5946
R1352 a_22469_13109.n1 a_22469_13109.n0 11.5946
R1353 a_22469_13109.n47 a_22469_13109.n46 11.5946
R1354 a_22469_13109.n48 a_22469_13109.n47 11.5946
R1355 a_22469_13109.n49 a_22469_13109.n48 11.5946
R1356 a_22469_13109.n50 a_22469_13109.n49 11.5946
R1357 a_22469_13109.n51 a_22469_13109.n50 11.5946
R1358 a_22469_13109.n52 a_22469_13109.n51 11.5946
R1359 a_22469_13109.n53 a_22469_13109.n52 11.5946
R1360 a_22469_13109.n54 a_22469_13109.n53 11.5946
R1361 a_22469_13109.n55 a_22469_13109.n54 11.5946
R1362 a_22469_13109.n56 a_22469_13109.n55 11.5946
R1363 a_22469_13109.n57 a_22469_13109.n56 11.5946
R1364 a_22469_13109.n58 a_22469_13109.n57 11.5946
R1365 a_22469_13109.n59 a_22469_13109.n58 11.5946
R1366 a_22469_13109.n60 a_22469_13109.n59 11.5946
R1367 a_22469_13109.n45 a_22469_13109.n44 11.5946
R1368 a_22469_13109.n44 a_22469_13109.n43 11.5946
R1369 a_22469_13109.n43 a_22469_13109.n42 11.5946
R1370 a_22469_13109.n42 a_22469_13109.n41 11.5946
R1371 a_22469_13109.n41 a_22469_13109.n40 11.5946
R1372 a_22469_13109.n40 a_22469_13109.n39 11.5946
R1373 a_22469_13109.n39 a_22469_13109.n38 11.5946
R1374 a_22469_13109.n38 a_22469_13109.n37 11.5946
R1375 a_22469_13109.n37 a_22469_13109.n36 11.5946
R1376 a_22469_13109.n36 a_22469_13109.n35 11.5946
R1377 a_22469_13109.n35 a_22469_13109.n34 11.5946
R1378 a_22469_13109.n34 a_22469_13109.n33 11.5946
R1379 a_22469_13109.n33 a_22469_13109.n32 11.5946
R1380 a_22469_13109.n32 a_22469_13109.n31 11.5946
R1381 a_22469_13109.n62 a_22469_13109.n30 8.60227
R1382 a_22469_13109.n62 a_22469_13109.n61 6.52627
R1383 a_22469_13109.n30 a_22469_13109.n29 5.79756
R1384 a_22469_13109.n30 a_22469_13109.n14 5.79756
R1385 a_22469_13109.n61 a_22469_13109.n60 5.79756
R1386 a_22469_13109.n61 a_22469_13109.n45 5.79756
C510 VCTRL VSS 12.3128f
C511 B1 VSS 28.176f
C512 B0 VSS 18.9205f
C513 LOIN VSS 14.2045f
C514 LOIP VSS 15.2047f
C515 LOQN VSS 15.526f
C516 LOQP VSS 26.3688f
C517 VDD VSS 0.44752p
C518 VR VSS 0.55745p
C519 a_33780_3486# VSS 0.88455f ; **FLOATING
C520 a_33360_3486# VSS 0.85051f ; **FLOATING
C521 a_32940_1364# VSS 0.84806f ; **FLOATING
C522 a_32520_1364# VSS 0.85293f ; **FLOATING
C523 a_32100_3486# VSS 0.85871f ; **FLOATING
C524 a_31680_3486# VSS 0.85051f ; **FLOATING
C525 a_31260_1364# VSS 0.8637f ; **FLOATING
C526 a_30840_1364# VSS 0.85197f ; **FLOATING
C527 a_30420_3486# VSS 0.85871f ; **FLOATING
C528 a_30000_3486# VSS 0.85051f ; **FLOATING
C529 a_29580_1364# VSS 0.86466f ; **FLOATING
C530 a_29160_1364# VSS 0.851f ; **FLOATING
C531 a_28740_3486# VSS 0.85871f ; **FLOATING
C532 a_28320_3486# VSS 0.85051f ; **FLOATING
C533 a_27900_1364# VSS 0.86484f ; **FLOATING
C534 a_27480_1364# VSS 0.85048f ; **FLOATING
C535 a_27060_3486# VSS 0.85871f ; **FLOATING
C536 a_26640_3486# VSS 0.8665f ; **FLOATING
C537 a_22796_1120# VSS 1.02722f
C538 a_21840_1180# VSS 1.78228f ; **FLOATING
C539 a_21680_1120# VSS 1.029f
C540 a_37814_14482# VSS 0.24128f ; **FLOATING
C541 a_37404_14482# VSS 0.25327f ; **FLOATING
C542 a_31654_14482# VSS 0.24128f
C543 a_31244_14482# VSS 0.25327f ; **FLOATING
C544 a_27716_11900# VSS 0.12095f
C545 a_22284_11900# VSS 0.12095f
C546 a_27716_13271# VSS 0.1189f
C547 a_22284_13271# VSS 0.1189f
C548 a_20924_11900# VSS 0.12306f
C549 a_18084_11900# VSS 0.12306f
C550 a_16784_11900# VSS 0.12095f
C551 a_4224_11900# VSS 0.12095f
C552 a_16784_13271# VSS 0.1189f
C553 a_8697_11960# VSS 1.67063f ; **FLOATING
C554 a_4224_13271# VSS 0.1189f
C555 a_37814_18340# VSS 0.04368f
C556 a_37404_18340# VSS 0.04368f
C557 a_31654_18340# VSS 0.04368f
C558 a_18269_13109# VSS 7.43216f ; **FLOATING
C559 a_31244_18340# VSS 0.04368f
C560 a_40894_26942# VSS 0.24128f
C561 a_40484_26942# VSS 0.25327f ; **FLOATING
C562 a_34734_26942# VSS 0.24358f
C563 a_34324_26942# VSS 0.25159f ; **FLOATING
C564 a_33054_26942# VSS 0.24107f
C565 a_32644_26942# VSS 0.25284f ; **FLOATING
C566 a_26894_26942# VSS 0.24295f
C567 a_26484_26942# VSS 0.25159f ; **FLOATING
C568 a_25214_26942# VSS 0.24107f
C569 a_24804_26942# VSS 0.25284f ; **FLOATING
C570 a_19054_26600# VSS 0.39439f
C571 a_18644_26600# VSS 0.40738f ; **FLOATING
C572 a_17374_26600# VSS 0.38401f
C573 a_17080_26660# VSS 0.96614f ; **FLOATING
C574 a_16964_26600# VSS 0.38539f
C575 a_10816_26600# VSS 0.58235f ; **FLOATING
C576 a_10244_26600# VSS 0.58122f ; **FLOATING
C577 a_4096_26600# VSS 0.58235f ; **FLOATING
C578 a_3524_26600# VSS 0.58122f ; **FLOATING
C579 a_40894_30800# VSS 0.04368f
C580 a_40745_27002# VSS 3.2584f ; **FLOATING
C581 a_40484_30800# VSS 0.04368f
C582 a_34734_30800# VSS 0.07326f
C583 a_34324_30800# VSS 0.07326f
C584 a_26640_1364# VSS 16.1376f ; **FLOATING
C585 a_33054_30800# VSS 0.07326f
C586 a_32905_30860# VSS 0.53402f ; **FLOATING
C587 a_32644_30800# VSS 0.07326f
C588 a_26894_30800# VSS 0.07326f
C589 a_26484_30800# VSS 0.07326f
C590 a_25214_30800# VSS 0.07326f
C591 a_25065_30860# VSS 0.53402f ; **FLOATING
C592 a_24804_30800# VSS 0.07326f
C593 a_19054_30660# VSS 0.04368f
C594 a_18644_30660# VSS 0.04368f
C595 a_17374_30660# VSS 0.04368f
C596 a_17225_26660# VSS 19.6417f ; **FLOATING
C597 a_16964_30660# VSS 0.04368f
C598 a_11140_30800# VSS 0.07989f
C599 a_10244_30800# VSS 0.07989f
C600 a_4420_30800# VSS 0.07989f
C601 a_3524_30800# VSS 0.07989f
C602 a_31654_39340# VSS 0.39203f
C603 a_31244_39340# VSS 0.41056f ; **FLOATING
C604 a_25494_39340# VSS 0.39203f
C605 a_25084_39340# VSS 0.41056f ; **FLOATING
C606 a_19334_39340# VSS 0.39203f
C607 a_18924_39340# VSS 0.41056f ; **FLOATING
C608 a_13174_39340# VSS 0.39203f
C609 a_12764_39340# VSS 0.41056f ; **FLOATING
C610 a_31654_43400# VSS 0.07326f
C611 a_18787_27249# VSS 19.9004f ; **FLOATING
C612 a_31244_43400# VSS 0.07326f
C613 a_25494_43400# VSS 0.07326f
C614 a_17107_27249# VSS 16.8842f ; **FLOATING
C615 a_25084_43400# VSS 0.07326f
C616 a_19334_43400# VSS 0.07326f
C617 a_10429_27389# VSS 15.7512f ; **FLOATING
C618 a_18924_43400# VSS 0.07326f
C619 a_13174_43400# VSS 0.07326f
C620 a_3709_27389# VSS 15.4324f ; **FLOATING
C621 a_12764_43400# VSS 0.07326f
C622 a_34874_52282# VSS 0.24358f
C623 a_34464_52282# VSS 0.25096f ; **FLOATING
C624 a_33194_52282# VSS 0.24358f
C625 a_32784_52282# VSS 0.25096f ; **FLOATING
C626 a_31440_52179# VSS 0.73261f
C627 a_30544_52179# VSS 0.73101f
C628 a_29274_52282# VSS 0.24358f
C629 a_28864_52282# VSS 0.25096f ; **FLOATING
C630 a_27594_52282# VSS 0.24358f
C631 a_27184_52282# VSS 0.25096f ; **FLOATING
C632 a_25840_52179# VSS 0.73261f
C633 a_24944_52179# VSS 0.72843f
C634 a_23600_51940# VSS 0.7409f
C635 a_22704_51940# VSS 0.74598f
C636 a_21434_52282# VSS 0.24358f
C637 a_21024_52282# VSS 0.25096f ; **FLOATING
C638 a_19754_52282# VSS 0.24358f
C639 a_19344_52282# VSS 0.25096f ; **FLOATING
C640 a_18000_52179# VSS 0.73261f
C641 a_17104_52179# VSS 0.72786f
C642 a_15834_52282# VSS 0.24358f
C643 a_15424_52282# VSS 0.25096f
C644 a_14154_52282# VSS 0.24181f
C645 a_13744_52282# VSS 0.25096f
C646 a_12400_52179# VSS 0.73101f
C647 a_11504_52179# VSS 0.72925f
C648 a_10160_52179# VSS 0.72785f
C649 a_9264_52179# VSS 0.73261f ; **FLOATING
C650 a_9449_53149# VSS 27.0797f ; **FLOATING
C651 a_32634_56560# VSS 0.04368f
C652 a_32224_56560# VSS 0.04368f
C653 a_30954_56560# VSS 0.04368f
C654 a_30544_56560# VSS 0.04368f
C655 a_29288_56799# VSS 0.07763f
C656 a_27744_56799# VSS 0.07763f
C657 a_26474_56560# VSS 0.04368f
C658 a_26064_56560# VSS 0.04368f
C659 a_24794_56560# VSS 0.04368f
C660 a_24384_56560# VSS 0.04368f
C661 a_23128_56799# VSS 0.07763f
C662 a_22169_56859# VSS 16.2461f ; **FLOATING
C663 a_9849_52239# VSS 18.2297f ; **FLOATING
C664 a_21584_56799# VSS 0.07763f
C665 a_20314_56560# VSS 0.04368f
C666 a_19904_56560# VSS 0.04368f
C667 a_18634_56560# VSS 0.04368f
C668 a_18224_56560# VSS 0.04368f
C669 a_16968_56799# VSS 0.07763f
C670 a_15424_56799# VSS 0.07763f
C671 a_14154_56560# VSS 0.04368f
C672 a_13744_56560# VSS 0.04368f
C673 a_12474_56560# VSS 0.04368f
C674 a_12064_56560# VSS 0.04368f
C675 a_10808_56799# VSS 0.07763f
C676 a_9849_56859# VSS 18.7292f ; **FLOATING
C677 a_9525_52239# VSS 18.339f ; **FLOATING
C678 a_9264_56799# VSS 0.07763f
C679 a_31654_65240# VSS 0.39203f
C680 a_31244_65240# VSS 0.41056f ; **FLOATING
C681 a_25494_65240# VSS 0.39203f
C682 a_25084_65240# VSS 0.41056f ; **FLOATING
C683 a_19334_65240# VSS 0.39203f
C684 a_18924_65240# VSS 0.41056f ; **FLOATING
C685 a_13174_65240# VSS 0.39203f
C686 a_12764_65240# VSS 0.41056f ; **FLOATING
C687 a_31654_69300# VSS 0.07326f
C688 a_31244_69300# VSS 0.07326f
C689 a_15933_56649# VSS 17.0629f ; **FLOATING
C690 a_25494_69300# VSS 0.07326f
C691 a_25084_69300# VSS 0.07326f
C692 a_15609_57629# VSS 18.1728f ; **FLOATING
C693 a_19334_69300# VSS 0.07326f
C694 a_18924_69300# VSS 0.07326f
C695 a_9449_57629# VSS 17.2235f ; **FLOATING
C696 a_13174_69300# VSS 0.07326f
C697 a_12764_69300# VSS 0.07326f
C698 a_9773_56649# VSS 20.2922f ; **FLOATING
C699 a_40894_78182# VSS 0.24128f
C700 a_40484_78182# VSS 0.25327f ; **FLOATING
C701 a_34734_77840# VSS 0.39521f
C702 a_34324_77840# VSS 0.4082f ; **FLOATING
C703 a_33054_77840# VSS 0.38483f
C704 a_32760_77900# VSS 1.15362f ; **FLOATING
C705 a_32644_77840# VSS 0.38539f
C706 a_26894_78182# VSS 0.24358f
C707 a_26484_78182# VSS 0.2518f ; **FLOATING
C708 a_25214_78182# VSS 0.24128f
C709 a_24804_78182# VSS 0.25327f ; **FLOATING
C710 a_19054_77840# VSS 0.39521f
C711 a_18644_77840# VSS 0.4082f ; **FLOATING
C712 a_17374_77840# VSS 0.38483f
C713 a_17080_77900# VSS 1.15362f ; **FLOATING
C714 a_16964_77840# VSS 0.38539f
C715 a_10816_77840# VSS 0.58425f ; **FLOATING
C716 a_10244_77840# VSS 0.58298f ; **FLOATING
C717 a_4096_77840# VSS 0.58425f ; **FLOATING
C718 a_3524_77840# VSS 0.58298f ; **FLOATING
C719 a_40894_82040# VSS 0.04368f
C720 a_9773_52029# VSS 22.7568f ; **FLOATING
C721 a_40484_82040# VSS 0.04368f
C722 a_34734_81900# VSS 0.04368f
C723 a_34324_81900# VSS 0.04368f
C724 a_27060_1364# VSS 22.9557f ; **FLOATING
C725 a_33054_81900# VSS 0.04368f
C726 a_32905_77900# VSS 7.12842f ; **FLOATING
C727 a_32644_81900# VSS 0.04368f
C728 a_25065_27002# VSS 25.4336f ; **FLOATING
C729 a_26894_82040# VSS 0.07326f
C730 a_25065_78242# VSS 3.1942f ; **FLOATING
C731 a_26484_82040# VSS 0.07326f
C732 a_25214_82040# VSS 0.07326f
C733 a_25065_82100# VSS 0.53402f ; **FLOATING
C734 a_24804_82040# VSS 0.07326f
C735 a_19054_81900# VSS 0.04368f
C736 a_18644_81900# VSS 0.04368f
C737 a_13025_65300# VSS 15.7674f ; **FLOATING
C738 a_17374_81900# VSS 0.04368f
C739 a_17225_77900# VSS 2.24947f ; **FLOATING
C740 a_16964_81900# VSS 0.04368f
C741 a_17107_78489# VSS 15.4917f ; **FLOATING
C742 a_11140_82040# VSS 0.07989f
C743 a_10244_82040# VSS 0.07989f
C744 a_10429_78629# VSS 17.2394f ; **FLOATING
C745 a_4420_82040# VSS 0.07989f
C746 a_3524_82040# VSS 0.07989f
C747 a_3709_78629# VSS 18.9385f ; **FLOATING
C748 a_22469_13109.t17 VSS 0.16996f ; **FLOATING
C749 a_22469_13109.t16 VSS 0.16996f ; **FLOATING
C750 a_22469_13109.t15 VSS 0.16996f ; **FLOATING
C751 a_22469_13109.t14 VSS 0.16996f ; **FLOATING
C752 a_22469_13109.t13 VSS 0.16996f ; **FLOATING
C753 a_22469_13109.t12 VSS 0.16996f ; **FLOATING
C754 a_22469_13109.t11 VSS 0.16996f ; **FLOATING
C755 a_22469_13109.t10 VSS 0.16996f ; **FLOATING
C756 a_22469_13109.t9 VSS 0.16996f ; **FLOATING
C757 a_22469_13109.t8 VSS 0.16996f ; **FLOATING
C758 a_22469_13109.t7 VSS 0.16996f ; **FLOATING
C759 a_22469_13109.t6 VSS 0.16996f ; **FLOATING
C760 a_22469_13109.t5 VSS 0.16996f ; **FLOATING
C761 a_22469_13109.t4 VSS 0.16996f ; **FLOATING
C762 a_22469_13109.t3 VSS 0.16996f ; **FLOATING
C763 a_22469_13109.t2 VSS 0.18292f ; **FLOATING
C764 a_22469_13109.n0 VSS 0.2136f ; **FLOATING
C765 a_22469_13109.n1 VSS 0.11905f ; **FLOATING
C766 a_22469_13109.n2 VSS 0.11905f ; **FLOATING
C767 a_22469_13109.n3 VSS 0.11905f ; **FLOATING
C768 a_22469_13109.n4 VSS 0.11905f ; **FLOATING
C769 a_22469_13109.n5 VSS 0.11905f ; **FLOATING
C770 a_22469_13109.n6 VSS 0.11905f ; **FLOATING
C771 a_22469_13109.n7 VSS 0.11905f ; **FLOATING
C772 a_22469_13109.n8 VSS 0.11905f ; **FLOATING
C773 a_22469_13109.n9 VSS 0.11905f ; **FLOATING
C774 a_22469_13109.n10 VSS 0.11905f ; **FLOATING
C775 a_22469_13109.n11 VSS 0.11905f ; **FLOATING
C776 a_22469_13109.n12 VSS 0.11905f ; **FLOATING
C777 a_22469_13109.n13 VSS 0.11905f ; **FLOATING
C778 a_22469_13109.n14 VSS 0.10488f ; **FLOATING
C779 a_22469_13109.t18 VSS 0.16996f ; **FLOATING
C780 a_22469_13109.t19 VSS 0.16996f ; **FLOATING
C781 a_22469_13109.t20 VSS 0.16996f ; **FLOATING
C782 a_22469_13109.t21 VSS 0.16996f ; **FLOATING
C783 a_22469_13109.t22 VSS 0.16996f ; **FLOATING
C784 a_22469_13109.t23 VSS 0.16996f ; **FLOATING
C785 a_22469_13109.t24 VSS 0.16996f ; **FLOATING
C786 a_22469_13109.t25 VSS 0.16996f ; **FLOATING
C787 a_22469_13109.t26 VSS 0.16996f ; **FLOATING
C788 a_22469_13109.t27 VSS 0.16996f ; **FLOATING
C789 a_22469_13109.t28 VSS 0.16996f ; **FLOATING
C790 a_22469_13109.t29 VSS 0.16996f ; **FLOATING
C791 a_22469_13109.t30 VSS 0.16996f ; **FLOATING
C792 a_22469_13109.t31 VSS 0.16996f ; **FLOATING
C793 a_22469_13109.t32 VSS 0.16996f ; **FLOATING
C794 a_22469_13109.t33 VSS 0.18292f ; **FLOATING
C795 a_22469_13109.n15 VSS 0.2136f ; **FLOATING
C796 a_22469_13109.n16 VSS 0.11905f ; **FLOATING
C797 a_22469_13109.n17 VSS 0.11905f ; **FLOATING
C798 a_22469_13109.n18 VSS 0.11905f ; **FLOATING
C799 a_22469_13109.n19 VSS 0.11905f ; **FLOATING
C800 a_22469_13109.n20 VSS 0.11905f ; **FLOATING
C801 a_22469_13109.n21 VSS 0.11905f ; **FLOATING
C802 a_22469_13109.n22 VSS 0.11905f ; **FLOATING
C803 a_22469_13109.n23 VSS 0.11905f ; **FLOATING
C804 a_22469_13109.n24 VSS 0.11905f ; **FLOATING
C805 a_22469_13109.n25 VSS 0.11905f ; **FLOATING
C806 a_22469_13109.n26 VSS 0.11905f ; **FLOATING
C807 a_22469_13109.n27 VSS 0.11905f ; **FLOATING
C808 a_22469_13109.n28 VSS 0.11905f ; **FLOATING
C809 a_22469_13109.n29 VSS 0.10488f ; **FLOATING
C810 a_22469_13109.n30 VSS 2.57052f ; **FLOATING
C811 a_22469_13109.t49 VSS 0.17275f ; **FLOATING
C812 a_22469_13109.t48 VSS 0.17275f ; **FLOATING
C813 a_22469_13109.t47 VSS 0.17275f ; **FLOATING
C814 a_22469_13109.t46 VSS 0.17275f ; **FLOATING
C815 a_22469_13109.t45 VSS 0.17275f ; **FLOATING
C816 a_22469_13109.t44 VSS 0.17275f ; **FLOATING
C817 a_22469_13109.t43 VSS 0.17275f ; **FLOATING
C818 a_22469_13109.t42 VSS 0.17275f ; **FLOATING
C819 a_22469_13109.t41 VSS 0.17275f ; **FLOATING
C820 a_22469_13109.t40 VSS 0.17275f ; **FLOATING
C821 a_22469_13109.t39 VSS 0.17275f ; **FLOATING
C822 a_22469_13109.t38 VSS 0.17275f ; **FLOATING
C823 a_22469_13109.t37 VSS 0.17275f ; **FLOATING
C824 a_22469_13109.t36 VSS 0.17275f ; **FLOATING
C825 a_22469_13109.t35 VSS 0.17275f ; **FLOATING
C826 a_22469_13109.t34 VSS 0.18554f ; **FLOATING
C827 a_22469_13109.n31 VSS 0.21934f ; **FLOATING
C828 a_22469_13109.n32 VSS 0.12184f ; **FLOATING
C829 a_22469_13109.n33 VSS 0.12184f ; **FLOATING
C830 a_22469_13109.n34 VSS 0.12184f ; **FLOATING
C831 a_22469_13109.n35 VSS 0.12184f ; **FLOATING
C832 a_22469_13109.n36 VSS 0.12184f ; **FLOATING
C833 a_22469_13109.n37 VSS 0.12184f ; **FLOATING
C834 a_22469_13109.n38 VSS 0.12184f ; **FLOATING
C835 a_22469_13109.n39 VSS 0.12184f ; **FLOATING
C836 a_22469_13109.n40 VSS 0.12184f ; **FLOATING
C837 a_22469_13109.n41 VSS 0.12184f ; **FLOATING
C838 a_22469_13109.n42 VSS 0.12184f ; **FLOATING
C839 a_22469_13109.n43 VSS 0.12184f ; **FLOATING
C840 a_22469_13109.n44 VSS 0.12184f ; **FLOATING
C841 a_22469_13109.n45 VSS 0.10767f ; **FLOATING
C842 a_22469_13109.t50 VSS 0.17275f ; **FLOATING
C843 a_22469_13109.t51 VSS 0.17275f ; **FLOATING
C844 a_22469_13109.t52 VSS 0.17275f ; **FLOATING
C845 a_22469_13109.t53 VSS 0.17275f ; **FLOATING
C846 a_22469_13109.t54 VSS 0.17275f ; **FLOATING
C847 a_22469_13109.t55 VSS 0.17275f ; **FLOATING
C848 a_22469_13109.t56 VSS 0.17275f ; **FLOATING
C849 a_22469_13109.t57 VSS 0.17275f ; **FLOATING
C850 a_22469_13109.t58 VSS 0.17275f ; **FLOATING
C851 a_22469_13109.t59 VSS 0.17275f ; **FLOATING
C852 a_22469_13109.t60 VSS 0.17275f ; **FLOATING
C853 a_22469_13109.t61 VSS 0.17275f ; **FLOATING
C854 a_22469_13109.t62 VSS 0.17275f ; **FLOATING
C855 a_22469_13109.t63 VSS 0.17275f ; **FLOATING
C856 a_22469_13109.t64 VSS 0.17275f ; **FLOATING
C857 a_22469_13109.t65 VSS 0.18554f ; **FLOATING
C858 a_22469_13109.n46 VSS 0.21934f ; **FLOATING
C859 a_22469_13109.n47 VSS 0.12184f ; **FLOATING
C860 a_22469_13109.n48 VSS 0.12184f ; **FLOATING
C861 a_22469_13109.n49 VSS 0.12184f ; **FLOATING
C862 a_22469_13109.n50 VSS 0.12184f ; **FLOATING
C863 a_22469_13109.n51 VSS 0.12184f ; **FLOATING
C864 a_22469_13109.n52 VSS 0.12184f ; **FLOATING
C865 a_22469_13109.n53 VSS 0.12184f ; **FLOATING
C866 a_22469_13109.n54 VSS 0.12184f ; **FLOATING
C867 a_22469_13109.n55 VSS 0.12184f ; **FLOATING
C868 a_22469_13109.n56 VSS 0.12184f ; **FLOATING
C869 a_22469_13109.n57 VSS 0.12184f ; **FLOATING
C870 a_22469_13109.n58 VSS 0.12184f ; **FLOATING
C871 a_22469_13109.n59 VSS 0.12184f ; **FLOATING
C872 a_22469_13109.n60 VSS 0.10767f ; **FLOATING
C873 a_22469_13109.n61 VSS 2.48289f ; **FLOATING
C874 a_22469_13109.n62 VSS 2.57738f ; **FLOATING
C875 a_22469_13109.t0 VSS 3.68772f ; **FLOATING
C876 a_22469_13109.t1 VSS 0.46155f ; **FLOATING
C877 a_4409_13109.t9 VSS 0.58022f ; **FLOATING
C878 a_4409_13109.t12 VSS 0.58419f ; **FLOATING
C879 a_4409_13109.t11 VSS 0.5732f ; **FLOATING
C880 a_4409_13109.t120 VSS 0.19723f ; **FLOATING
C881 a_4409_13109.t119 VSS 0.19723f ; **FLOATING
C882 a_4409_13109.t118 VSS 0.19723f ; **FLOATING
C883 a_4409_13109.t117 VSS 0.19723f ; **FLOATING
C884 a_4409_13109.t116 VSS 0.19723f ; **FLOATING
C885 a_4409_13109.t115 VSS 0.19723f ; **FLOATING
C886 a_4409_13109.t3 VSS 0.19723f ; **FLOATING
C887 a_4409_13109.t4 VSS 0.19723f ; **FLOATING
C888 a_4409_13109.t114 VSS 0.19723f ; **FLOATING
C889 a_4409_13109.t113 VSS 0.19723f ; **FLOATING
C890 a_4409_13109.t112 VSS 0.19723f ; **FLOATING
C891 a_4409_13109.t111 VSS 0.19723f ; **FLOATING
C892 a_4409_13109.t110 VSS 0.19723f ; **FLOATING
C893 a_4409_13109.t109 VSS 0.19723f ; **FLOATING
C894 a_4409_13109.t108 VSS 0.19723f ; **FLOATING
C895 a_4409_13109.t107 VSS 0.19723f ; **FLOATING
C896 a_4409_13109.t106 VSS 0.19723f ; **FLOATING
C897 a_4409_13109.t105 VSS 0.19723f ; **FLOATING
C898 a_4409_13109.t104 VSS 0.19723f ; **FLOATING
C899 a_4409_13109.t103 VSS 0.19723f ; **FLOATING
C900 a_4409_13109.t102 VSS 0.19723f ; **FLOATING
C901 a_4409_13109.t101 VSS 0.19723f ; **FLOATING
C902 a_4409_13109.t100 VSS 0.19723f ; **FLOATING
C903 a_4409_13109.t99 VSS 0.19723f ; **FLOATING
C904 a_4409_13109.t98 VSS 0.19723f ; **FLOATING
C905 a_4409_13109.t97 VSS 0.19723f ; **FLOATING
C906 a_4409_13109.t96 VSS 0.19723f ; **FLOATING
C907 a_4409_13109.t95 VSS 0.19723f ; **FLOATING
C908 a_4409_13109.t94 VSS 0.19723f ; **FLOATING
C909 a_4409_13109.t93 VSS 0.19723f ; **FLOATING
C910 a_4409_13109.t92 VSS 0.19723f ; **FLOATING
C911 a_4409_13109.t91 VSS 0.19723f ; **FLOATING
C912 a_4409_13109.t90 VSS 0.19723f ; **FLOATING
C913 a_4409_13109.t89 VSS 0.19723f ; **FLOATING
C914 a_4409_13109.t88 VSS 0.19723f ; **FLOATING
C915 a_4409_13109.t87 VSS 0.19723f ; **FLOATING
C916 a_4409_13109.t86 VSS 0.19723f ; **FLOATING
C917 a_4409_13109.t85 VSS 0.21184f ; **FLOATING
C918 a_4409_13109.n0 VSS 0.25043f ; **FLOATING
C919 a_4409_13109.n1 VSS 0.13911f ; **FLOATING
C920 a_4409_13109.n2 VSS 0.13911f ; **FLOATING
C921 a_4409_13109.n3 VSS 0.13911f ; **FLOATING
C922 a_4409_13109.n4 VSS 0.13911f ; **FLOATING
C923 a_4409_13109.n5 VSS 0.13911f ; **FLOATING
C924 a_4409_13109.n6 VSS 0.13911f ; **FLOATING
C925 a_4409_13109.n7 VSS 0.13911f ; **FLOATING
C926 a_4409_13109.n8 VSS 0.13911f ; **FLOATING
C927 a_4409_13109.n9 VSS 0.13911f ; **FLOATING
C928 a_4409_13109.n10 VSS 0.13911f ; **FLOATING
C929 a_4409_13109.n11 VSS 0.13911f ; **FLOATING
C930 a_4409_13109.n12 VSS 0.13911f ; **FLOATING
C931 a_4409_13109.n13 VSS 0.13911f ; **FLOATING
C932 a_4409_13109.n14 VSS 0.13911f ; **FLOATING
C933 a_4409_13109.n15 VSS 0.13911f ; **FLOATING
C934 a_4409_13109.n16 VSS 0.13911f ; **FLOATING
C935 a_4409_13109.n17 VSS 0.13911f ; **FLOATING
C936 a_4409_13109.n18 VSS 0.13911f ; **FLOATING
C937 a_4409_13109.n19 VSS 0.13911f ; **FLOATING
C938 a_4409_13109.n20 VSS 0.13911f ; **FLOATING
C939 a_4409_13109.n21 VSS 0.13911f ; **FLOATING
C940 a_4409_13109.n22 VSS 0.13911f ; **FLOATING
C941 a_4409_13109.n23 VSS 0.13911f ; **FLOATING
C942 a_4409_13109.n24 VSS 0.13911f ; **FLOATING
C943 a_4409_13109.n25 VSS 0.13911f ; **FLOATING
C944 a_4409_13109.n26 VSS 0.13911f ; **FLOATING
C945 a_4409_13109.n27 VSS 0.13911f ; **FLOATING
C946 a_4409_13109.n28 VSS 0.13911f ; **FLOATING
C947 a_4409_13109.n29 VSS 0.13911f ; **FLOATING
C948 a_4409_13109.n30 VSS 0.13911f ; **FLOATING
C949 a_4409_13109.n31 VSS 0.13911f ; **FLOATING
C950 a_4409_13109.n32 VSS 0.13911f ; **FLOATING
C951 a_4409_13109.n33 VSS 0.13911f ; **FLOATING
C952 a_4409_13109.n34 VSS 0.13911f ; **FLOATING
C953 a_4409_13109.n35 VSS 0.13911f ; **FLOATING
C954 a_4409_13109.n36 VSS 0.12293f ; **FLOATING
C955 a_4409_13109.t121 VSS 0.19723f ; **FLOATING
C956 a_4409_13109.t122 VSS 0.19723f ; **FLOATING
C957 a_4409_13109.t123 VSS 0.19723f ; **FLOATING
C958 a_4409_13109.t124 VSS 0.19723f ; **FLOATING
C959 a_4409_13109.t125 VSS 0.19723f ; **FLOATING
C960 a_4409_13109.t126 VSS 0.19723f ; **FLOATING
C961 a_4409_13109.t2 VSS 0.19723f ; **FLOATING
C962 a_4409_13109.t0 VSS 0.19723f ; **FLOATING
C963 a_4409_13109.t127 VSS 0.19723f ; **FLOATING
C964 a_4409_13109.t128 VSS 0.19723f ; **FLOATING
C965 a_4409_13109.t129 VSS 0.19723f ; **FLOATING
C966 a_4409_13109.t130 VSS 0.19723f ; **FLOATING
C967 a_4409_13109.t131 VSS 0.19723f ; **FLOATING
C968 a_4409_13109.t132 VSS 0.19723f ; **FLOATING
C969 a_4409_13109.t133 VSS 0.19723f ; **FLOATING
C970 a_4409_13109.t134 VSS 0.19723f ; **FLOATING
C971 a_4409_13109.t135 VSS 0.19723f ; **FLOATING
C972 a_4409_13109.t136 VSS 0.19723f ; **FLOATING
C973 a_4409_13109.t137 VSS 0.19723f ; **FLOATING
C974 a_4409_13109.t138 VSS 0.19723f ; **FLOATING
C975 a_4409_13109.t139 VSS 0.19723f ; **FLOATING
C976 a_4409_13109.t140 VSS 0.19723f ; **FLOATING
C977 a_4409_13109.t141 VSS 0.19723f ; **FLOATING
C978 a_4409_13109.t142 VSS 0.19723f ; **FLOATING
C979 a_4409_13109.t143 VSS 0.19723f ; **FLOATING
C980 a_4409_13109.t144 VSS 0.19723f ; **FLOATING
C981 a_4409_13109.t145 VSS 0.19723f ; **FLOATING
C982 a_4409_13109.t146 VSS 0.19723f ; **FLOATING
C983 a_4409_13109.t147 VSS 0.19723f ; **FLOATING
C984 a_4409_13109.t148 VSS 0.19723f ; **FLOATING
C985 a_4409_13109.t149 VSS 0.19723f ; **FLOATING
C986 a_4409_13109.t150 VSS 0.19723f ; **FLOATING
C987 a_4409_13109.t151 VSS 0.19723f ; **FLOATING
C988 a_4409_13109.t152 VSS 0.19723f ; **FLOATING
C989 a_4409_13109.t153 VSS 0.19723f ; **FLOATING
C990 a_4409_13109.t154 VSS 0.19723f ; **FLOATING
C991 a_4409_13109.t155 VSS 0.19723f ; **FLOATING
C992 a_4409_13109.t156 VSS 0.21184f ; **FLOATING
C993 a_4409_13109.n37 VSS 0.25043f ; **FLOATING
C994 a_4409_13109.n38 VSS 0.13911f ; **FLOATING
C995 a_4409_13109.n39 VSS 0.13911f ; **FLOATING
C996 a_4409_13109.n40 VSS 0.13911f ; **FLOATING
C997 a_4409_13109.n41 VSS 0.13911f ; **FLOATING
C998 a_4409_13109.n42 VSS 0.13911f ; **FLOATING
C999 a_4409_13109.n43 VSS 0.13911f ; **FLOATING
C1000 a_4409_13109.n44 VSS 0.13911f ; **FLOATING
C1001 a_4409_13109.n45 VSS 0.13911f ; **FLOATING
C1002 a_4409_13109.n46 VSS 0.13911f ; **FLOATING
C1003 a_4409_13109.n47 VSS 0.13911f ; **FLOATING
C1004 a_4409_13109.n48 VSS 0.13911f ; **FLOATING
C1005 a_4409_13109.n49 VSS 0.13911f ; **FLOATING
C1006 a_4409_13109.n50 VSS 0.13911f ; **FLOATING
C1007 a_4409_13109.n51 VSS 0.13911f ; **FLOATING
C1008 a_4409_13109.n52 VSS 0.13911f ; **FLOATING
C1009 a_4409_13109.n53 VSS 0.13911f ; **FLOATING
C1010 a_4409_13109.n54 VSS 0.13911f ; **FLOATING
C1011 a_4409_13109.n55 VSS 0.13911f ; **FLOATING
C1012 a_4409_13109.n56 VSS 0.13911f ; **FLOATING
C1013 a_4409_13109.n57 VSS 0.13911f ; **FLOATING
C1014 a_4409_13109.n58 VSS 0.13911f ; **FLOATING
C1015 a_4409_13109.n59 VSS 0.13911f ; **FLOATING
C1016 a_4409_13109.n60 VSS 0.13911f ; **FLOATING
C1017 a_4409_13109.n61 VSS 0.13911f ; **FLOATING
C1018 a_4409_13109.n62 VSS 0.13911f ; **FLOATING
C1019 a_4409_13109.n63 VSS 0.13911f ; **FLOATING
C1020 a_4409_13109.n64 VSS 0.13911f ; **FLOATING
C1021 a_4409_13109.n65 VSS 0.13911f ; **FLOATING
C1022 a_4409_13109.n66 VSS 0.13911f ; **FLOATING
C1023 a_4409_13109.n67 VSS 0.13911f ; **FLOATING
C1024 a_4409_13109.n68 VSS 0.13911f ; **FLOATING
C1025 a_4409_13109.n69 VSS 0.13911f ; **FLOATING
C1026 a_4409_13109.n70 VSS 0.13911f ; **FLOATING
C1027 a_4409_13109.n71 VSS 0.13911f ; **FLOATING
C1028 a_4409_13109.n72 VSS 0.13911f ; **FLOATING
C1029 a_4409_13109.n73 VSS 0.12293f ; **FLOATING
C1030 a_4409_13109.n74 VSS 6.73605f ; **FLOATING
C1031 a_4409_13109.n75 VSS 2.60606f ; **FLOATING
C1032 a_4409_13109.t48 VSS 0.19405f ; **FLOATING
C1033 a_4409_13109.t47 VSS 0.19405f ; **FLOATING
C1034 a_4409_13109.t46 VSS 0.19405f ; **FLOATING
C1035 a_4409_13109.t45 VSS 0.19405f ; **FLOATING
C1036 a_4409_13109.t44 VSS 0.19405f ; **FLOATING
C1037 a_4409_13109.t43 VSS 0.19405f ; **FLOATING
C1038 a_4409_13109.t8 VSS 0.19405f ; **FLOATING
C1039 a_4409_13109.t10 VSS 0.19405f ; **FLOATING
C1040 a_4409_13109.t42 VSS 0.19405f ; **FLOATING
C1041 a_4409_13109.t41 VSS 0.19405f ; **FLOATING
C1042 a_4409_13109.t40 VSS 0.19405f ; **FLOATING
C1043 a_4409_13109.t39 VSS 0.19405f ; **FLOATING
C1044 a_4409_13109.t38 VSS 0.19405f ; **FLOATING
C1045 a_4409_13109.t37 VSS 0.19405f ; **FLOATING
C1046 a_4409_13109.t36 VSS 0.19405f ; **FLOATING
C1047 a_4409_13109.t35 VSS 0.19405f ; **FLOATING
C1048 a_4409_13109.t34 VSS 0.19405f ; **FLOATING
C1049 a_4409_13109.t33 VSS 0.19405f ; **FLOATING
C1050 a_4409_13109.t32 VSS 0.19405f ; **FLOATING
C1051 a_4409_13109.t31 VSS 0.19405f ; **FLOATING
C1052 a_4409_13109.t30 VSS 0.19405f ; **FLOATING
C1053 a_4409_13109.t29 VSS 0.19405f ; **FLOATING
C1054 a_4409_13109.t28 VSS 0.19405f ; **FLOATING
C1055 a_4409_13109.t27 VSS 0.19405f ; **FLOATING
C1056 a_4409_13109.t26 VSS 0.19405f ; **FLOATING
C1057 a_4409_13109.t25 VSS 0.19405f ; **FLOATING
C1058 a_4409_13109.t24 VSS 0.19405f ; **FLOATING
C1059 a_4409_13109.t23 VSS 0.19405f ; **FLOATING
C1060 a_4409_13109.t22 VSS 0.19405f ; **FLOATING
C1061 a_4409_13109.t21 VSS 0.19405f ; **FLOATING
C1062 a_4409_13109.t20 VSS 0.19405f ; **FLOATING
C1063 a_4409_13109.t19 VSS 0.19405f ; **FLOATING
C1064 a_4409_13109.t18 VSS 0.19405f ; **FLOATING
C1065 a_4409_13109.t17 VSS 0.19405f ; **FLOATING
C1066 a_4409_13109.t16 VSS 0.19405f ; **FLOATING
C1067 a_4409_13109.t15 VSS 0.19405f ; **FLOATING
C1068 a_4409_13109.t14 VSS 0.19405f ; **FLOATING
C1069 a_4409_13109.t13 VSS 0.20884f ; **FLOATING
C1070 a_4409_13109.n76 VSS 0.24387f ; **FLOATING
C1071 a_4409_13109.n77 VSS 0.13593f ; **FLOATING
C1072 a_4409_13109.n78 VSS 0.13593f ; **FLOATING
C1073 a_4409_13109.n79 VSS 0.13593f ; **FLOATING
C1074 a_4409_13109.n80 VSS 0.13593f ; **FLOATING
C1075 a_4409_13109.n81 VSS 0.13593f ; **FLOATING
C1076 a_4409_13109.n82 VSS 0.13593f ; **FLOATING
C1077 a_4409_13109.n83 VSS 0.13593f ; **FLOATING
C1078 a_4409_13109.n84 VSS 0.13593f ; **FLOATING
C1079 a_4409_13109.n85 VSS 0.13593f ; **FLOATING
C1080 a_4409_13109.n86 VSS 0.13593f ; **FLOATING
C1081 a_4409_13109.n87 VSS 0.13593f ; **FLOATING
C1082 a_4409_13109.n88 VSS 0.13593f ; **FLOATING
C1083 a_4409_13109.n89 VSS 0.13593f ; **FLOATING
C1084 a_4409_13109.n90 VSS 0.13593f ; **FLOATING
C1085 a_4409_13109.n91 VSS 0.13593f ; **FLOATING
C1086 a_4409_13109.n92 VSS 0.13593f ; **FLOATING
C1087 a_4409_13109.n93 VSS 0.13593f ; **FLOATING
C1088 a_4409_13109.n94 VSS 0.13593f ; **FLOATING
C1089 a_4409_13109.n95 VSS 0.13593f ; **FLOATING
C1090 a_4409_13109.n96 VSS 0.13593f ; **FLOATING
C1091 a_4409_13109.n97 VSS 0.13593f ; **FLOATING
C1092 a_4409_13109.n98 VSS 0.13593f ; **FLOATING
C1093 a_4409_13109.n99 VSS 0.13593f ; **FLOATING
C1094 a_4409_13109.n100 VSS 0.13593f ; **FLOATING
C1095 a_4409_13109.n101 VSS 0.13593f ; **FLOATING
C1096 a_4409_13109.n102 VSS 0.13593f ; **FLOATING
C1097 a_4409_13109.n103 VSS 0.13593f ; **FLOATING
C1098 a_4409_13109.n104 VSS 0.13593f ; **FLOATING
C1099 a_4409_13109.n105 VSS 0.13593f ; **FLOATING
C1100 a_4409_13109.n106 VSS 0.13593f ; **FLOATING
C1101 a_4409_13109.n107 VSS 0.13593f ; **FLOATING
C1102 a_4409_13109.n108 VSS 0.13593f ; **FLOATING
C1103 a_4409_13109.n109 VSS 0.13593f ; **FLOATING
C1104 a_4409_13109.n110 VSS 0.13593f ; **FLOATING
C1105 a_4409_13109.n111 VSS 0.13593f ; **FLOATING
C1106 a_4409_13109.n112 VSS 0.11974f ; **FLOATING
C1107 a_4409_13109.t49 VSS 0.19405f ; **FLOATING
C1108 a_4409_13109.t50 VSS 0.19405f ; **FLOATING
C1109 a_4409_13109.t51 VSS 0.19405f ; **FLOATING
C1110 a_4409_13109.t52 VSS 0.19405f ; **FLOATING
C1111 a_4409_13109.t53 VSS 0.19405f ; **FLOATING
C1112 a_4409_13109.t54 VSS 0.19405f ; **FLOATING
C1113 a_4409_13109.t7 VSS 0.19405f ; **FLOATING
C1114 a_4409_13109.t5 VSS 0.19405f ; **FLOATING
C1115 a_4409_13109.t55 VSS 0.19405f ; **FLOATING
C1116 a_4409_13109.t56 VSS 0.19405f ; **FLOATING
C1117 a_4409_13109.t57 VSS 0.19405f ; **FLOATING
C1118 a_4409_13109.t58 VSS 0.19405f ; **FLOATING
C1119 a_4409_13109.t59 VSS 0.19405f ; **FLOATING
C1120 a_4409_13109.t60 VSS 0.19405f ; **FLOATING
C1121 a_4409_13109.t61 VSS 0.19405f ; **FLOATING
C1122 a_4409_13109.t62 VSS 0.19405f ; **FLOATING
C1123 a_4409_13109.t63 VSS 0.19405f ; **FLOATING
C1124 a_4409_13109.t64 VSS 0.19405f ; **FLOATING
C1125 a_4409_13109.t65 VSS 0.19405f ; **FLOATING
C1126 a_4409_13109.t66 VSS 0.19405f ; **FLOATING
C1127 a_4409_13109.t67 VSS 0.19405f ; **FLOATING
C1128 a_4409_13109.t68 VSS 0.19405f ; **FLOATING
C1129 a_4409_13109.t69 VSS 0.19405f ; **FLOATING
C1130 a_4409_13109.t70 VSS 0.19405f ; **FLOATING
C1131 a_4409_13109.t71 VSS 0.19405f ; **FLOATING
C1132 a_4409_13109.t72 VSS 0.19405f ; **FLOATING
C1133 a_4409_13109.t73 VSS 0.19405f ; **FLOATING
C1134 a_4409_13109.t74 VSS 0.19405f ; **FLOATING
C1135 a_4409_13109.t75 VSS 0.19405f ; **FLOATING
C1136 a_4409_13109.t76 VSS 0.19405f ; **FLOATING
C1137 a_4409_13109.t77 VSS 0.19405f ; **FLOATING
C1138 a_4409_13109.t78 VSS 0.19405f ; **FLOATING
C1139 a_4409_13109.t79 VSS 0.19405f ; **FLOATING
C1140 a_4409_13109.t80 VSS 0.19405f ; **FLOATING
C1141 a_4409_13109.t81 VSS 0.19405f ; **FLOATING
C1142 a_4409_13109.t82 VSS 0.19405f ; **FLOATING
C1143 a_4409_13109.t83 VSS 0.19405f ; **FLOATING
C1144 a_4409_13109.t84 VSS 0.20884f ; **FLOATING
C1145 a_4409_13109.n113 VSS 0.24387f ; **FLOATING
C1146 a_4409_13109.n114 VSS 0.13593f ; **FLOATING
C1147 a_4409_13109.n115 VSS 0.13593f ; **FLOATING
C1148 a_4409_13109.n116 VSS 0.13593f ; **FLOATING
C1149 a_4409_13109.n117 VSS 0.13593f ; **FLOATING
C1150 a_4409_13109.n118 VSS 0.13593f ; **FLOATING
C1151 a_4409_13109.n119 VSS 0.13593f ; **FLOATING
C1152 a_4409_13109.n120 VSS 0.13593f ; **FLOATING
C1153 a_4409_13109.n121 VSS 0.13593f ; **FLOATING
C1154 a_4409_13109.n122 VSS 0.13593f ; **FLOATING
C1155 a_4409_13109.n123 VSS 0.13593f ; **FLOATING
C1156 a_4409_13109.n124 VSS 0.13593f ; **FLOATING
C1157 a_4409_13109.n125 VSS 0.13593f ; **FLOATING
C1158 a_4409_13109.n126 VSS 0.13593f ; **FLOATING
C1159 a_4409_13109.n127 VSS 0.13593f ; **FLOATING
C1160 a_4409_13109.n128 VSS 0.13593f ; **FLOATING
C1161 a_4409_13109.n129 VSS 0.13593f ; **FLOATING
C1162 a_4409_13109.n130 VSS 0.13593f ; **FLOATING
C1163 a_4409_13109.n131 VSS 0.13593f ; **FLOATING
C1164 a_4409_13109.n132 VSS 0.13593f ; **FLOATING
C1165 a_4409_13109.n133 VSS 0.13593f ; **FLOATING
C1166 a_4409_13109.n134 VSS 0.13593f ; **FLOATING
C1167 a_4409_13109.n135 VSS 0.13593f ; **FLOATING
C1168 a_4409_13109.n136 VSS 0.13593f ; **FLOATING
C1169 a_4409_13109.n137 VSS 0.13593f ; **FLOATING
C1170 a_4409_13109.n138 VSS 0.13593f ; **FLOATING
C1171 a_4409_13109.n139 VSS 0.13593f ; **FLOATING
C1172 a_4409_13109.n140 VSS 0.13593f ; **FLOATING
C1173 a_4409_13109.n141 VSS 0.13593f ; **FLOATING
C1174 a_4409_13109.n142 VSS 0.13593f ; **FLOATING
C1175 a_4409_13109.n143 VSS 0.13593f ; **FLOATING
C1176 a_4409_13109.n144 VSS 0.13593f ; **FLOATING
C1177 a_4409_13109.n145 VSS 0.13593f ; **FLOATING
C1178 a_4409_13109.n146 VSS 0.13593f ; **FLOATING
C1179 a_4409_13109.n147 VSS 0.13593f ; **FLOATING
C1180 a_4409_13109.n148 VSS 0.13593f ; **FLOATING
C1181 a_4409_13109.n149 VSS 0.11974f ; **FLOATING
C1182 a_4409_13109.n150 VSS 6.70274f ; **FLOATING
C1183 a_4409_13109.n151 VSS 2.6856f ; **FLOATING
C1184 a_4409_13109.n152 VSS 1.40168f ; **FLOATING
C1185 a_4409_13109.t1 VSS 2.87046f ; **FLOATING
C1186 a_4409_13109.t6 VSS 1.45671f ; **FLOATING
C1187 a_4809_11960.n0 VSS 0.41118f ; **FLOATING
C1188 a_4809_11960.n1 VSS 0.86469f ; **FLOATING
C1189 a_4809_11960.n2 VSS 0.68109f ; **FLOATING
C1190 a_4809_11960.n3 VSS 0.53982f ; **FLOATING
C1191 a_4809_11960.n4 VSS 0.4124f ; **FLOATING
C1192 a_4809_11960.n5 VSS 0.81286f ; **FLOATING
C1193 a_4809_11960.n6 VSS 0.68289f ; **FLOATING
C1194 a_4809_11960.n7 VSS 0.54098f ; **FLOATING
C1195 a_4809_11960.n8 VSS 0.33228f ; **FLOATING
C1196 a_4809_11960.n9 VSS 0.3317f ; **FLOATING
C1197 a_4809_11960.t0 VSS 0.67192f ; **FLOATING
C1198 a_4809_11960.t3 VSS 0.69763f ; **FLOATING
C1199 a_4809_11960.t5 VSS 0.67809f ; **FLOATING
C1200 a_4809_11960.t26 VSS 0.67809f ; **FLOATING
C1201 a_4809_11960.t30 VSS 0.67809f ; **FLOATING
C1202 a_4809_11960.t9 VSS 0.67809f ; **FLOATING
C1203 a_4809_11960.t19 VSS 0.67809f ; **FLOATING
C1204 a_4809_11960.t14 VSS 0.67809f ; **FLOATING
C1205 a_4809_11960.t7 VSS 0.67809f ; **FLOATING
C1206 a_4809_11960.t8 VSS 0.67809f ; **FLOATING
C1207 a_4809_11960.t13 VSS 0.67809f ; **FLOATING
C1208 a_4809_11960.t22 VSS 0.67809f ; **FLOATING
C1209 a_4809_11960.t24 VSS 0.67809f ; **FLOATING
C1210 a_4809_11960.t20 VSS 0.67809f ; **FLOATING
C1211 a_4809_11960.t12 VSS 0.67809f ; **FLOATING
C1212 a_4809_11960.t29 VSS 0.67809f ; **FLOATING
C1213 a_4809_11960.t25 VSS 0.69763f ; **FLOATING
C1214 a_4809_11960.t11 VSS 0.697f ; **FLOATING
C1215 a_4809_11960.t15 VSS 0.67751f ; **FLOATING
C1216 a_4809_11960.t10 VSS 0.67751f ; **FLOATING
C1217 a_4809_11960.t27 VSS 0.67751f ; **FLOATING
C1218 a_4809_11960.t6 VSS 0.67751f ; **FLOATING
C1219 a_4809_11960.t23 VSS 0.67751f ; **FLOATING
C1220 a_4809_11960.t31 VSS 0.67751f ; **FLOATING
C1221 a_4809_11960.t32 VSS 0.67751f ; **FLOATING
C1222 a_4809_11960.t34 VSS 0.67751f ; **FLOATING
C1223 a_4809_11960.t28 VSS 0.67751f ; **FLOATING
C1224 a_4809_11960.t18 VSS 0.67751f ; **FLOATING
C1225 a_4809_11960.t4 VSS 0.67751f ; **FLOATING
C1226 a_4809_11960.t21 VSS 0.67751f ; **FLOATING
C1227 a_4809_11960.t16 VSS 0.67751f ; **FLOATING
C1228 a_4809_11960.t33 VSS 0.67751f ; **FLOATING
C1229 a_4809_11960.t17 VSS 0.697f ; **FLOATING
C1230 a_4809_11960.t1 VSS 16.7623f ; **FLOATING
C1231 a_4809_11960.n10 VSS 0.6634f ; **FLOATING
C1232 a_4809_11960.n11 VSS 0.66457f ; **FLOATING
C1233 a_4809_11960.n12 VSS 0.33228f ; **FLOATING
C1234 a_4809_11960.n13 VSS 0.45587f ; **FLOATING
C1235 a_4809_11960.n14 VSS 0.45587f ; **FLOATING
C1236 a_4809_11960.n15 VSS 0.3317f ; **FLOATING
C1237 a_4809_11960.n16 VSS 0.45529f ; **FLOATING
C1238 a_4809_11960.n17 VSS 0.45529f ; **FLOATING
C1239 a_4809_11960.n18 VSS 2.47613f ; **FLOATING
C1240 a_4809_11960.t2 VSS 19.9612f ; **FLOATING
C1241 VR.n0 VSS 0.06819f ; **FLOATING
C1242 VR.n1 VSS 0.28118f ; **FLOATING
C1243 VR.n2 VSS 0.06819f ; **FLOATING
C1244 VR.n3 VSS 0.28118f ; **FLOATING
C1245 VR.n4 VSS 0.06819f ; **FLOATING
C1246 VR.n5 VSS 0.28118f ; **FLOATING
C1247 VR.n6 VSS 0.06819f ; **FLOATING
C1248 VR.n7 VSS 0.28118f ; **FLOATING
C1249 VR.n8 VSS 0.06819f ; **FLOATING
C1250 VR.n9 VSS 0.28118f ; **FLOATING
C1251 VR.n10 VSS 0.06819f ; **FLOATING
C1252 VR.n11 VSS 0.28118f ; **FLOATING
C1253 VR.n12 VSS 0.06819f ; **FLOATING
C1254 VR.n13 VSS 0.28118f ; **FLOATING
C1255 VR.n14 VSS 0.06819f ; **FLOATING
C1256 VR.n15 VSS 0.28118f ; **FLOATING
C1257 VR.n16 VSS 5.52681f ; **FLOATING
C1258 VR.t226 VSS 39.2723f ; **FLOATING
C1259 VR.n17 VSS 1.53249f ; **FLOATING
C1260 VR.n18 VSS 0.17097f ; **FLOATING
C1261 VR.n19 VSS 0.2948f ; **FLOATING
C1262 VR.n20 VSS 0.82072f ; **FLOATING
C1263 VR.n21 VSS 0.28397f ; **FLOATING
C1264 VR.n22 VSS 0.27007f ; **FLOATING
C1265 VR.n23 VSS 0.20487f ; **FLOATING
C1266 VR.n24 VSS 0.15728f ; **FLOATING
C1267 VR.n25 VSS 0.27007f ; **FLOATING
C1268 VR.n26 VSS 0.20487f ; **FLOATING
C1269 VR.n27 VSS 0.15728f ; **FLOATING
C1270 VR.n28 VSS 0.27007f ; **FLOATING
C1271 VR.n29 VSS 0.20487f ; **FLOATING
C1272 VR.n30 VSS 0.15728f ; **FLOATING
C1273 VR.t196 VSS 0.07648f ; **FLOATING
C1274 VR.t182 VSS 0.07529f ; **FLOATING
C1275 VR.t147 VSS 0.07529f ; **FLOATING
C1276 VR.t197 VSS 0.07529f ; **FLOATING
C1277 VR.t180 VSS 0.07529f ; **FLOATING
C1278 VR.t210 VSS 0.07529f ; **FLOATING
C1279 VR.t206 VSS 0.07529f ; **FLOATING
C1280 VR.t198 VSS 0.07529f ; **FLOATING
C1281 VR.t209 VSS 0.07529f ; **FLOATING
C1282 VR.t213 VSS 0.07529f ; **FLOATING
C1283 VR.t207 VSS 0.07529f ; **FLOATING
C1284 VR.t199 VSS 0.07529f ; **FLOATING
C1285 VR.t52 VSS 0.07529f ; **FLOATING
C1286 VR.t0 VSS 0.07529f ; **FLOATING
C1287 VR.t43 VSS 0.07529f ; **FLOATING
C1288 VR.t208 VSS 0.07545f ; **FLOATING
C1289 VR.t53 VSS 0.07662f ; **FLOATING
C1290 VR.t18 VSS 0.07542f ; **FLOATING
C1291 VR.t17 VSS 0.07542f ; **FLOATING
C1292 VR.t1 VSS 0.07542f ; **FLOATING
C1293 VR.t175 VSS 0.07542f ; **FLOATING
C1294 VR.t148 VSS 0.07542f ; **FLOATING
C1295 VR.t181 VSS 0.07542f ; **FLOATING
C1296 VR.t176 VSS 0.07542f ; **FLOATING
C1297 VR.t3 VSS 0.07542f ; **FLOATING
C1298 VR.t178 VSS 0.07542f ; **FLOATING
C1299 VR.t179 VSS 0.07542f ; **FLOATING
C1300 VR.t177 VSS 0.07542f ; **FLOATING
C1301 VR.t212 VSS 0.07542f ; **FLOATING
C1302 VR.t211 VSS 0.07542f ; **FLOATING
C1303 VR.t214 VSS 0.07542f ; **FLOATING
C1304 VR.t174 VSS 0.07559f ; **FLOATING
C1305 VR.t32 VSS 0.07801f ; **FLOATING
C1306 VR.t16 VSS 0.07586f ; **FLOATING
C1307 VR.t202 VSS 0.07586f ; **FLOATING
C1308 VR.t158 VSS 0.07586f ; **FLOATING
C1309 VR.t76 VSS 0.07586f ; **FLOATING
C1310 VR.t142 VSS 0.07586f ; **FLOATING
C1311 VR.t183 VSS 0.07586f ; **FLOATING
C1312 VR.t91 VSS 0.07586f ; **FLOATING
C1313 VR.t102 VSS 0.07586f ; **FLOATING
C1314 VR.t150 VSS 0.07586f ; **FLOATING
C1315 VR.t145 VSS 0.07586f ; **FLOATING
C1316 VR.t149 VSS 0.07586f ; **FLOATING
C1317 VR.t156 VSS 0.07586f ; **FLOATING
C1318 VR.t77 VSS 0.07586f ; **FLOATING
C1319 VR.t101 VSS 0.07586f ; **FLOATING
C1320 VR.t141 VSS 0.07801f ; **FLOATING
C1321 VR.t75 VSS 0.07811f ; **FLOATING
C1322 VR.t140 VSS 0.07594f ; **FLOATING
C1323 VR.t78 VSS 0.07594f ; **FLOATING
C1324 VR.t131 VSS 0.07594f ; **FLOATING
C1325 VR.t159 VSS 0.07594f ; **FLOATING
C1326 VR.t154 VSS 0.07594f ; **FLOATING
C1327 VR.t92 VSS 0.07594f ; **FLOATING
C1328 VR.t161 VSS 0.07594f ; **FLOATING
C1329 VR.t146 VSS 0.07594f ; **FLOATING
C1330 VR.t153 VSS 0.07594f ; **FLOATING
C1331 VR.t54 VSS 0.07594f ; **FLOATING
C1332 VR.t157 VSS 0.07594f ; **FLOATING
C1333 VR.t160 VSS 0.07594f ; **FLOATING
C1334 VR.t143 VSS 0.07594f ; **FLOATING
C1335 VR.t31 VSS 0.07594f ; **FLOATING
C1336 VR.t155 VSS 0.07811f ; **FLOATING
C1337 VR.t225 VSS 0.07662f ; **FLOATING
C1338 VR.t224 VSS 0.07542f ; **FLOATING
C1339 VR.t223 VSS 0.07542f ; **FLOATING
C1340 VR.t222 VSS 0.07542f ; **FLOATING
C1341 VR.t221 VSS 0.07542f ; **FLOATING
C1342 VR.t220 VSS 0.07542f ; **FLOATING
C1343 VR.t219 VSS 0.07542f ; **FLOATING
C1344 VR.t218 VSS 0.07559f ; **FLOATING
C1345 VR.n31 VSS 0.23282f ; **FLOATING
C1346 VR.n32 VSS 0.21782f ; **FLOATING
C1347 VR.n33 VSS 0.23282f ; **FLOATING
C1348 VR.n34 VSS 0.21782f ; **FLOATING
C1349 VR.n35 VSS 0.23282f ; **FLOATING
C1350 VR.n36 VSS 0.21782f ; **FLOATING
C1351 VR.n37 VSS 0.24972f ; **FLOATING
C1352 VR.n38 VSS 0.21782f ; **FLOATING
C1353 VR.n39 VSS 0.07285f ; **FLOATING
C1354 VR.n40 VSS 0.07947f ; **FLOATING
C1355 VR.n41 VSS 0.02532f ; **FLOATING
C1356 VR.n42 VSS 0.0418f ; **FLOATING
C1357 VR.n43 VSS 0.02532f ; **FLOATING
C1358 VR.n44 VSS 0.0418f ; **FLOATING
C1359 VR.n45 VSS 0.02532f ; **FLOATING
C1360 VR.n46 VSS 0.0418f ; **FLOATING
C1361 VR.n47 VSS 0.02532f ; **FLOATING
C1362 VR.n48 VSS 0.0418f ; **FLOATING
C1363 VR.n49 VSS 0.02531f ; **FLOATING
C1364 VR.n50 VSS 0.07557f ; **FLOATING
C1365 VR.n51 VSS 0.0419f ; **FLOATING
C1366 VR.n52 VSS 0.02531f ; **FLOATING
C1367 VR.n53 VSS 0.07557f ; **FLOATING
C1368 VR.n54 VSS 0.0419f ; **FLOATING
C1369 VR.n55 VSS 2.76279f ; **FLOATING
C1370 VR.n56 VSS 0.02531f ; **FLOATING
C1371 VR.n57 VSS 0.07557f ; **FLOATING
C1372 VR.n58 VSS 0.0419f ; **FLOATING
C1373 VR.n59 VSS 0.09407f ; **FLOATING
C1374 VR.n60 VSS 0.0419f ; **FLOATING
C1375 VR.n61 VSS 0.04525f ; **FLOATING
C1376 VR.n62 VSS 0.2292f ; **FLOATING
C1377 VR.n63 VSS 0.04409f ; **FLOATING
C1378 VR.n64 VSS 0.03892f ; **FLOATING
C1379 VR.n65 VSS 0.18666f ; **FLOATING
C1380 VR.n66 VSS 0.03836f ; **FLOATING
C1381 VR.n67 VSS 0.03892f ; **FLOATING
C1382 VR.n68 VSS 0.18666f ; **FLOATING
C1383 VR.n69 VSS 0.03836f ; **FLOATING
C1384 VR.n70 VSS 0.03892f ; **FLOATING
C1385 VR.n71 VSS 0.18666f ; **FLOATING
C1386 VR.n72 VSS 0.03836f ; **FLOATING
C1387 VR.n73 VSS 0.03892f ; **FLOATING
C1388 VR.n74 VSS 0.18666f ; **FLOATING
C1389 VR.n75 VSS 0.03836f ; **FLOATING
C1390 VR.n76 VSS 0.04525f ; **FLOATING
C1391 VR.n77 VSS 0.2292f ; **FLOATING
C1392 VR.n78 VSS 0.04409f ; **FLOATING
C1393 VR.n79 VSS 0.03892f ; **FLOATING
C1394 VR.n80 VSS 0.18666f ; **FLOATING
C1395 VR.n81 VSS 0.03836f ; **FLOATING
C1396 VR.n82 VSS 0.04525f ; **FLOATING
C1397 VR.n83 VSS 0.2292f ; **FLOATING
C1398 VR.n84 VSS 0.04409f ; **FLOATING
C1399 VR.n85 VSS 0.04525f ; **FLOATING
C1400 VR.n86 VSS 0.2292f ; **FLOATING
C1401 VR.n87 VSS 0.04409f ; **FLOATING
C1402 VR.n88 VSS 0.03892f ; **FLOATING
C1403 VR.n89 VSS 0.18666f ; **FLOATING
C1404 VR.n90 VSS 0.03836f ; **FLOATING
C1405 VR.n91 VSS 0.03892f ; **FLOATING
C1406 VR.n92 VSS 0.18666f ; **FLOATING
C1407 VR.n93 VSS 0.03836f ; **FLOATING
C1408 VR.n94 VSS 0.04525f ; **FLOATING
C1409 VR.n95 VSS 0.2292f ; **FLOATING
C1410 VR.n96 VSS 0.04409f ; **FLOATING
C1411 VR.n97 VSS 0.04525f ; **FLOATING
C1412 VR.n98 VSS 0.2292f ; **FLOATING
C1413 VR.n99 VSS 0.04409f ; **FLOATING
C1414 VR.n100 VSS 0.04525f ; **FLOATING
C1415 VR.n101 VSS 0.2292f ; **FLOATING
C1416 VR.n102 VSS 0.04409f ; **FLOATING
C1417 VR.n103 VSS 0.03892f ; **FLOATING
C1418 VR.n104 VSS 0.18666f ; **FLOATING
C1419 VR.n105 VSS 0.03836f ; **FLOATING
C1420 VR.n106 VSS 0.03892f ; **FLOATING
C1421 VR.n107 VSS 0.18666f ; **FLOATING
C1422 VR.n108 VSS 0.03836f ; **FLOATING
C1423 VR.n109 VSS 0.03892f ; **FLOATING
C1424 VR.n110 VSS 0.18666f ; **FLOATING
C1425 VR.n111 VSS 0.03836f ; **FLOATING
C1426 VR.n112 VSS 0.03892f ; **FLOATING
C1427 VR.n113 VSS 0.18666f ; **FLOATING
C1428 VR.n114 VSS 0.03836f ; **FLOATING
C1429 VR.n115 VSS 0.03892f ; **FLOATING
C1430 VR.n116 VSS 0.18666f ; **FLOATING
C1431 VR.n117 VSS 0.03836f ; **FLOATING
C1432 VR.n118 VSS 0.03892f ; **FLOATING
C1433 VR.n119 VSS 0.18666f ; **FLOATING
C1434 VR.n120 VSS 0.03836f ; **FLOATING
C1435 VR.n121 VSS 0.03892f ; **FLOATING
C1436 VR.n122 VSS 0.18666f ; **FLOATING
C1437 VR.n123 VSS 0.03836f ; **FLOATING
C1438 VR.n124 VSS 0.03892f ; **FLOATING
C1439 VR.n125 VSS 0.18666f ; **FLOATING
C1440 VR.n126 VSS 0.03836f ; **FLOATING
C1441 VR.n127 VSS 0.04525f ; **FLOATING
C1442 VR.n128 VSS 0.2292f ; **FLOATING
C1443 VR.n129 VSS 0.04409f ; **FLOATING
C1444 VR.n130 VSS 0.04525f ; **FLOATING
C1445 VR.n131 VSS 0.2292f ; **FLOATING
C1446 VR.n132 VSS 0.04409f ; **FLOATING
C1447 VR.n133 VSS 0.04525f ; **FLOATING
C1448 VR.n134 VSS 0.2292f ; **FLOATING
C1449 VR.n135 VSS 0.04409f ; **FLOATING
C1450 VR.n136 VSS 0.04525f ; **FLOATING
C1451 VR.n137 VSS 0.2292f ; **FLOATING
C1452 VR.n138 VSS 0.04409f ; **FLOATING
C1453 VR.n139 VSS 0.03892f ; **FLOATING
C1454 VR.n140 VSS 0.18666f ; **FLOATING
C1455 VR.n141 VSS 0.03836f ; **FLOATING
C1456 VR.n142 VSS 1.34968f ; **FLOATING
C1457 VR.n143 VSS 1.99097f ; **FLOATING
C1458 VR.n144 VSS 0.19766f ; **FLOATING
C1459 VR.n145 VSS 0.19766f ; **FLOATING
C1460 VR.n146 VSS 0.19834f ; **FLOATING
C1461 VR.t205 VSS 0.27347f ; **FLOATING
C1462 VR.n147 VSS 0.05237f ; **FLOATING
C1463 VR.t136 VSS 0.24857f ; **FLOATING
C1464 VR.n148 VSS 0.05237f ; **FLOATING
C1465 VR.t103 VSS 0.24857f ; **FLOATING
C1466 VR.n149 VSS 0.05237f ; **FLOATING
C1467 VR.t144 VSS 0.27347f ; **FLOATING
C1468 VR.n150 VSS 0.05237f ; **FLOATING
C1469 VR.t200 VSS 0.24857f ; **FLOATING
C1470 VR.n151 VSS 0.05237f ; **FLOATING
C1471 VR.t217 VSS 0.27347f ; **FLOATING
C1472 VR.n152 VSS 0.05237f ; **FLOATING
C1473 VR.t115 VSS 0.24857f ; **FLOATING
C1474 VR.n153 VSS 0.05237f ; **FLOATING
C1475 VR.t119 VSS 0.24857f ; **FLOATING
C1476 VR.n154 VSS 0.05237f ; **FLOATING
C1477 VR.t186 VSS 0.24857f ; **FLOATING
C1478 VR.n155 VSS 0.05237f ; **FLOATING
C1479 VR.t89 VSS 0.24857f ; **FLOATING
C1480 VR.n156 VSS 0.05237f ; **FLOATING
C1481 VR.t166 VSS 0.24857f ; **FLOATING
C1482 VR.n157 VSS 0.05237f ; **FLOATING
C1483 VR.t57 VSS 0.24857f ; **FLOATING
C1484 VR.n158 VSS 0.05237f ; **FLOATING
C1485 VR.t10 VSS 0.24857f ; **FLOATING
C1486 VR.n159 VSS 0.05237f ; **FLOATING
C1487 VR.t23 VSS 0.24857f ; **FLOATING
C1488 VR.n160 VSS 0.05237f ; **FLOATING
C1489 VR.n161 VSS 0.05232f ; **FLOATING
C1490 VR.n162 VSS 0.05232f ; **FLOATING
C1491 VR.n163 VSS 0.05232f ; **FLOATING
C1492 VR.n164 VSS 0.05232f ; **FLOATING
C1493 VR.n165 VSS 0.05232f ; **FLOATING
C1494 VR.n166 VSS 0.05232f ; **FLOATING
C1495 VR.n167 VSS 0.05232f ; **FLOATING
C1496 VR.n168 VSS 0.05232f ; **FLOATING
C1497 VR.n169 VSS 0.05232f ; **FLOATING
C1498 VR.n170 VSS 0.05232f ; **FLOATING
C1499 VR.n171 VSS 0.05232f ; **FLOATING
C1500 VR.n172 VSS 0.11827f ; **FLOATING
C1501 VR.n173 VSS 0.0496f ; **FLOATING
C1502 VR.n174 VSS 0.22154f ; **FLOATING
C1503 VR.n175 VSS 0.0496f ; **FLOATING
C1504 VR.n176 VSS 0.0496f ; **FLOATING
C1505 VR.n177 VSS 0.22154f ; **FLOATING
C1506 VR.n178 VSS 0.0496f ; **FLOATING
C1507 VR.n179 VSS 0.0496f ; **FLOATING
C1508 VR.n180 VSS 0.22154f ; **FLOATING
C1509 VR.n181 VSS 0.0496f ; **FLOATING
C1510 VR.n182 VSS 0.0496f ; **FLOATING
C1511 VR.n183 VSS 0.22154f ; **FLOATING
C1512 VR.n184 VSS 0.0496f ; **FLOATING
C1513 VR.t203 VSS 0.19911f ; **FLOATING
C1514 VR.n185 VSS 0.04457f ; **FLOATING
C1515 VR.t134 VSS 0.19911f ; **FLOATING
C1516 VR.n186 VSS 0.04457f ; **FLOATING
C1517 VR.t138 VSS 0.19911f ; **FLOATING
C1518 VR.n187 VSS 0.04457f ; **FLOATING
C1519 VR.t132 VSS 0.19911f ; **FLOATING
C1520 VR.n188 VSS 0.04457f ; **FLOATING
C1521 VR.t151 VSS 0.19911f ; **FLOATING
C1522 VR.n189 VSS 0.04457f ; **FLOATING
C1523 VR.t215 VSS 0.19911f ; **FLOATING
C1524 VR.n190 VSS 0.04457f ; **FLOATING
C1525 VR.t117 VSS 0.19911f ; **FLOATING
C1526 VR.n191 VSS 0.04457f ; **FLOATING
C1527 VR.t164 VSS 0.19911f ; **FLOATING
C1528 VR.n192 VSS 0.04457f ; **FLOATING
C1529 VR.t65 VSS 0.19911f ; **FLOATING
C1530 VR.n193 VSS 0.04457f ; **FLOATING
C1531 VR.t81 VSS 0.19911f ; **FLOATING
C1532 VR.n194 VSS 0.04457f ; **FLOATING
C1533 VR.t184 VSS 0.19911f ; **FLOATING
C1534 VR.n195 VSS 0.04457f ; **FLOATING
C1535 VR.t4 VSS 0.19911f ; **FLOATING
C1536 VR.n196 VSS 0.04457f ; **FLOATING
C1537 VR.t19 VSS 0.19911f ; **FLOATING
C1538 VR.n197 VSS 0.04457f ; **FLOATING
C1539 VR.t121 VSS 0.19911f ; **FLOATING
C1540 VR.n198 VSS 0.04457f ; **FLOATING
C1541 VR.t109 VSS 0.19911f ; **FLOATING
C1542 VR.n199 VSS 0.04457f ; **FLOATING
C1543 VR.t41 VSS 0.19911f ; **FLOATING
C1544 VR.n200 VSS 0.04457f ; **FLOATING
C1545 VR.n201 VSS 0.04451f ; **FLOATING
C1546 VR.n202 VSS 0.04451f ; **FLOATING
C1547 VR.n203 VSS 0.04451f ; **FLOATING
C1548 VR.n204 VSS 0.04451f ; **FLOATING
C1549 VR.n205 VSS 0.04451f ; **FLOATING
C1550 VR.n206 VSS 0.04451f ; **FLOATING
C1551 VR.n207 VSS 0.04451f ; **FLOATING
C1552 VR.n208 VSS 0.04451f ; **FLOATING
C1553 VR.n209 VSS 0.04451f ; **FLOATING
C1554 VR.n210 VSS 0.04451f ; **FLOATING
C1555 VR.n211 VSS 0.04451f ; **FLOATING
C1556 VR.n212 VSS 0.04451f ; **FLOATING
C1557 VR.n213 VSS 0.04451f ; **FLOATING
C1558 VR.n214 VSS 0.04451f ; **FLOATING
C1559 VR.n215 VSS 0.04451f ; **FLOATING
C1560 VR.n216 VSS 0.04451f ; **FLOATING
C1561 VR.n217 VSS 0.90411f ; **FLOATING
C1562 VR.n218 VSS 0.06066f ; **FLOATING
C1563 VR.t45 VSS 0.03676f ; **FLOATING
C1564 VR.t49 VSS 0.03707f ; **FLOATING
C1565 VR.t51 VSS 0.03676f ; **FLOATING
C1566 VR.n219 VSS 0.08861f ; **FLOATING
C1567 VR.n220 VSS 0.06061f ; **FLOATING
C1568 VR.n221 VSS 0.22154f ; **FLOATING
C1569 VR.t50 VSS 0.16435f ; **FLOATING
C1570 VR.t48 VSS 0.07862f ; **FLOATING
C1571 VR.n222 VSS 0.05241f ; **FLOATING
C1572 VR.t46 VSS 0.07862f ; **FLOATING
C1573 VR.t44 VSS 0.16435f ; **FLOATING
C1574 VR.n223 VSS 3.57506f ; **FLOATING
C1575 VR.n224 VSS 0.06066f ; **FLOATING
C1576 VR.t94 VSS 0.03676f ; **FLOATING
C1577 VR.t98 VSS 0.03707f ; **FLOATING
C1578 VR.t100 VSS 0.03676f ; **FLOATING
C1579 VR.n225 VSS 0.08861f ; **FLOATING
C1580 VR.n226 VSS 0.06061f ; **FLOATING
C1581 VR.n227 VSS 0.22154f ; **FLOATING
C1582 VR.t99 VSS 0.16435f ; **FLOATING
C1583 VR.t97 VSS 0.07862f ; **FLOATING
C1584 VR.n228 VSS 0.05241f ; **FLOATING
C1585 VR.t95 VSS 0.07862f ; **FLOATING
C1586 VR.t93 VSS 0.16435f ; **FLOATING
C1587 VR.n229 VSS 3.04581f ; **FLOATING
C1588 VR.n230 VSS 3.74589f ; **FLOATING
C1589 VR.n231 VSS 0.18666f ; **FLOATING
C1590 VR.t135 VSS 0.02352f ; **FLOATING
C1591 VR.n232 VSS 0.03677f ; **FLOATING
C1592 VR.n233 VSS 0.05401f ; **FLOATING
C1593 VR.n234 VSS 0.16982f ; **FLOATING
C1594 VR.n235 VSS 0.18666f ; **FLOATING
C1595 VR.t204 VSS 0.02352f ; **FLOATING
C1596 VR.n236 VSS 0.03677f ; **FLOATING
C1597 VR.n237 VSS 0.05401f ; **FLOATING
C1598 VR.n238 VSS 0.07922f ; **FLOATING
C1599 VR.n239 VSS 4.72799f ; **FLOATING
C1600 VR.n240 VSS 1.34785f ; **FLOATING
C1601 VR.n241 VSS 0.2292f ; **FLOATING
C1602 VR.t137 VSS 0.04767f ; **FLOATING
C1603 VR.n242 VSS 0.09577f ; **FLOATING
C1604 VR.n243 VSS 0.05997f ; **FLOATING
C1605 VR.n244 VSS 0.1756f ; **FLOATING
C1606 VR.n245 VSS 0.085f ; **FLOATING
C1607 VR.n246 VSS 4.82218f ; **FLOATING
C1608 VR.n247 VSS 1.36028f ; **FLOATING
C1609 VR.n248 VSS 0.18666f ; **FLOATING
C1610 VR.t152 VSS 0.02352f ; **FLOATING
C1611 VR.n249 VSS 0.03677f ; **FLOATING
C1612 VR.n250 VSS 0.05401f ; **FLOATING
C1613 VR.n251 VSS 2.74643f ; **FLOATING
C1614 VR.n252 VSS 0.2292f ; **FLOATING
C1615 VR.t201 VSS 0.04767f ; **FLOATING
C1616 VR.n253 VSS 0.09577f ; **FLOATING
C1617 VR.n254 VSS 0.05997f ; **FLOATING
C1618 VR.n255 VSS 0.1756f ; **FLOATING
C1619 VR.n256 VSS 0.085f ; **FLOATING
C1620 VR.n257 VSS 4.03919f ; **FLOATING
C1621 VR.n258 VSS 3.92769f ; **FLOATING
C1622 VR.n259 VSS 0.2292f ; **FLOATING
C1623 VR.t116 VSS 0.04767f ; **FLOATING
C1624 VR.n260 VSS 0.09577f ; **FLOATING
C1625 VR.n261 VSS 0.05997f ; **FLOATING
C1626 VR.n262 VSS 0.1756f ; **FLOATING
C1627 VR.n263 VSS 0.085f ; **FLOATING
C1628 VR.n264 VSS 4.03919f ; **FLOATING
C1629 VR.n265 VSS 2.17014f ; **FLOATING
C1630 VR.t2 VSS 0.58817f ; **FLOATING
C1631 VR.n266 VSS 0.24999f ; **FLOATING
C1632 VR.n267 VSS 0.04693f ; **FLOATING
C1633 VR.n268 VSS 0.03068f ; **FLOATING
C1634 VR.n269 VSS 0.03068f ; **FLOATING
C1635 VR.n270 VSS 0.03068f ; **FLOATING
C1636 VR.n271 VSS 0.03068f ; **FLOATING
C1637 VR.n272 VSS 0.04458f ; **FLOATING
C1638 VR.n273 VSS 0.06543f ; **FLOATING
C1639 VR.n274 VSS 0.04693f ; **FLOATING
C1640 VR.n275 VSS 0.03068f ; **FLOATING
C1641 VR.n276 VSS 0.03068f ; **FLOATING
C1642 VR.n277 VSS 0.03068f ; **FLOATING
C1643 VR.n278 VSS 0.03068f ; **FLOATING
C1644 VR.n279 VSS 0.03725f ; **FLOATING
C1645 VR.n280 VSS 0.0471f ; **FLOATING
C1646 VR.n281 VSS 0.03076f ; **FLOATING
C1647 VR.n282 VSS 0.03076f ; **FLOATING
C1648 VR.n283 VSS 0.03076f ; **FLOATING
C1649 VR.n284 VSS 0.03076f ; **FLOATING
C1650 VR.n285 VSS 0.04466f ; **FLOATING
C1651 VR.n286 VSS 0.06551f ; **FLOATING
C1652 VR.n287 VSS 0.0471f ; **FLOATING
C1653 VR.n288 VSS 0.03076f ; **FLOATING
C1654 VR.n289 VSS 0.03076f ; **FLOATING
C1655 VR.n290 VSS 0.03076f ; **FLOATING
C1656 VR.n291 VSS 0.03076f ; **FLOATING
C1657 VR.n292 VSS 0.03733f ; **FLOATING
C1658 VR.n293 VSS 0.18666f ; **FLOATING
C1659 VR.t118 VSS 0.02352f ; **FLOATING
C1660 VR.n294 VSS 0.03677f ; **FLOATING
C1661 VR.n295 VSS 0.05401f ; **FLOATING
C1662 VR.n296 VSS 0.16982f ; **FLOATING
C1663 VR.n297 VSS 0.18666f ; **FLOATING
C1664 VR.t216 VSS 0.02352f ; **FLOATING
C1665 VR.n298 VSS 0.03677f ; **FLOATING
C1666 VR.n299 VSS 0.05401f ; **FLOATING
C1667 VR.n300 VSS 0.07922f ; **FLOATING
C1668 VR.n301 VSS 2.86651f ; **FLOATING
C1669 VR.n302 VSS 3.14578f ; **FLOATING
C1670 VR.n303 VSS 0.71126f ; **FLOATING
C1671 VR.n304 VSS 0.06066f ; **FLOATING
C1672 VR.t34 VSS 0.03676f ; **FLOATING
C1673 VR.t38 VSS 0.03707f ; **FLOATING
C1674 VR.t40 VSS 0.03676f ; **FLOATING
C1675 VR.n305 VSS 0.08861f ; **FLOATING
C1676 VR.n306 VSS 0.06061f ; **FLOATING
C1677 VR.n307 VSS 0.22154f ; **FLOATING
C1678 VR.t39 VSS 0.16435f ; **FLOATING
C1679 VR.t37 VSS 0.07862f ; **FLOATING
C1680 VR.n308 VSS 0.05241f ; **FLOATING
C1681 VR.t35 VSS 0.07862f ; **FLOATING
C1682 VR.t33 VSS 0.16435f ; **FLOATING
C1683 VR.n309 VSS 3.57506f ; **FLOATING
C1684 VR.n310 VSS 0.06066f ; **FLOATING
C1685 VR.t68 VSS 0.03676f ; **FLOATING
C1686 VR.t72 VSS 0.03707f ; **FLOATING
C1687 VR.t74 VSS 0.03676f ; **FLOATING
C1688 VR.n311 VSS 0.08861f ; **FLOATING
C1689 VR.n312 VSS 0.06061f ; **FLOATING
C1690 VR.n313 VSS 0.22154f ; **FLOATING
C1691 VR.t73 VSS 0.16435f ; **FLOATING
C1692 VR.t71 VSS 0.07862f ; **FLOATING
C1693 VR.n314 VSS 0.05241f ; **FLOATING
C1694 VR.t69 VSS 0.07862f ; **FLOATING
C1695 VR.t67 VSS 0.16435f ; **FLOATING
C1696 VR.n315 VSS 3.04581f ; **FLOATING
C1697 VR.n316 VSS 3.42021f ; **FLOATING
C1698 VR.n317 VSS 0.96077f ; **FLOATING
C1699 VR.n318 VSS 0.2292f ; **FLOATING
C1700 VR.t104 VSS 0.04767f ; **FLOATING
C1701 VR.n319 VSS 0.09577f ; **FLOATING
C1702 VR.n320 VSS 0.05997f ; **FLOATING
C1703 VR.n321 VSS 0.88568f ; **FLOATING
C1704 VR.n322 VSS 4.41936f ; **FLOATING
C1705 VR.n323 VSS 0.2292f ; **FLOATING
C1706 VR.t120 VSS 0.04767f ; **FLOATING
C1707 VR.n324 VSS 0.09577f ; **FLOATING
C1708 VR.n325 VSS 0.05997f ; **FLOATING
C1709 VR.n326 VSS 1.69269f ; **FLOATING
C1710 VR.n327 VSS 3.32786f ; **FLOATING
C1711 VR.n328 VSS 0.2292f ; **FLOATING
C1712 VR.t187 VSS 0.04767f ; **FLOATING
C1713 VR.n329 VSS 0.09577f ; **FLOATING
C1714 VR.n330 VSS 0.05997f ; **FLOATING
C1715 VR.n331 VSS 1.69269f ; **FLOATING
C1716 VR.n332 VSS 3.25267f ; **FLOATING
C1717 VR.n333 VSS 0.2292f ; **FLOATING
C1718 VR.t90 VSS 0.04767f ; **FLOATING
C1719 VR.n334 VSS 0.09577f ; **FLOATING
C1720 VR.n335 VSS 0.05997f ; **FLOATING
C1721 VR.n336 VSS 1.69269f ; **FLOATING
C1722 VR.n337 VSS 4.45797f ; **FLOATING
C1723 VR.t28 VSS 0.03697f ; **FLOATING
C1724 VR.t22 VSS 0.03697f ; **FLOATING
C1725 VR.t7 VSS 0.03676f ; **FLOATING
C1726 VR.n338 VSS 0.02531f ; **FLOATING
C1727 VR.t9 VSS 0.03697f ; **FLOATING
C1728 VR.t15 VSS 0.03676f ; **FLOATING
C1729 VR.t14 VSS 0.2014f ; **FLOATING
C1730 VR.t8 VSS 0.12799f ; **FLOATING
C1731 VR.t29 VSS 0.12799f ; **FLOATING
C1732 VR.t27 VSS 0.096f ; **FLOATING
C1733 VR.n339 VSS 0.064f ; **FLOATING
C1734 VR.t25 VSS 0.096f ; **FLOATING
C1735 VR.t21 VSS 0.12799f ; **FLOATING
C1736 VR.t12 VSS 0.12799f ; **FLOATING
C1737 VR.t6 VSS 0.2014f ; **FLOATING
C1738 VR.n340 VSS 0.18666f ; **FLOATING
C1739 VR.t110 VSS 0.02352f ; **FLOATING
C1740 VR.n341 VSS 0.03677f ; **FLOATING
C1741 VR.n342 VSS 0.05401f ; **FLOATING
C1742 VR.n343 VSS 0.09404f ; **FLOATING
C1743 VR.n344 VSS 0.18666f ; **FLOATING
C1744 VR.t122 VSS 0.02352f ; **FLOATING
C1745 VR.n345 VSS 0.03677f ; **FLOATING
C1746 VR.n346 VSS 0.05401f ; **FLOATING
C1747 VR.n347 VSS 0.09404f ; **FLOATING
C1748 VR.t56 VSS 0.03676f ; **FLOATING
C1749 VR.t163 VSS 0.03697f ; **FLOATING
C1750 VR.t171 VSS 0.03697f ; **FLOATING
C1751 VR.t62 VSS 0.03697f ; **FLOATING
C1752 VR.t64 VSS 0.03676f ; **FLOATING
C1753 VR.t63 VSS 0.2014f ; **FLOATING
C1754 VR.t61 VSS 0.12799f ; **FLOATING
C1755 VR.t172 VSS 0.12799f ; **FLOATING
C1756 VR.t170 VSS 0.096f ; **FLOATING
C1757 VR.n348 VSS 0.064f ; **FLOATING
C1758 VR.t168 VSS 0.096f ; **FLOATING
C1759 VR.t162 VSS 0.12799f ; **FLOATING
C1760 VR.t59 VSS 0.12799f ; **FLOATING
C1761 VR.t55 VSS 0.2014f ; **FLOATING
C1762 VR.n349 VSS 0.18666f ; **FLOATING
C1763 VR.t20 VSS 0.02352f ; **FLOATING
C1764 VR.n350 VSS 0.03677f ; **FLOATING
C1765 VR.n351 VSS 0.05401f ; **FLOATING
C1766 VR.n352 VSS 0.09404f ; **FLOATING
C1767 VR.n353 VSS 0.18666f ; **FLOATING
C1768 VR.t5 VSS 0.02352f ; **FLOATING
C1769 VR.n354 VSS 0.03677f ; **FLOATING
C1770 VR.n355 VSS 0.05401f ; **FLOATING
C1771 VR.n356 VSS 0.09404f ; **FLOATING
C1772 VR.t106 VSS 0.03676f ; **FLOATING
C1773 VR.t124 VSS 0.03697f ; **FLOATING
C1774 VR.t128 VSS 0.03697f ; **FLOATING
C1775 VR.t108 VSS 0.03697f ; **FLOATING
C1776 VR.t114 VSS 0.03676f ; **FLOATING
C1777 VR.t113 VSS 0.2014f ; **FLOATING
C1778 VR.t107 VSS 0.12799f ; **FLOATING
C1779 VR.t129 VSS 0.12799f ; **FLOATING
C1780 VR.t127 VSS 0.096f ; **FLOATING
C1781 VR.n357 VSS 0.064f ; **FLOATING
C1782 VR.t125 VSS 0.096f ; **FLOATING
C1783 VR.t123 VSS 0.12799f ; **FLOATING
C1784 VR.t111 VSS 0.12799f ; **FLOATING
C1785 VR.t105 VSS 0.2014f ; **FLOATING
C1786 VR.n358 VSS 0.18666f ; **FLOATING
C1787 VR.t185 VSS 0.02352f ; **FLOATING
C1788 VR.n359 VSS 0.03677f ; **FLOATING
C1789 VR.n360 VSS 0.05401f ; **FLOATING
C1790 VR.n361 VSS 0.09404f ; **FLOATING
C1791 VR.n362 VSS 0.18666f ; **FLOATING
C1792 VR.t82 VSS 0.02352f ; **FLOATING
C1793 VR.n363 VSS 0.03677f ; **FLOATING
C1794 VR.n364 VSS 0.05401f ; **FLOATING
C1795 VR.n365 VSS 0.09404f ; **FLOATING
C1796 VR.t189 VSS 0.03676f ; **FLOATING
C1797 VR.t80 VSS 0.03697f ; **FLOATING
C1798 VR.t86 VSS 0.03697f ; **FLOATING
C1799 VR.t193 VSS 0.03697f ; **FLOATING
C1800 VR.t195 VSS 0.03676f ; **FLOATING
C1801 VR.t194 VSS 0.2014f ; **FLOATING
C1802 VR.t192 VSS 0.12799f ; **FLOATING
C1803 VR.t87 VSS 0.12799f ; **FLOATING
C1804 VR.t85 VSS 0.096f ; **FLOATING
C1805 VR.n366 VSS 0.064f ; **FLOATING
C1806 VR.t83 VSS 0.096f ; **FLOATING
C1807 VR.t79 VSS 0.12799f ; **FLOATING
C1808 VR.t190 VSS 0.12799f ; **FLOATING
C1809 VR.t188 VSS 0.2014f ; **FLOATING
C1810 VR.n367 VSS 0.18666f ; **FLOATING
C1811 VR.t66 VSS 0.02352f ; **FLOATING
C1812 VR.n368 VSS 0.03677f ; **FLOATING
C1813 VR.n369 VSS 0.05401f ; **FLOATING
C1814 VR.n370 VSS 0.09404f ; **FLOATING
C1815 VR.n371 VSS 0.18666f ; **FLOATING
C1816 VR.t165 VSS 0.02352f ; **FLOATING
C1817 VR.n372 VSS 0.03677f ; **FLOATING
C1818 VR.n373 VSS 0.05401f ; **FLOATING
C1819 VR.n374 VSS 0.09404f ; **FLOATING
C1820 VR.n375 VSS 12.4055f ; **FLOATING
C1821 VR.n376 VSS 0.2292f ; **FLOATING
C1822 VR.t24 VSS 0.04767f ; **FLOATING
C1823 VR.n377 VSS 0.09577f ; **FLOATING
C1824 VR.n378 VSS 0.05997f ; **FLOATING
C1825 VR.n379 VSS 3.24928f ; **FLOATING
C1826 VR.n380 VSS 0.2292f ; **FLOATING
C1827 VR.t11 VSS 0.04767f ; **FLOATING
C1828 VR.n381 VSS 0.09577f ; **FLOATING
C1829 VR.n382 VSS 0.05997f ; **FLOATING
C1830 VR.n383 VSS 2.77964f ; **FLOATING
C1831 VR.n384 VSS 3.54764f ; **FLOATING
C1832 VR.n385 VSS 0.2292f ; **FLOATING
C1833 VR.t58 VSS 0.04767f ; **FLOATING
C1834 VR.n386 VSS 0.09577f ; **FLOATING
C1835 VR.n387 VSS 0.05997f ; **FLOATING
C1836 VR.n388 VSS 2.77964f ; **FLOATING
C1837 VR.n389 VSS 2.16427f ; **FLOATING
C1838 VR.n390 VSS 0.2292f ; **FLOATING
C1839 VR.t167 VSS 0.04767f ; **FLOATING
C1840 VR.n391 VSS 0.09577f ; **FLOATING
C1841 VR.n392 VSS 0.05997f ; **FLOATING
C1842 VR.n393 VSS 2.77964f ; **FLOATING
C1843 VR.n394 VSS 2.0458f ; **FLOATING
C1844 VR.n395 VSS 1.09997f ; **FLOATING
C1845 VR.n396 VSS 0.18666f ; **FLOATING
C1846 VR.t133 VSS 0.02352f ; **FLOATING
C1847 VR.n397 VSS 0.03677f ; **FLOATING
C1848 VR.n398 VSS 0.05401f ; **FLOATING
C1849 VR.n399 VSS 0.16982f ; **FLOATING
C1850 VR.n400 VSS 0.18666f ; **FLOATING
C1851 VR.t139 VSS 0.02352f ; **FLOATING
C1852 VR.n401 VSS 0.03677f ; **FLOATING
C1853 VR.n402 VSS 0.05401f ; **FLOATING
C1854 VR.n403 VSS 0.07922f ; **FLOATING
C1855 VR.n404 VSS 2.86651f ; **FLOATING
C1856 VR.n405 VSS 3.01291f ; **FLOATING
C1857 VR.n406 VSS 0.70093f ; **FLOATING
C1858 VR.n407 VSS 0.18666f ; **FLOATING
C1859 VR.t42 VSS 0.02352f ; **FLOATING
C1860 VR.n408 VSS 0.03677f ; **FLOATING
C1861 VR.n409 VSS 0.05401f ; **FLOATING
C1862 VR.n410 VSS 1.67353f ; **FLOATING
C1863 VR.n411 VSS 3.53485f ; **FLOATING
.ends

.subckt vco_ring4 VCTRL B0 B1 LOIP LOIN LOQP LOQN VR VDD VSS
XPEX VSS VDD VCTRL B0 B1 LOIP LOIN LOQP LOQN VR vco_ring4_flat
.ends
.end
