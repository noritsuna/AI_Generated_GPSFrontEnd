** sch_path: /home/noritsuna/GPS/xschem/tb_lna.sch
**.subckt tb_lna
VDD vdd gc 3.3
XB nb pb vdd gc bias_gen
LG gc 0 0.5n
VRF s0 0 dc 0 ac 1
RS50 s0 s1 50
LP s1 0 1
CP s1 0 1a
LSER s1 s2 1p
CSER s2 c0 10p
LP2 c0 c0b 1
CB2 c0b 0 1u
CP2 c0 0 1a
LCON c0 t0 0.6n
CCON t0 0 0.15p
LT0 t0 u0 0.441052n
RT0 u0 t1 0.0825708
CT0 t1 0 0.0501647p
LT1 t1 u1 0.441052n
RT1 u1 t2 0.0825708
CT1 t2 0 0.0501647p
LT2 t2 u2 0.441052n
RT2 u2 t3 0.0825708
CT2 t3 0 0.0501647p
LT3 t3 u3 0.441052n
RT3 u3 t4 0.0825708
CT3 t4 0 0.0501647p
LT4 t4 u4 0.441052n
RT4 u4 t5 0.0825708
CT4 t5 0 0.0501647p
LT5 t5 u5 0.441052n
RT5 u5 t6 0.0825708
CT5 t6 0 0.0501647p
LVIA t6 t7 0.4n
CVIA t7 0 0.1p
LT7 t7 u7 0.395934n
RT7 u7 t8 0.0741241
CT7 t8 0 0.045033p
LT8 t8 u8 0.395934n
RT8 u8 t9 0.0741241
CT8 t9 0 0.045033p
LT9 t9 u9 0.395934n
RT9 u9 t10 0.0741241
CT9 t10 0 0.045033p
LT10 t10 u10 0.395934n
RT10 u10 t11 0.0741241
CT10 t11 0 0.045033p
LT11 t11 u11 0.395934n
RT11 u11 t12 0.0741241
CT11 t12 0 0.045033p
LT12 t12 u12 0.395934n
RT12 u12 t13 0.0741241
CT12 t13 0 0.045033p
CBF t13 0 0.06p
LW t13 w1 3n
RWB w1 pad 0.5
CPV pad vdd 5.4e-13
CPS pad gc 7e-13
DN0 gc pad diode_nd2ps_06v0 area=150e-12 pj=106e-6
DP0 pad vdd diode_pd2nw_06v0 area=150e-12 pj=106e-6
DN1 gc pad diode_nd2ps_06v0 area=150e-12 pj=106e-6
DP1 pad vdd diode_pd2nw_06v0 area=150e-12 pj=106e-6
DN2 gc pad diode_nd2ps_06v0 area=150e-12 pj=106e-6
DP2 pad vdd diode_pd2nw_06v0 area=150e-12 pj=106e-6
DN3 gc pad diode_nd2ps_06v0 area=150e-12 pj=106e-6
DP3 pad vdd diode_pd2nw_06v0 area=150e-12 pj=106e-6
RW pad rfin 1.2
CW rfin gc 2.39038e-14
XLNA rfin pb rfp rfn vdd gc lna_nc
VL1P l1p gc 2.0
VL1N l1n gc 0
VL2P l2p gc 2.0
VL2N l2n gc 0
VL3P l3p gc 2.0
VL3N l3n gc 0
VL4P l4p gc 2.0
VL4N l4n gc 0
XM rfp rfn l1p l1n l2p l2n l3p l3n l4p l4n nb ifip ifin ifqp ifqn vdd gc mixer_iq
**** begin user architecture code
 .include /home/noritsuna/pdk/gf180mcuD/libs.tech/ngspice/design.ngspice
.lib /home/noritsuna/pdk/gf180mcuD/libs.tech/ngspice/sm141064.ngspice typical
.lib /home/noritsuna/pdk/gf180mcuD/libs.tech/ngspice/sm141064.ngspice res_typical
.lib /home/noritsuna/pdk/gf180mcuD/libs.tech/ngspice/sm141064.ngspice mimcap_typical
.lib /home/noritsuna/pdk/gf180mcuD/libs.tech/ngspice/sm141064.ngspice diode_typical

.temp 27
.nodeset v(vdd) = 3.3
.nodeset v(gc) = 5.65487e-22
.nodeset v(xb.nbc) = 1.29604
.nodeset v(xb.pbc) = 1.54691
.nodeset v(xb.nr) = 0.247195
.nodeset v(xb.xrb.11) = 0.00436844
.nodeset v(xb.xrb.21) = 0.242827
.nodeset v(xb.st) = 0.0200775
.nodeset v(nb) = 0.959766
.nodeset v(pb) = 2.05645
.nodeset v(s0) = 0
.nodeset v(s1) = 0
.nodeset v(s2) = 0
.nodeset v(c0) = 1.00487
.nodeset v(c0b) = 1.00487
.nodeset v(t0) = 1.00487
.nodeset v(u0) = 1.00487
.nodeset v(t1) = 1.00487
.nodeset v(u1) = 1.00487
.nodeset v(t2) = 1.00487
.nodeset v(u2) = 1.00487
.nodeset v(t3) = 1.00487
.nodeset v(u3) = 1.00487
.nodeset v(t4) = 1.00487
.nodeset v(u4) = 1.00487
.nodeset v(t5) = 1.00487
.nodeset v(u5) = 1.00487
.nodeset v(t6) = 1.00487
.nodeset v(t7) = 1.00487
.nodeset v(u7) = 1.00487
.nodeset v(t8) = 1.00487
.nodeset v(u8) = 1.00487
.nodeset v(t9) = 1.00487
.nodeset v(u9) = 1.00487
.nodeset v(t10) = 1.00487
.nodeset v(u10) = 1.00487
.nodeset v(t11) = 1.00487
.nodeset v(u11) = 1.00487
.nodeset v(t12) = 1.00487
.nodeset v(u12) = 1.00487
.nodeset v(t13) = 1.00487
.nodeset v(w1) = 1.00487
.nodeset v(pad) = 1.00487
.nodeset v(rfin) = 1.00487
.nodeset v(xlna.xpex.a_7845_15740.t2) = 2.31478
.nodeset v(rfn) = 1.30354
.nodeset v(rfp) = 1.30354
.nodeset v(xlna.xpex.a_7845_15740.t0) = 2.31478
.nodeset v(xlna.xpex.x15.11) = 0.966628
.nodeset v(xlna.xpex.x15.21) = 0.0264109
.nodeset v(xlna.xpex.a_7040_29924.t8) = 0.993914
.nodeset v(xlna.xpex.pb.t16) = 2.05645
.nodeset v(xlna.xpex.a_1749_16889.t1) = 2.09771
.nodeset v(xlna.xpex.pb.t21) = 2.05645
.nodeset v(xlna.xpex.a_1749_16889.t0) = 2.09702
.nodeset v(xlna.xpex.pb.t23) = 2.05645
.nodeset v(xlna.xpex.pb.t28) = 2.05645
.nodeset v(xlna.xpex.a_7040_29924.t0) = 0.996506
.nodeset v(xlna.xpex.pb.t40) = 2.05645
.nodeset v(xlna.xpex.a_1749_16889.t2) = 2.09785
.nodeset v(xlna.xpex.pb.t13) = 2.05645
.nodeset v(xlna.xpex.pb.t9) = 2.05645
.nodeset v(xlna.xpex.a_1749_16889.t5) = 2.09387
.nodeset v(xlna.xpex.a_1749_16889.t6) = 2.09128
.nodeset v(xlna.xpex.a_7845_15740.t1) = 2.31327
.nodeset v(xlna.xpex.pb.t38) = 2.05645
.nodeset v(xlna.xpex.a_7040_29924.t4) = 0.994242
.nodeset v(xlna.xpex.a_7040_29924.t5) = 0.993914
.nodeset v(xlna.xpex.pb.t43) = 2.05645
.nodeset v(xlna.xpex.a_7040_29924.t1) = 0.997082
.nodeset v(xlna.xpex.pb.t11) = 2.05645
.nodeset v(xlna.xpex.pb.t2) = 2.05645
.nodeset v(xlna.xpex.a_7040_29924.t3) = 0.997301
.nodeset v(xlna.xpex.a_7040_29924.t2) = 0.997204
.nodeset v(xlna.xpex.pb.t7) = 2.05645
.nodeset v(xlna.xpex.pb.t19) = 2.05645
.nodeset v(xlna.xpex.pb.t35) = 2.05645
.nodeset v(xlna.xpex.a_1749_16889.t11) = 2.09246
.nodeset v(xlna.xpex.pb.t31) = 2.05645
.nodeset v(xlna.xpex.a_1749_16889.t9) = 2.09246
.nodeset v(xlna.xpex.pb.t14) = 2.05645
.nodeset v(xlna.xpex.a_1749_16889.t30) = 2.09246
.nodeset v(xlna.xpex.a_1749_16889.t16) = 2.09246
.nodeset v(xlna.xpex.pb.t0) = 2.05645
.nodeset v(xlna.xpex.a_1749_16889.t4) = 2.09802
.nodeset v(xlna.xpex.a_1749_16889.t3) = 2.09794
.nodeset v(xlna.xpex.pb.t5) = 2.05645
.nodeset v(xlna.xpex.pb.t17) = 2.05645
.nodeset v(xlna.xpex.pb.t20) = 2.05645
.nodeset v(xlna.xpex.pb.t33) = 2.05645
.nodeset v(xlna.xpex.a_1749_16889.t14) = 2.09246
.nodeset v(xlna.xpex.a_1749_16889.t17) = 2.09246
.nodeset v(xlna.xpex.pb.t24) = 2.05645
.nodeset v(xlna.xpex.pb.t29) = 2.05645
.nodeset v(xlna.xpex.pb.t41) = 2.05645
.nodeset v(xlna.xpex.a_1749_16889.t21) = 2.09246
.nodeset v(xlna.xpex.a_1749_16889.t24) = 2.09246
.nodeset v(xlna.xpex.pb.t12) = 2.05645
.nodeset v(xlna.xpex.a_1749_16889.t10) = 2.09246
.nodeset v(xlna.xpex.a_1749_16889.t19) = 2.09246
.nodeset v(xlna.xpex.a_1749_16889.t22) = 2.09246
.nodeset v(xlna.xpex.pb.t3) = 2.05645
.nodeset v(xlna.xpex.pb.t15) = 2.05645
.nodeset v(xlna.xpex.pb.t36) = 2.05645
.nodeset v(xlna.xpex.a_1749_16889.t26) = 2.09246
.nodeset v(xlna.xpex.a_1749_16889.t29) = 2.09246
.nodeset v(xlna.xpex.a_1749_16889.t15) = 2.09246
.nodeset v(xlna.xpex.pb.t22) = 2.05645
.nodeset v(xlna.xpex.pb.t27) = 2.05645
.nodeset v(xlna.xpex.a_1749_16889.t18) = 2.09246
.nodeset v(xlna.xpex.pb.t39) = 2.05645
.nodeset v(xlna.xpex.a_1749_16889.t27) = 2.09246
.nodeset v(xlna.xpex.pb.t42) = 2.05645
.nodeset v(xlna.xpex.a_1749_16889.t13) = 2.09246
.nodeset v(xlna.xpex.pb.t10) = 2.05645
.nodeset v(xlna.xpex.a_1749_16889.t31) = 2.09246
.nodeset v(xlna.xpex.a_1749_16889.t20) = 2.09246
.nodeset v(xlna.xpex.a_1749_16889.t23) = 2.09246
.nodeset v(xlna.xpex.pb.t34) = 2.05645
.nodeset v(xlna.xpex.a_1749_16889.t32) = 2.09246
.nodeset v(xlna.xpex.a_1749_16889.t12) = 2.09246
.nodeset v(xlna.xpex.pb.t25) = 2.05645
.nodeset v(xlna.xpex.pb.t37) = 2.05645
.nodeset v(xlna.xpex.a_1749_16889.t25) = 2.09246
.nodeset v(xlna.xpex.x307.11) = 0.0267256
.nodeset v(xlna.xpex.x307.21) = 0.978146
.nodeset v(xlna.xpex.a_1749_16889.t28) = 2.09246
.nodeset v(xlna.xpex.pb.t8) = 2.05645
.nodeset v(xlna.xpex.pb.t4) = 2.05645
.nodeset v(xlna.xpex.pb.t32) = 2.05645
.nodeset v(xlna.xpex.x326.11) = 3.2645
.nodeset v(xlna.xpex.x326.21) = 2.35029
.nodeset v(xlna.xpex.x337.11) = 0.996084
.nodeset v(xlna.xpex.x337.21) = 0.996084
.nodeset v(xlna.xpex.a_7040_29924.t7) = 0.996084
.nodeset v(xlna.xpex.x347.11) = 3.27327
.nodeset v(xlna.xpex.x347.21) = 2.639
.nodeset v(xlna.xpex.pb.t1) = 2.05645
.nodeset v(xlna.xpex.pb.t6) = 2.05645
.nodeset v(xlna.xpex.pb.t18) = 2.05645
.nodeset v(xlna.xpex.pb.t30) = 2.05645
.nodeset v(xlna.xpex.a_1749_16889.t8) = 2.09246
.nodeset v(xlna.xpex.pb.t26) = 2.05645
.nodeset v(xlna.xpex.pb.n42) = 2.05645
.nodeset v(xlna.xpex.pb.n21) = 2.05645
.nodeset v(xlna.xpex.pb.n31) = 2.05645
.nodeset v(xlna.xpex.pb.n0) = 2.05645
.nodeset v(xlna.xpex.pb.n10) = 2.05645
.nodeset v(xlna.xpex.pb.n30) = 2.05645
.nodeset v(xlna.xpex.pb.n29) = 2.05645
.nodeset v(xlna.xpex.pb.n28) = 2.05645
.nodeset v(xlna.xpex.pb.n27) = 2.05645
.nodeset v(xlna.xpex.pb.n26) = 2.05645
.nodeset v(xlna.xpex.pb.n25) = 2.05645
.nodeset v(xlna.xpex.pb.n24) = 2.05645
.nodeset v(xlna.xpex.pb.n23) = 2.05645
.nodeset v(xlna.xpex.pb.n22) = 2.05645
.nodeset v(xlna.xpex.pb.n40) = 2.05645
.nodeset v(xlna.xpex.pb.n39) = 2.05645
.nodeset v(xlna.xpex.pb.n38) = 2.05645
.nodeset v(xlna.xpex.pb.n37) = 2.05645
.nodeset v(xlna.xpex.pb.n36) = 2.05645
.nodeset v(xlna.xpex.pb.n35) = 2.05645
.nodeset v(xlna.xpex.pb.n34) = 2.05645
.nodeset v(xlna.xpex.pb.n33) = 2.05645
.nodeset v(xlna.xpex.pb.n32) = 2.05645
.nodeset v(xlna.xpex.pb.n9) = 2.05645
.nodeset v(xlna.xpex.pb.n8) = 2.05645
.nodeset v(xlna.xpex.pb.n7) = 2.05645
.nodeset v(xlna.xpex.pb.n6) = 2.05645
.nodeset v(xlna.xpex.pb.n5) = 2.05645
.nodeset v(xlna.xpex.pb.n4) = 2.05645
.nodeset v(xlna.xpex.pb.n3) = 2.05645
.nodeset v(xlna.xpex.pb.n2) = 2.05645
.nodeset v(xlna.xpex.pb.n1) = 2.05645
.nodeset v(xlna.xpex.pb.n19) = 2.05645
.nodeset v(xlna.xpex.pb.n18) = 2.05645
.nodeset v(xlna.xpex.pb.n17) = 2.05645
.nodeset v(xlna.xpex.pb.n16) = 2.05645
.nodeset v(xlna.xpex.pb.n15) = 2.05645
.nodeset v(xlna.xpex.pb.n14) = 2.05645
.nodeset v(xlna.xpex.pb.n13) = 2.05645
.nodeset v(xlna.xpex.pb.n12) = 2.05645
.nodeset v(xlna.xpex.pb.n11) = 2.05645
.nodeset v(xlna.xpex.pb.n20) = 2.05645
.nodeset v(xlna.xpex.pb.n41) = 2.05645
.nodeset v(xlna.xpex.a_1749_16889.n1) = 2.09246
.nodeset v(xlna.xpex.a_1749_16889.n12) = 2.09246
.nodeset v(xlna.xpex.a_1749_16889.n2) = 2.09246
.nodeset v(xlna.xpex.a_1749_16889.n3) = 2.09246
.nodeset v(xlna.xpex.a_1749_16889.n4) = 2.09246
.nodeset v(xlna.xpex.a_1749_16889.n5) = 2.09246
.nodeset v(xlna.xpex.a_1749_16889.n6) = 2.09246
.nodeset v(xlna.xpex.a_1749_16889.n7) = 2.09246
.nodeset v(xlna.xpex.a_1749_16889.n8) = 2.09246
.nodeset v(xlna.xpex.a_1749_16889.n9) = 2.09246
.nodeset v(xlna.xpex.a_1749_16889.n10) = 2.09246
.nodeset v(xlna.xpex.a_1749_16889.n11) = 2.09246
.nodeset v(xlna.xpex.a_1749_16889.n22) = 2.09246
.nodeset v(xlna.xpex.a_1749_16889.n21) = 2.09246
.nodeset v(xlna.xpex.a_1749_16889.n20) = 2.09246
.nodeset v(xlna.xpex.a_1749_16889.n19) = 2.09246
.nodeset v(xlna.xpex.a_1749_16889.n18) = 2.09246
.nodeset v(xlna.xpex.a_1749_16889.n17) = 2.09246
.nodeset v(xlna.xpex.a_1749_16889.n16) = 2.09246
.nodeset v(xlna.xpex.a_1749_16889.n15) = 2.09246
.nodeset v(xlna.xpex.a_1749_16889.n14) = 2.09246
.nodeset v(xlna.xpex.a_1749_16889.n13) = 2.09246
.nodeset v(xlna.xpex.a_1749_16889.n0) = 2.09246
.nodeset v(xlna.xpex.a_1749_16889.n23) = 2.09246
.nodeset v(l1p) = 2
.nodeset v(l1n) = 5.65487e-22
.nodeset v(l2p) = 2
.nodeset v(l2n) = 5.65487e-22
.nodeset v(l3p) = 2
.nodeset v(l3n) = 5.65487e-22
.nodeset v(l4p) = 2
.nodeset v(l4n) = 1.82934e-06
.nodeset v(xm.vbrf) = 1.30354
.nodeset v(xm.xrt1.11) = 1.30354
.nodeset v(xm.xrt1.21) = 1.30354
.nodeset v(xm.xrt2.11) = 1.30354
.nodeset v(xm.xrt2.21) = 1.30354
.nodeset v(xm.xrba.11) = 1.31188
.nodeset v(xm.xrba.21) = 3.29166
.nodeset v(xm.xrbb.11) = 0.00834167
.nodeset v(xm.xrbb.21) = 1.2952
.nodeset v(xm.vlou) = 1.7937
.nodeset v(xm.xrlua.11) = 1.7964
.nodeset v(xm.xrlua.21) = 3.29731
.nodeset v(xm.xrlub.11) = 0.00269106
.nodeset v(xm.xrlub.21) = 1.79101
.nodeset v(xm.vlol) = 1.19855
.nodeset v(xm.xrlla.11) = 1.20127
.nodeset v(xm.xrlla.21) = 3.29728
.nodeset v(xm.xrllb.11) = 0.00271735
.nodeset v(xm.xrllb.21) = 1.19583
.nodeset v(xm.gl1p) = 1.7937
.nodeset v(xm.xracl1p.11) = 1.7937
.nodeset v(xm.xracl1p.21) = 1.7937
.nodeset v(xm.gl1n) = 1.7937
.nodeset v(xm.xracl1n.11) = 1.7937
.nodeset v(xm.xracl1n.21) = 1.7937
.nodeset v(xm.gl2p) = 1.7937
.nodeset v(xm.xracl2p.11) = 1.7937
.nodeset v(xm.xracl2p.21) = 1.7937
.nodeset v(xm.gl2n) = 1.7937
.nodeset v(xm.xracl2n.11) = 1.7937
.nodeset v(xm.xracl2n.21) = 1.7937
.nodeset v(xm.gl3p) = 1.19855
.nodeset v(xm.xracl3p.11) = 1.19855
.nodeset v(xm.xracl3p.21) = 1.19855
.nodeset v(xm.gl3n) = 1.19855
.nodeset v(xm.xracl3n.11) = 1.19855
.nodeset v(xm.xracl3n.21) = 1.19855
.nodeset v(xm.gl4p) = 1.19855
.nodeset v(xm.xracl4p.11) = 1.19855
.nodeset v(xm.xracl4p.21) = 1.19855
.nodeset v(xm.gl4n) = 1.19855
.nodeset v(xm.xracl4n.11) = 1.19855
.nodeset v(xm.xracl4n.21) = 1.19855
.nodeset v(xm.ti) = 0.224238
.nodeset v(xm.xpi) = 0.300285
.nodeset v(xm.xni) = 0.300285
.nodeset v(xm.mpai) = 0.840616
.nodeset v(xm.mpbi) = 0.840616
.nodeset v(ifip) = 2.06265
.nodeset v(ifin) = 2.06265
.nodeset v(xm.mnai) = 0.840616
.nodeset v(xm.mnbi) = 0.840616
.nodeset v(xm.xrl1i.11) = 2.08282
.nodeset v(xm.xrl1i.21) = 3.27983
.nodeset v(xm.xrl2i.11) = 2.08282
.nodeset v(xm.xrl2i.21) = 3.27983
.nodeset v(xm.tq) = 0.224238
.nodeset v(xm.xpq) = 0.300285
.nodeset v(xm.xnq) = 0.300285
.nodeset v(xm.mpaq) = 0.840616
.nodeset v(xm.mpbq) = 0.840616
.nodeset v(ifqp) = 2.06265
.nodeset v(ifqn) = 2.06265
.nodeset v(xm.mnaq) = 0.840616
.nodeset v(xm.mnbq) = 0.840616
.nodeset v(xm.xrl1q.11) = 2.08282
.nodeset v(xm.xrl1q.21) = 3.27983
.nodeset v(xm.xrl2q.11) = 2.08282
.nodeset v(xm.xrl2q.21) = 3.27983
.control
set num_threads=1
op
alter LP = 1
alter CP = 1e-18
alter LP2 = 1
alter CP2 = 1e-18
alter LSER = 1.5e-09
alter CSER = 1e-11
ac lin 1 1.57542e+09 1.57542e+09
let zin = v(s1)/(-i(VRF))
let s11 = db((zin-50)/(zin+50))
let gd = db((v(rfp)-v(rfn))/v(s0)*2)
let zr = real(zin)
let zi = imag(zin)
noise v(rfp,rfn) VRF lin 1 1.57542e+09 1.57542e+09
setplot noise1
let nf = 10*log10(1+(inoise_spectrum^2-4*1.380649e-23*300*50)/(4*1.380649e-23*300*50))
echo RES lp=0 se=1.5 lp2=0 f=1.57542e+09 zr=$&ac1.zr zi=$&ac1.zi s11=$&ac1.s11 gd=$&ac1.gd nf=$&nf
destroy all
alter LP = 1
alter CP = 1e-18
alter LP2 = 1
alter CP2 = 1e-18
alter LSER = 1.5e-08
alter CSER = 1e-11
ac lin 1 1.57542e+09 1.57542e+09
let zin = v(s1)/(-i(VRF))
let s11 = db((zin-50)/(zin+50))
let gd = db((v(rfp)-v(rfn))/v(s0)*2)
let zr = real(zin)
let zi = imag(zin)
noise v(rfp,rfn) VRF lin 1 1.57542e+09 1.57542e+09
setplot noise1
let nf = 10*log10(1+(inoise_spectrum^2-4*1.380649e-23*300*50)/(4*1.380649e-23*300*50))
echo RES lp=0 se=15 lp2=0 f=1.57542e+09 zr=$&ac1.zr zi=$&ac1.zi s11=$&ac1.s11 gd=$&ac1.gd nf=$&nf
destroy all
alter LP = 1
alter CP = 1e-18
alter LP2 = 1
alter CP2 = 1e-18
alter LSER = 1e-12
alter CSER = 6.8e-12
ac lin 1 1.57542e+09 1.57542e+09
let zin = v(s1)/(-i(VRF))
let s11 = db((zin-50)/(zin+50))
let gd = db((v(rfp)-v(rfn))/v(s0)*2)
let zr = real(zin)
let zi = imag(zin)
noise v(rfp,rfn) VRF lin 1 1.57542e+09 1.57542e+09
setplot noise1
let nf = 10*log10(1+(inoise_spectrum^2-4*1.380649e-23*300*50)/(4*1.380649e-23*300*50))
echo RES lp=0 se=-6.8 lp2=0 f=1.57542e+09 zr=$&ac1.zr zi=$&ac1.zi s11=$&ac1.s11 gd=$&ac1.gd nf=$&nf
destroy all
alter LP = 1.5e-09
alter CP = 1e-18
alter LP2 = 1
alter CP2 = 1e-18
alter LSER = 3.3e-09
alter CSER = 1e-11
ac lin 1 1.57542e+09 1.57542e+09
let zin = v(s1)/(-i(VRF))
let s11 = db((zin-50)/(zin+50))
let gd = db((v(rfp)-v(rfn))/v(s0)*2)
let zr = real(zin)
let zi = imag(zin)
noise v(rfp,rfn) VRF lin 1 1.57542e+09 1.57542e+09
setplot noise1
let nf = 10*log10(1+(inoise_spectrum^2-4*1.380649e-23*300*50)/(4*1.380649e-23*300*50))
echo RES lp=1.5 se=3.3 lp2=0 f=1.57542e+09 zr=$&ac1.zr zi=$&ac1.zi s11=$&ac1.s11 gd=$&ac1.gd nf=$&nf
destroy all
alter LP = 1.5e-09
alter CP = 1e-18
alter LP2 = 1
alter CP2 = 1e-18
alter LSER = 1e-12
alter CSER = 1.5e-12
ac lin 1 1.57542e+09 1.57542e+09
let zin = v(s1)/(-i(VRF))
let s11 = db((zin-50)/(zin+50))
let gd = db((v(rfp)-v(rfn))/v(s0)*2)
let zr = real(zin)
let zi = imag(zin)
noise v(rfp,rfn) VRF lin 1 1.57542e+09 1.57542e+09
setplot noise1
let nf = 10*log10(1+(inoise_spectrum^2-4*1.380649e-23*300*50)/(4*1.380649e-23*300*50))
echo RES lp=1.5 se=-1.5 lp2=0 f=1.57542e+09 zr=$&ac1.zr zi=$&ac1.zi s11=$&ac1.s11 gd=$&ac1.gd nf=$&nf
destroy all
alter LP = 1.5e-09
alter CP = 1e-18
alter LP2 = 1
alter CP2 = 1e-18
alter LSER = 1e-12
alter CSER = 8.2e-13
ac lin 1 1.57542e+09 1.57542e+09
let zin = v(s1)/(-i(VRF))
let s11 = db((zin-50)/(zin+50))
let gd = db((v(rfp)-v(rfn))/v(s0)*2)
let zr = real(zin)
let zi = imag(zin)
noise v(rfp,rfn) VRF lin 1 1.57542e+09 1.57542e+09
setplot noise1
let nf = 10*log10(1+(inoise_spectrum^2-4*1.380649e-23*300*50)/(4*1.380649e-23*300*50))
echo RES lp=1.5 se=-0.82 lp2=0 f=1.57542e+09 zr=$&ac1.zr zi=$&ac1.zi s11=$&ac1.s11 gd=$&ac1.gd nf=$&nf
destroy all
alter LP = 1.8e-09
alter CP = 1e-18
alter LP2 = 1
alter CP2 = 1e-18
alter LSER = 6.8e-09
alter CSER = 1e-11
ac lin 1 1.57542e+09 1.57542e+09
let zin = v(s1)/(-i(VRF))
let s11 = db((zin-50)/(zin+50))
let gd = db((v(rfp)-v(rfn))/v(s0)*2)
let zr = real(zin)
let zi = imag(zin)
noise v(rfp,rfn) VRF lin 1 1.57542e+09 1.57542e+09
setplot noise1
let nf = 10*log10(1+(inoise_spectrum^2-4*1.380649e-23*300*50)/(4*1.380649e-23*300*50))
echo RES lp=1.8 se=6.8 lp2=0 f=1.57542e+09 zr=$&ac1.zr zi=$&ac1.zi s11=$&ac1.s11 gd=$&ac1.gd nf=$&nf
destroy all
alter LP = 1.8e-09
alter CP = 1e-18
alter LP2 = 1
alter CP2 = 1e-18
alter LSER = 1e-12
alter CSER = 3.3e-12
ac lin 1 1.57542e+09 1.57542e+09
let zin = v(s1)/(-i(VRF))
let s11 = db((zin-50)/(zin+50))
let gd = db((v(rfp)-v(rfn))/v(s0)*2)
let zr = real(zin)
let zi = imag(zin)
noise v(rfp,rfn) VRF lin 1 1.57542e+09 1.57542e+09
setplot noise1
let nf = 10*log10(1+(inoise_spectrum^2-4*1.380649e-23*300*50)/(4*1.380649e-23*300*50))
echo RES lp=1.8 se=-3.3 lp2=0 f=1.57542e+09 zr=$&ac1.zr zi=$&ac1.zi s11=$&ac1.s11 gd=$&ac1.gd nf=$&nf
destroy all
alter LP = 2.2e-09
alter CP = 1e-18
alter LP2 = 1
alter CP2 = 1e-18
alter LSER = 1.5e-09
alter CSER = 1e-11
ac lin 1 1.57542e+09 1.57542e+09
let zin = v(s1)/(-i(VRF))
let s11 = db((zin-50)/(zin+50))
let gd = db((v(rfp)-v(rfn))/v(s0)*2)
let zr = real(zin)
let zi = imag(zin)
noise v(rfp,rfn) VRF lin 1 1.57542e+09 1.57542e+09
setplot noise1
let nf = 10*log10(1+(inoise_spectrum^2-4*1.380649e-23*300*50)/(4*1.380649e-23*300*50))
echo RES lp=2.2 se=1.5 lp2=0 f=1.57542e+09 zr=$&ac1.zr zi=$&ac1.zi s11=$&ac1.s11 gd=$&ac1.gd nf=$&nf
destroy all
alter LP = 2.2e-09
alter CP = 1e-18
alter LP2 = 1
alter CP2 = 1e-18
alter LSER = 1.5e-08
alter CSER = 1e-11
ac lin 1 1.57542e+09 1.57542e+09
let zin = v(s1)/(-i(VRF))
let s11 = db((zin-50)/(zin+50))
let gd = db((v(rfp)-v(rfn))/v(s0)*2)
let zr = real(zin)
let zi = imag(zin)
noise v(rfp,rfn) VRF lin 1 1.57542e+09 1.57542e+09
setplot noise1
let nf = 10*log10(1+(inoise_spectrum^2-4*1.380649e-23*300*50)/(4*1.380649e-23*300*50))
echo RES lp=2.2 se=15 lp2=0 f=1.57542e+09 zr=$&ac1.zr zi=$&ac1.zi s11=$&ac1.s11 gd=$&ac1.gd nf=$&nf
destroy all
alter LP = 2.2e-09
alter CP = 1e-18
alter LP2 = 1
alter CP2 = 1e-18
alter LSER = 1e-12
alter CSER = 6.8e-12
ac lin 1 1.57542e+09 1.57542e+09
let zin = v(s1)/(-i(VRF))
let s11 = db((zin-50)/(zin+50))
let gd = db((v(rfp)-v(rfn))/v(s0)*2)
let zr = real(zin)
let zi = imag(zin)
noise v(rfp,rfn) VRF lin 1 1.57542e+09 1.57542e+09
setplot noise1
let nf = 10*log10(1+(inoise_spectrum^2-4*1.380649e-23*300*50)/(4*1.380649e-23*300*50))
echo RES lp=2.2 se=-6.8 lp2=0 f=1.57542e+09 zr=$&ac1.zr zi=$&ac1.zi s11=$&ac1.s11 gd=$&ac1.gd nf=$&nf
destroy all
alter LP = 2.7e-09
alter CP = 1e-18
alter LP2 = 1
alter CP2 = 1e-18
alter LSER = 3.3e-09
alter CSER = 1e-11
ac lin 1 1.57542e+09 1.57542e+09
let zin = v(s1)/(-i(VRF))
let s11 = db((zin-50)/(zin+50))
let gd = db((v(rfp)-v(rfn))/v(s0)*2)
let zr = real(zin)
let zi = imag(zin)
noise v(rfp,rfn) VRF lin 1 1.57542e+09 1.57542e+09
setplot noise1
let nf = 10*log10(1+(inoise_spectrum^2-4*1.380649e-23*300*50)/(4*1.380649e-23*300*50))
echo RES lp=2.7 se=3.3 lp2=0 f=1.57542e+09 zr=$&ac1.zr zi=$&ac1.zi s11=$&ac1.s11 gd=$&ac1.gd nf=$&nf
destroy all
alter LP = 2.7e-09
alter CP = 1e-18
alter LP2 = 1
alter CP2 = 1e-18
alter LSER = 1e-12
alter CSER = 1.5e-12
ac lin 1 1.57542e+09 1.57542e+09
let zin = v(s1)/(-i(VRF))
let s11 = db((zin-50)/(zin+50))
let gd = db((v(rfp)-v(rfn))/v(s0)*2)
let zr = real(zin)
let zi = imag(zin)
noise v(rfp,rfn) VRF lin 1 1.57542e+09 1.57542e+09
setplot noise1
let nf = 10*log10(1+(inoise_spectrum^2-4*1.380649e-23*300*50)/(4*1.380649e-23*300*50))
echo RES lp=2.7 se=-1.5 lp2=0 f=1.57542e+09 zr=$&ac1.zr zi=$&ac1.zi s11=$&ac1.s11 gd=$&ac1.gd nf=$&nf
destroy all
alter LP = 2.7e-09
alter CP = 1e-18
alter LP2 = 1
alter CP2 = 1e-18
alter LSER = 1e-12
alter CSER = 8.2e-13
ac lin 1 1.57542e+09 1.57542e+09
let zin = v(s1)/(-i(VRF))
let s11 = db((zin-50)/(zin+50))
let gd = db((v(rfp)-v(rfn))/v(s0)*2)
let zr = real(zin)
let zi = imag(zin)
noise v(rfp,rfn) VRF lin 1 1.57542e+09 1.57542e+09
setplot noise1
let nf = 10*log10(1+(inoise_spectrum^2-4*1.380649e-23*300*50)/(4*1.380649e-23*300*50))
echo RES lp=2.7 se=-0.82 lp2=0 f=1.57542e+09 zr=$&ac1.zr zi=$&ac1.zi s11=$&ac1.s11 gd=$&ac1.gd nf=$&nf
destroy all
alter LP = 3.3e-09
alter CP = 1e-18
alter LP2 = 1
alter CP2 = 1e-18
alter LSER = 6.8e-09
alter CSER = 1e-11
ac lin 1 1.57542e+09 1.57542e+09
let zin = v(s1)/(-i(VRF))
let s11 = db((zin-50)/(zin+50))
let gd = db((v(rfp)-v(rfn))/v(s0)*2)
let zr = real(zin)
let zi = imag(zin)
noise v(rfp,rfn) VRF lin 1 1.57542e+09 1.57542e+09
setplot noise1
let nf = 10*log10(1+(inoise_spectrum^2-4*1.380649e-23*300*50)/(4*1.380649e-23*300*50))
echo RES lp=3.3 se=6.8 lp2=0 f=1.57542e+09 zr=$&ac1.zr zi=$&ac1.zi s11=$&ac1.s11 gd=$&ac1.gd nf=$&nf
destroy all
alter LP = 3.3e-09
alter CP = 1e-18
alter LP2 = 1
alter CP2 = 1e-18
alter LSER = 1e-12
alter CSER = 3.3e-12
ac lin 1 1.57542e+09 1.57542e+09
let zin = v(s1)/(-i(VRF))
let s11 = db((zin-50)/(zin+50))
let gd = db((v(rfp)-v(rfn))/v(s0)*2)
let zr = real(zin)
let zi = imag(zin)
noise v(rfp,rfn) VRF lin 1 1.57542e+09 1.57542e+09
setplot noise1
let nf = 10*log10(1+(inoise_spectrum^2-4*1.380649e-23*300*50)/(4*1.380649e-23*300*50))
echo RES lp=3.3 se=-3.3 lp2=0 f=1.57542e+09 zr=$&ac1.zr zi=$&ac1.zi s11=$&ac1.s11 gd=$&ac1.gd nf=$&nf
destroy all
alter LP = 3.9e-09
alter CP = 1e-18
alter LP2 = 1
alter CP2 = 1e-18
alter LSER = 1.5e-09
alter CSER = 1e-11
ac lin 1 1.57542e+09 1.57542e+09
let zin = v(s1)/(-i(VRF))
let s11 = db((zin-50)/(zin+50))
let gd = db((v(rfp)-v(rfn))/v(s0)*2)
let zr = real(zin)
let zi = imag(zin)
noise v(rfp,rfn) VRF lin 1 1.57542e+09 1.57542e+09
setplot noise1
let nf = 10*log10(1+(inoise_spectrum^2-4*1.380649e-23*300*50)/(4*1.380649e-23*300*50))
echo RES lp=3.9 se=1.5 lp2=0 f=1.57542e+09 zr=$&ac1.zr zi=$&ac1.zi s11=$&ac1.s11 gd=$&ac1.gd nf=$&nf
destroy all
alter LP = 3.9e-09
alter CP = 1e-18
alter LP2 = 1
alter CP2 = 1e-18
alter LSER = 1.5e-08
alter CSER = 1e-11
ac lin 1 1.57542e+09 1.57542e+09
let zin = v(s1)/(-i(VRF))
let s11 = db((zin-50)/(zin+50))
let gd = db((v(rfp)-v(rfn))/v(s0)*2)
let zr = real(zin)
let zi = imag(zin)
noise v(rfp,rfn) VRF lin 1 1.57542e+09 1.57542e+09
setplot noise1
let nf = 10*log10(1+(inoise_spectrum^2-4*1.380649e-23*300*50)/(4*1.380649e-23*300*50))
echo RES lp=3.9 se=15 lp2=0 f=1.57542e+09 zr=$&ac1.zr zi=$&ac1.zi s11=$&ac1.s11 gd=$&ac1.gd nf=$&nf
destroy all
alter LP = 3.9e-09
alter CP = 1e-18
alter LP2 = 1
alter CP2 = 1e-18
alter LSER = 1e-12
alter CSER = 6.8e-12
ac lin 1 1.57542e+09 1.57542e+09
let zin = v(s1)/(-i(VRF))
let s11 = db((zin-50)/(zin+50))
let gd = db((v(rfp)-v(rfn))/v(s0)*2)
let zr = real(zin)
let zi = imag(zin)
noise v(rfp,rfn) VRF lin 1 1.57542e+09 1.57542e+09
setplot noise1
let nf = 10*log10(1+(inoise_spectrum^2-4*1.380649e-23*300*50)/(4*1.380649e-23*300*50))
echo RES lp=3.9 se=-6.8 lp2=0 f=1.57542e+09 zr=$&ac1.zr zi=$&ac1.zi s11=$&ac1.s11 gd=$&ac1.gd nf=$&nf
destroy all
alter LP = 4.7e-09
alter CP = 1e-18
alter LP2 = 1
alter CP2 = 1e-18
alter LSER = 3.3e-09
alter CSER = 1e-11
ac lin 1 1.57542e+09 1.57542e+09
let zin = v(s1)/(-i(VRF))
let s11 = db((zin-50)/(zin+50))
let gd = db((v(rfp)-v(rfn))/v(s0)*2)
let zr = real(zin)
let zi = imag(zin)
noise v(rfp,rfn) VRF lin 1 1.57542e+09 1.57542e+09
setplot noise1
let nf = 10*log10(1+(inoise_spectrum^2-4*1.380649e-23*300*50)/(4*1.380649e-23*300*50))
echo RES lp=4.7 se=3.3 lp2=0 f=1.57542e+09 zr=$&ac1.zr zi=$&ac1.zi s11=$&ac1.s11 gd=$&ac1.gd nf=$&nf
destroy all
alter LP = 4.7e-09
alter CP = 1e-18
alter LP2 = 1
alter CP2 = 1e-18
alter LSER = 1e-12
alter CSER = 1.5e-12
ac lin 1 1.57542e+09 1.57542e+09
let zin = v(s1)/(-i(VRF))
let s11 = db((zin-50)/(zin+50))
let gd = db((v(rfp)-v(rfn))/v(s0)*2)
let zr = real(zin)
let zi = imag(zin)
noise v(rfp,rfn) VRF lin 1 1.57542e+09 1.57542e+09
setplot noise1
let nf = 10*log10(1+(inoise_spectrum^2-4*1.380649e-23*300*50)/(4*1.380649e-23*300*50))
echo RES lp=4.7 se=-1.5 lp2=0 f=1.57542e+09 zr=$&ac1.zr zi=$&ac1.zi s11=$&ac1.s11 gd=$&ac1.gd nf=$&nf
destroy all
alter LP = 4.7e-09
alter CP = 1e-18
alter LP2 = 1
alter CP2 = 1e-18
alter LSER = 1e-12
alter CSER = 8.2e-13
ac lin 1 1.57542e+09 1.57542e+09
let zin = v(s1)/(-i(VRF))
let s11 = db((zin-50)/(zin+50))
let gd = db((v(rfp)-v(rfn))/v(s0)*2)
let zr = real(zin)
let zi = imag(zin)
noise v(rfp,rfn) VRF lin 1 1.57542e+09 1.57542e+09
setplot noise1
let nf = 10*log10(1+(inoise_spectrum^2-4*1.380649e-23*300*50)/(4*1.380649e-23*300*50))
echo RES lp=4.7 se=-0.82 lp2=0 f=1.57542e+09 zr=$&ac1.zr zi=$&ac1.zi s11=$&ac1.s11 gd=$&ac1.gd nf=$&nf
destroy all
alter LP = 5.6e-09
alter CP = 1e-18
alter LP2 = 1
alter CP2 = 1e-18
alter LSER = 6.8e-09
alter CSER = 1e-11
ac lin 1 1.57542e+09 1.57542e+09
let zin = v(s1)/(-i(VRF))
let s11 = db((zin-50)/(zin+50))
let gd = db((v(rfp)-v(rfn))/v(s0)*2)
let zr = real(zin)
let zi = imag(zin)
noise v(rfp,rfn) VRF lin 1 1.57542e+09 1.57542e+09
setplot noise1
let nf = 10*log10(1+(inoise_spectrum^2-4*1.380649e-23*300*50)/(4*1.380649e-23*300*50))
echo RES lp=5.6 se=6.8 lp2=0 f=1.57542e+09 zr=$&ac1.zr zi=$&ac1.zi s11=$&ac1.s11 gd=$&ac1.gd nf=$&nf
destroy all
alter LP = 5.6e-09
alter CP = 1e-18
alter LP2 = 1
alter CP2 = 1e-18
alter LSER = 1e-12
alter CSER = 3.3e-12
ac lin 1 1.57542e+09 1.57542e+09
let zin = v(s1)/(-i(VRF))
let s11 = db((zin-50)/(zin+50))
let gd = db((v(rfp)-v(rfn))/v(s0)*2)
let zr = real(zin)
let zi = imag(zin)
noise v(rfp,rfn) VRF lin 1 1.57542e+09 1.57542e+09
setplot noise1
let nf = 10*log10(1+(inoise_spectrum^2-4*1.380649e-23*300*50)/(4*1.380649e-23*300*50))
echo RES lp=5.6 se=-3.3 lp2=0 f=1.57542e+09 zr=$&ac1.zr zi=$&ac1.zi s11=$&ac1.s11 gd=$&ac1.gd nf=$&nf
destroy all
alter LP = 6.8e-09
alter CP = 1e-18
alter LP2 = 1
alter CP2 = 1e-18
alter LSER = 1.5e-09
alter CSER = 1e-11
ac lin 1 1.57542e+09 1.57542e+09
let zin = v(s1)/(-i(VRF))
let s11 = db((zin-50)/(zin+50))
let gd = db((v(rfp)-v(rfn))/v(s0)*2)
let zr = real(zin)
let zi = imag(zin)
noise v(rfp,rfn) VRF lin 1 1.57542e+09 1.57542e+09
setplot noise1
let nf = 10*log10(1+(inoise_spectrum^2-4*1.380649e-23*300*50)/(4*1.380649e-23*300*50))
echo RES lp=6.8 se=1.5 lp2=0 f=1.57542e+09 zr=$&ac1.zr zi=$&ac1.zi s11=$&ac1.s11 gd=$&ac1.gd nf=$&nf
destroy all
alter LP = 6.8e-09
alter CP = 1e-18
alter LP2 = 1
alter CP2 = 1e-18
alter LSER = 1.5e-08
alter CSER = 1e-11
ac lin 1 1.57542e+09 1.57542e+09
let zin = v(s1)/(-i(VRF))
let s11 = db((zin-50)/(zin+50))
let gd = db((v(rfp)-v(rfn))/v(s0)*2)
let zr = real(zin)
let zi = imag(zin)
noise v(rfp,rfn) VRF lin 1 1.57542e+09 1.57542e+09
setplot noise1
let nf = 10*log10(1+(inoise_spectrum^2-4*1.380649e-23*300*50)/(4*1.380649e-23*300*50))
echo RES lp=6.8 se=15 lp2=0 f=1.57542e+09 zr=$&ac1.zr zi=$&ac1.zi s11=$&ac1.s11 gd=$&ac1.gd nf=$&nf
destroy all
alter LP = 6.8e-09
alter CP = 1e-18
alter LP2 = 1
alter CP2 = 1e-18
alter LSER = 1e-12
alter CSER = 6.8e-12
ac lin 1 1.57542e+09 1.57542e+09
let zin = v(s1)/(-i(VRF))
let s11 = db((zin-50)/(zin+50))
let gd = db((v(rfp)-v(rfn))/v(s0)*2)
let zr = real(zin)
let zi = imag(zin)
noise v(rfp,rfn) VRF lin 1 1.57542e+09 1.57542e+09
setplot noise1
let nf = 10*log10(1+(inoise_spectrum^2-4*1.380649e-23*300*50)/(4*1.380649e-23*300*50))
echo RES lp=6.8 se=-6.8 lp2=0 f=1.57542e+09 zr=$&ac1.zr zi=$&ac1.zi s11=$&ac1.s11 gd=$&ac1.gd nf=$&nf
destroy all
alter LP = 8.2e-09
alter CP = 1e-18
alter LP2 = 1
alter CP2 = 1e-18
alter LSER = 3.3e-09
alter CSER = 1e-11
ac lin 1 1.57542e+09 1.57542e+09
let zin = v(s1)/(-i(VRF))
let s11 = db((zin-50)/(zin+50))
let gd = db((v(rfp)-v(rfn))/v(s0)*2)
let zr = real(zin)
let zi = imag(zin)
noise v(rfp,rfn) VRF lin 1 1.57542e+09 1.57542e+09
setplot noise1
let nf = 10*log10(1+(inoise_spectrum^2-4*1.380649e-23*300*50)/(4*1.380649e-23*300*50))
echo RES lp=8.2 se=3.3 lp2=0 f=1.57542e+09 zr=$&ac1.zr zi=$&ac1.zi s11=$&ac1.s11 gd=$&ac1.gd nf=$&nf
destroy all
alter LP = 8.2e-09
alter CP = 1e-18
alter LP2 = 1
alter CP2 = 1e-18
alter LSER = 1e-12
alter CSER = 1.5e-12
ac lin 1 1.57542e+09 1.57542e+09
let zin = v(s1)/(-i(VRF))
let s11 = db((zin-50)/(zin+50))
let gd = db((v(rfp)-v(rfn))/v(s0)*2)
let zr = real(zin)
let zi = imag(zin)
noise v(rfp,rfn) VRF lin 1 1.57542e+09 1.57542e+09
setplot noise1
let nf = 10*log10(1+(inoise_spectrum^2-4*1.380649e-23*300*50)/(4*1.380649e-23*300*50))
echo RES lp=8.2 se=-1.5 lp2=0 f=1.57542e+09 zr=$&ac1.zr zi=$&ac1.zi s11=$&ac1.s11 gd=$&ac1.gd nf=$&nf
destroy all
alter LP = 8.2e-09
alter CP = 1e-18
alter LP2 = 1
alter CP2 = 1e-18
alter LSER = 1e-12
alter CSER = 8.2e-13
ac lin 1 1.57542e+09 1.57542e+09
let zin = v(s1)/(-i(VRF))
let s11 = db((zin-50)/(zin+50))
let gd = db((v(rfp)-v(rfn))/v(s0)*2)
let zr = real(zin)
let zi = imag(zin)
noise v(rfp,rfn) VRF lin 1 1.57542e+09 1.57542e+09
setplot noise1
let nf = 10*log10(1+(inoise_spectrum^2-4*1.380649e-23*300*50)/(4*1.380649e-23*300*50))
echo RES lp=8.2 se=-0.82 lp2=0 f=1.57542e+09 zr=$&ac1.zr zi=$&ac1.zi s11=$&ac1.s11 gd=$&ac1.gd nf=$&nf
destroy all
alter LP = 1e-08
alter CP = 1e-18
alter LP2 = 1
alter CP2 = 1e-18
alter LSER = 6.8e-09
alter CSER = 1e-11
ac lin 1 1.57542e+09 1.57542e+09
let zin = v(s1)/(-i(VRF))
let s11 = db((zin-50)/(zin+50))
let gd = db((v(rfp)-v(rfn))/v(s0)*2)
let zr = real(zin)
let zi = imag(zin)
noise v(rfp,rfn) VRF lin 1 1.57542e+09 1.57542e+09
setplot noise1
let nf = 10*log10(1+(inoise_spectrum^2-4*1.380649e-23*300*50)/(4*1.380649e-23*300*50))
echo RES lp=10 se=6.8 lp2=0 f=1.57542e+09 zr=$&ac1.zr zi=$&ac1.zi s11=$&ac1.s11 gd=$&ac1.gd nf=$&nf
destroy all
alter LP = 1e-08
alter CP = 1e-18
alter LP2 = 1
alter CP2 = 1e-18
alter LSER = 1e-12
alter CSER = 3.3e-12
ac lin 1 1.57542e+09 1.57542e+09
let zin = v(s1)/(-i(VRF))
let s11 = db((zin-50)/(zin+50))
let gd = db((v(rfp)-v(rfn))/v(s0)*2)
let zr = real(zin)
let zi = imag(zin)
noise v(rfp,rfn) VRF lin 1 1.57542e+09 1.57542e+09
setplot noise1
let nf = 10*log10(1+(inoise_spectrum^2-4*1.380649e-23*300*50)/(4*1.380649e-23*300*50))
echo RES lp=10 se=-3.3 lp2=0 f=1.57542e+09 zr=$&ac1.zr zi=$&ac1.zi s11=$&ac1.s11 gd=$&ac1.gd nf=$&nf
destroy all
alter LP = 1.2e-08
alter CP = 1e-18
alter LP2 = 1
alter CP2 = 1e-18
alter LSER = 1.5e-09
alter CSER = 1e-11
ac lin 1 1.57542e+09 1.57542e+09
let zin = v(s1)/(-i(VRF))
let s11 = db((zin-50)/(zin+50))
let gd = db((v(rfp)-v(rfn))/v(s0)*2)
let zr = real(zin)
let zi = imag(zin)
noise v(rfp,rfn) VRF lin 1 1.57542e+09 1.57542e+09
setplot noise1
let nf = 10*log10(1+(inoise_spectrum^2-4*1.380649e-23*300*50)/(4*1.380649e-23*300*50))
echo RES lp=12 se=1.5 lp2=0 f=1.57542e+09 zr=$&ac1.zr zi=$&ac1.zi s11=$&ac1.s11 gd=$&ac1.gd nf=$&nf
destroy all
alter LP = 1.2e-08
alter CP = 1e-18
alter LP2 = 1
alter CP2 = 1e-18
alter LSER = 1.5e-08
alter CSER = 1e-11
ac lin 1 1.57542e+09 1.57542e+09
let zin = v(s1)/(-i(VRF))
let s11 = db((zin-50)/(zin+50))
let gd = db((v(rfp)-v(rfn))/v(s0)*2)
let zr = real(zin)
let zi = imag(zin)
noise v(rfp,rfn) VRF lin 1 1.57542e+09 1.57542e+09
setplot noise1
let nf = 10*log10(1+(inoise_spectrum^2-4*1.380649e-23*300*50)/(4*1.380649e-23*300*50))
echo RES lp=12 se=15 lp2=0 f=1.57542e+09 zr=$&ac1.zr zi=$&ac1.zi s11=$&ac1.s11 gd=$&ac1.gd nf=$&nf
destroy all
alter LP = 1.2e-08
alter CP = 1e-18
alter LP2 = 1
alter CP2 = 1e-18
alter LSER = 1e-12
alter CSER = 6.8e-12
ac lin 1 1.57542e+09 1.57542e+09
let zin = v(s1)/(-i(VRF))
let s11 = db((zin-50)/(zin+50))
let gd = db((v(rfp)-v(rfn))/v(s0)*2)
let zr = real(zin)
let zi = imag(zin)
noise v(rfp,rfn) VRF lin 1 1.57542e+09 1.57542e+09
setplot noise1
let nf = 10*log10(1+(inoise_spectrum^2-4*1.380649e-23*300*50)/(4*1.380649e-23*300*50))
echo RES lp=12 se=-6.8 lp2=0 f=1.57542e+09 zr=$&ac1.zr zi=$&ac1.zi s11=$&ac1.s11 gd=$&ac1.gd nf=$&nf
destroy all
alter LP = 1.5e-08
alter CP = 1e-18
alter LP2 = 1
alter CP2 = 1e-18
alter LSER = 3.3e-09
alter CSER = 1e-11
ac lin 1 1.57542e+09 1.57542e+09
let zin = v(s1)/(-i(VRF))
let s11 = db((zin-50)/(zin+50))
let gd = db((v(rfp)-v(rfn))/v(s0)*2)
let zr = real(zin)
let zi = imag(zin)
noise v(rfp,rfn) VRF lin 1 1.57542e+09 1.57542e+09
setplot noise1
let nf = 10*log10(1+(inoise_spectrum^2-4*1.380649e-23*300*50)/(4*1.380649e-23*300*50))
echo RES lp=15 se=3.3 lp2=0 f=1.57542e+09 zr=$&ac1.zr zi=$&ac1.zi s11=$&ac1.s11 gd=$&ac1.gd nf=$&nf
destroy all
alter LP = 1.5e-08
alter CP = 1e-18
alter LP2 = 1
alter CP2 = 1e-18
alter LSER = 1e-12
alter CSER = 1.5e-12
ac lin 1 1.57542e+09 1.57542e+09
let zin = v(s1)/(-i(VRF))
let s11 = db((zin-50)/(zin+50))
let gd = db((v(rfp)-v(rfn))/v(s0)*2)
let zr = real(zin)
let zi = imag(zin)
noise v(rfp,rfn) VRF lin 1 1.57542e+09 1.57542e+09
setplot noise1
let nf = 10*log10(1+(inoise_spectrum^2-4*1.380649e-23*300*50)/(4*1.380649e-23*300*50))
echo RES lp=15 se=-1.5 lp2=0 f=1.57542e+09 zr=$&ac1.zr zi=$&ac1.zi s11=$&ac1.s11 gd=$&ac1.gd nf=$&nf
destroy all
alter LP = 1.5e-08
alter CP = 1e-18
alter LP2 = 1
alter CP2 = 1e-18
alter LSER = 1e-12
alter CSER = 8.2e-13
ac lin 1 1.57542e+09 1.57542e+09
let zin = v(s1)/(-i(VRF))
let s11 = db((zin-50)/(zin+50))
let gd = db((v(rfp)-v(rfn))/v(s0)*2)
let zr = real(zin)
let zi = imag(zin)
noise v(rfp,rfn) VRF lin 1 1.57542e+09 1.57542e+09
setplot noise1
let nf = 10*log10(1+(inoise_spectrum^2-4*1.380649e-23*300*50)/(4*1.380649e-23*300*50))
echo RES lp=15 se=-0.82 lp2=0 f=1.57542e+09 zr=$&ac1.zr zi=$&ac1.zi s11=$&ac1.s11 gd=$&ac1.gd nf=$&nf
destroy all
alter LP = 1.8e-08
alter CP = 1e-18
alter LP2 = 1
alter CP2 = 1e-18
alter LSER = 6.8e-09
alter CSER = 1e-11
ac lin 1 1.57542e+09 1.57542e+09
let zin = v(s1)/(-i(VRF))
let s11 = db((zin-50)/(zin+50))
let gd = db((v(rfp)-v(rfn))/v(s0)*2)
let zr = real(zin)
let zi = imag(zin)
noise v(rfp,rfn) VRF lin 1 1.57542e+09 1.57542e+09
setplot noise1
let nf = 10*log10(1+(inoise_spectrum^2-4*1.380649e-23*300*50)/(4*1.380649e-23*300*50))
echo RES lp=18 se=6.8 lp2=0 f=1.57542e+09 zr=$&ac1.zr zi=$&ac1.zi s11=$&ac1.s11 gd=$&ac1.gd nf=$&nf
destroy all
alter LP = 1.8e-08
alter CP = 1e-18
alter LP2 = 1
alter CP2 = 1e-18
alter LSER = 1e-12
alter CSER = 3.3e-12
ac lin 1 1.57542e+09 1.57542e+09
let zin = v(s1)/(-i(VRF))
let s11 = db((zin-50)/(zin+50))
let gd = db((v(rfp)-v(rfn))/v(s0)*2)
let zr = real(zin)
let zi = imag(zin)
noise v(rfp,rfn) VRF lin 1 1.57542e+09 1.57542e+09
setplot noise1
let nf = 10*log10(1+(inoise_spectrum^2-4*1.380649e-23*300*50)/(4*1.380649e-23*300*50))
echo RES lp=18 se=-3.3 lp2=0 f=1.57542e+09 zr=$&ac1.zr zi=$&ac1.zi s11=$&ac1.s11 gd=$&ac1.gd nf=$&nf
destroy all
alter LP = 2.2e-08
alter CP = 1e-18
alter LP2 = 1
alter CP2 = 1e-18
alter LSER = 1.5e-09
alter CSER = 1e-11
ac lin 1 1.57542e+09 1.57542e+09
let zin = v(s1)/(-i(VRF))
let s11 = db((zin-50)/(zin+50))
let gd = db((v(rfp)-v(rfn))/v(s0)*2)
let zr = real(zin)
let zi = imag(zin)
noise v(rfp,rfn) VRF lin 1 1.57542e+09 1.57542e+09
setplot noise1
let nf = 10*log10(1+(inoise_spectrum^2-4*1.380649e-23*300*50)/(4*1.380649e-23*300*50))
echo RES lp=22 se=1.5 lp2=0 f=1.57542e+09 zr=$&ac1.zr zi=$&ac1.zi s11=$&ac1.s11 gd=$&ac1.gd nf=$&nf
destroy all
alter LP = 2.2e-08
alter CP = 1e-18
alter LP2 = 1
alter CP2 = 1e-18
alter LSER = 1.5e-08
alter CSER = 1e-11
ac lin 1 1.57542e+09 1.57542e+09
let zin = v(s1)/(-i(VRF))
let s11 = db((zin-50)/(zin+50))
let gd = db((v(rfp)-v(rfn))/v(s0)*2)
let zr = real(zin)
let zi = imag(zin)
noise v(rfp,rfn) VRF lin 1 1.57542e+09 1.57542e+09
setplot noise1
let nf = 10*log10(1+(inoise_spectrum^2-4*1.380649e-23*300*50)/(4*1.380649e-23*300*50))
echo RES lp=22 se=15 lp2=0 f=1.57542e+09 zr=$&ac1.zr zi=$&ac1.zi s11=$&ac1.s11 gd=$&ac1.gd nf=$&nf
destroy all
alter LP = 2.2e-08
alter CP = 1e-18
alter LP2 = 1
alter CP2 = 1e-18
alter LSER = 1e-12
alter CSER = 6.8e-12
ac lin 1 1.57542e+09 1.57542e+09
let zin = v(s1)/(-i(VRF))
let s11 = db((zin-50)/(zin+50))
let gd = db((v(rfp)-v(rfn))/v(s0)*2)
let zr = real(zin)
let zi = imag(zin)
noise v(rfp,rfn) VRF lin 1 1.57542e+09 1.57542e+09
setplot noise1
let nf = 10*log10(1+(inoise_spectrum^2-4*1.380649e-23*300*50)/(4*1.380649e-23*300*50))
echo RES lp=22 se=-6.8 lp2=0 f=1.57542e+09 zr=$&ac1.zr zi=$&ac1.zi s11=$&ac1.s11 gd=$&ac1.gd nf=$&nf
destroy all
alter LP = 1
alter CP = 1e-12
alter LP2 = 1
alter CP2 = 1e-18
alter LSER = 3.3e-09
alter CSER = 1e-11
ac lin 1 1.57542e+09 1.57542e+09
let zin = v(s1)/(-i(VRF))
let s11 = db((zin-50)/(zin+50))
let gd = db((v(rfp)-v(rfn))/v(s0)*2)
let zr = real(zin)
let zi = imag(zin)
noise v(rfp,rfn) VRF lin 1 1.57542e+09 1.57542e+09
setplot noise1
let nf = 10*log10(1+(inoise_spectrum^2-4*1.380649e-23*300*50)/(4*1.380649e-23*300*50))
echo RES lp=-1 se=3.3 lp2=0 f=1.57542e+09 zr=$&ac1.zr zi=$&ac1.zi s11=$&ac1.s11 gd=$&ac1.gd nf=$&nf
destroy all
alter LP = 1
alter CP = 1e-12
alter LP2 = 1
alter CP2 = 1e-18
alter LSER = 1e-12
alter CSER = 1.5e-12
ac lin 1 1.57542e+09 1.57542e+09
let zin = v(s1)/(-i(VRF))
let s11 = db((zin-50)/(zin+50))
let gd = db((v(rfp)-v(rfn))/v(s0)*2)
let zr = real(zin)
let zi = imag(zin)
noise v(rfp,rfn) VRF lin 1 1.57542e+09 1.57542e+09
setplot noise1
let nf = 10*log10(1+(inoise_spectrum^2-4*1.380649e-23*300*50)/(4*1.380649e-23*300*50))
echo RES lp=-1 se=-1.5 lp2=0 f=1.57542e+09 zr=$&ac1.zr zi=$&ac1.zi s11=$&ac1.s11 gd=$&ac1.gd nf=$&nf
destroy all
alter LP = 1
alter CP = 1e-12
alter LP2 = 1
alter CP2 = 1e-18
alter LSER = 1e-12
alter CSER = 8.2e-13
ac lin 1 1.57542e+09 1.57542e+09
let zin = v(s1)/(-i(VRF))
let s11 = db((zin-50)/(zin+50))
let gd = db((v(rfp)-v(rfn))/v(s0)*2)
let zr = real(zin)
let zi = imag(zin)
noise v(rfp,rfn) VRF lin 1 1.57542e+09 1.57542e+09
setplot noise1
let nf = 10*log10(1+(inoise_spectrum^2-4*1.380649e-23*300*50)/(4*1.380649e-23*300*50))
echo RES lp=-1 se=-0.82 lp2=0 f=1.57542e+09 zr=$&ac1.zr zi=$&ac1.zi s11=$&ac1.s11 gd=$&ac1.gd nf=$&nf
destroy all
alter LP = 1
alter CP = 1.2e-12
alter LP2 = 1
alter CP2 = 1e-18
alter LSER = 6.8e-09
alter CSER = 1e-11
ac lin 1 1.57542e+09 1.57542e+09
let zin = v(s1)/(-i(VRF))
let s11 = db((zin-50)/(zin+50))
let gd = db((v(rfp)-v(rfn))/v(s0)*2)
let zr = real(zin)
let zi = imag(zin)
noise v(rfp,rfn) VRF lin 1 1.57542e+09 1.57542e+09
setplot noise1
let nf = 10*log10(1+(inoise_spectrum^2-4*1.380649e-23*300*50)/(4*1.380649e-23*300*50))
echo RES lp=-1.2 se=6.8 lp2=0 f=1.57542e+09 zr=$&ac1.zr zi=$&ac1.zi s11=$&ac1.s11 gd=$&ac1.gd nf=$&nf
destroy all
alter LP = 1
alter CP = 1.2e-12
alter LP2 = 1
alter CP2 = 1e-18
alter LSER = 1e-12
alter CSER = 3.3e-12
ac lin 1 1.57542e+09 1.57542e+09
let zin = v(s1)/(-i(VRF))
let s11 = db((zin-50)/(zin+50))
let gd = db((v(rfp)-v(rfn))/v(s0)*2)
let zr = real(zin)
let zi = imag(zin)
noise v(rfp,rfn) VRF lin 1 1.57542e+09 1.57542e+09
setplot noise1
let nf = 10*log10(1+(inoise_spectrum^2-4*1.380649e-23*300*50)/(4*1.380649e-23*300*50))
echo RES lp=-1.2 se=-3.3 lp2=0 f=1.57542e+09 zr=$&ac1.zr zi=$&ac1.zi s11=$&ac1.s11 gd=$&ac1.gd nf=$&nf
destroy all
alter LP = 1
alter CP = 1.5e-12
alter LP2 = 1
alter CP2 = 1e-18
alter LSER = 1.5e-09
alter CSER = 1e-11
ac lin 1 1.57542e+09 1.57542e+09
let zin = v(s1)/(-i(VRF))
let s11 = db((zin-50)/(zin+50))
let gd = db((v(rfp)-v(rfn))/v(s0)*2)
let zr = real(zin)
let zi = imag(zin)
noise v(rfp,rfn) VRF lin 1 1.57542e+09 1.57542e+09
setplot noise1
let nf = 10*log10(1+(inoise_spectrum^2-4*1.380649e-23*300*50)/(4*1.380649e-23*300*50))
echo RES lp=-1.5 se=1.5 lp2=0 f=1.57542e+09 zr=$&ac1.zr zi=$&ac1.zi s11=$&ac1.s11 gd=$&ac1.gd nf=$&nf
destroy all
alter LP = 1
alter CP = 1.5e-12
alter LP2 = 1
alter CP2 = 1e-18
alter LSER = 1.5e-08
alter CSER = 1e-11
ac lin 1 1.57542e+09 1.57542e+09
let zin = v(s1)/(-i(VRF))
let s11 = db((zin-50)/(zin+50))
let gd = db((v(rfp)-v(rfn))/v(s0)*2)
let zr = real(zin)
let zi = imag(zin)
noise v(rfp,rfn) VRF lin 1 1.57542e+09 1.57542e+09
setplot noise1
let nf = 10*log10(1+(inoise_spectrum^2-4*1.380649e-23*300*50)/(4*1.380649e-23*300*50))
echo RES lp=-1.5 se=15 lp2=0 f=1.57542e+09 zr=$&ac1.zr zi=$&ac1.zi s11=$&ac1.s11 gd=$&ac1.gd nf=$&nf
destroy all
alter LP = 1
alter CP = 1.5e-12
alter LP2 = 1
alter CP2 = 1e-18
alter LSER = 1e-12
alter CSER = 6.8e-12
ac lin 1 1.57542e+09 1.57542e+09
let zin = v(s1)/(-i(VRF))
let s11 = db((zin-50)/(zin+50))
let gd = db((v(rfp)-v(rfn))/v(s0)*2)
let zr = real(zin)
let zi = imag(zin)
noise v(rfp,rfn) VRF lin 1 1.57542e+09 1.57542e+09
setplot noise1
let nf = 10*log10(1+(inoise_spectrum^2-4*1.380649e-23*300*50)/(4*1.380649e-23*300*50))
echo RES lp=-1.5 se=-6.8 lp2=0 f=1.57542e+09 zr=$&ac1.zr zi=$&ac1.zi s11=$&ac1.s11 gd=$&ac1.gd nf=$&nf
destroy all
alter LP = 1
alter CP = 1.8e-12
alter LP2 = 1
alter CP2 = 1e-18
alter LSER = 3.3e-09
alter CSER = 1e-11
ac lin 1 1.57542e+09 1.57542e+09
let zin = v(s1)/(-i(VRF))
let s11 = db((zin-50)/(zin+50))
let gd = db((v(rfp)-v(rfn))/v(s0)*2)
let zr = real(zin)
let zi = imag(zin)
noise v(rfp,rfn) VRF lin 1 1.57542e+09 1.57542e+09
setplot noise1
let nf = 10*log10(1+(inoise_spectrum^2-4*1.380649e-23*300*50)/(4*1.380649e-23*300*50))
echo RES lp=-1.8 se=3.3 lp2=0 f=1.57542e+09 zr=$&ac1.zr zi=$&ac1.zi s11=$&ac1.s11 gd=$&ac1.gd nf=$&nf
destroy all
alter LP = 1
alter CP = 1.8e-12
alter LP2 = 1
alter CP2 = 1e-18
alter LSER = 1e-12
alter CSER = 1.5e-12
ac lin 1 1.57542e+09 1.57542e+09
let zin = v(s1)/(-i(VRF))
let s11 = db((zin-50)/(zin+50))
let gd = db((v(rfp)-v(rfn))/v(s0)*2)
let zr = real(zin)
let zi = imag(zin)
noise v(rfp,rfn) VRF lin 1 1.57542e+09 1.57542e+09
setplot noise1
let nf = 10*log10(1+(inoise_spectrum^2-4*1.380649e-23*300*50)/(4*1.380649e-23*300*50))
echo RES lp=-1.8 se=-1.5 lp2=0 f=1.57542e+09 zr=$&ac1.zr zi=$&ac1.zi s11=$&ac1.s11 gd=$&ac1.gd nf=$&nf
destroy all
alter LP = 1
alter CP = 1.8e-12
alter LP2 = 1
alter CP2 = 1e-18
alter LSER = 1e-12
alter CSER = 8.2e-13
ac lin 1 1.57542e+09 1.57542e+09
let zin = v(s1)/(-i(VRF))
let s11 = db((zin-50)/(zin+50))
let gd = db((v(rfp)-v(rfn))/v(s0)*2)
let zr = real(zin)
let zi = imag(zin)
noise v(rfp,rfn) VRF lin 1 1.57542e+09 1.57542e+09
setplot noise1
let nf = 10*log10(1+(inoise_spectrum^2-4*1.380649e-23*300*50)/(4*1.380649e-23*300*50))
echo RES lp=-1.8 se=-0.82 lp2=0 f=1.57542e+09 zr=$&ac1.zr zi=$&ac1.zi s11=$&ac1.s11 gd=$&ac1.gd nf=$&nf
destroy all
alter LP = 1
alter CP = 2.2e-12
alter LP2 = 1
alter CP2 = 1e-18
alter LSER = 6.8e-09
alter CSER = 1e-11
ac lin 1 1.57542e+09 1.57542e+09
let zin = v(s1)/(-i(VRF))
let s11 = db((zin-50)/(zin+50))
let gd = db((v(rfp)-v(rfn))/v(s0)*2)
let zr = real(zin)
let zi = imag(zin)
noise v(rfp,rfn) VRF lin 1 1.57542e+09 1.57542e+09
setplot noise1
let nf = 10*log10(1+(inoise_spectrum^2-4*1.380649e-23*300*50)/(4*1.380649e-23*300*50))
echo RES lp=-2.2 se=6.8 lp2=0 f=1.57542e+09 zr=$&ac1.zr zi=$&ac1.zi s11=$&ac1.s11 gd=$&ac1.gd nf=$&nf
destroy all
alter LP = 1
alter CP = 2.2e-12
alter LP2 = 1
alter CP2 = 1e-18
alter LSER = 1e-12
alter CSER = 3.3e-12
ac lin 1 1.57542e+09 1.57542e+09
let zin = v(s1)/(-i(VRF))
let s11 = db((zin-50)/(zin+50))
let gd = db((v(rfp)-v(rfn))/v(s0)*2)
let zr = real(zin)
let zi = imag(zin)
noise v(rfp,rfn) VRF lin 1 1.57542e+09 1.57542e+09
setplot noise1
let nf = 10*log10(1+(inoise_spectrum^2-4*1.380649e-23*300*50)/(4*1.380649e-23*300*50))
echo RES lp=-2.2 se=-3.3 lp2=0 f=1.57542e+09 zr=$&ac1.zr zi=$&ac1.zi s11=$&ac1.s11 gd=$&ac1.gd nf=$&nf
destroy all
alter LP = 1
alter CP = 2.7e-12
alter LP2 = 1
alter CP2 = 1e-18
alter LSER = 1.5e-09
alter CSER = 1e-11
ac lin 1 1.57542e+09 1.57542e+09
let zin = v(s1)/(-i(VRF))
let s11 = db((zin-50)/(zin+50))
let gd = db((v(rfp)-v(rfn))/v(s0)*2)
let zr = real(zin)
let zi = imag(zin)
noise v(rfp,rfn) VRF lin 1 1.57542e+09 1.57542e+09
setplot noise1
let nf = 10*log10(1+(inoise_spectrum^2-4*1.380649e-23*300*50)/(4*1.380649e-23*300*50))
echo RES lp=-2.7 se=1.5 lp2=0 f=1.57542e+09 zr=$&ac1.zr zi=$&ac1.zi s11=$&ac1.s11 gd=$&ac1.gd nf=$&nf
destroy all
alter LP = 1
alter CP = 2.7e-12
alter LP2 = 1
alter CP2 = 1e-18
alter LSER = 1.5e-08
alter CSER = 1e-11
ac lin 1 1.57542e+09 1.57542e+09
let zin = v(s1)/(-i(VRF))
let s11 = db((zin-50)/(zin+50))
let gd = db((v(rfp)-v(rfn))/v(s0)*2)
let zr = real(zin)
let zi = imag(zin)
noise v(rfp,rfn) VRF lin 1 1.57542e+09 1.57542e+09
setplot noise1
let nf = 10*log10(1+(inoise_spectrum^2-4*1.380649e-23*300*50)/(4*1.380649e-23*300*50))
echo RES lp=-2.7 se=15 lp2=0 f=1.57542e+09 zr=$&ac1.zr zi=$&ac1.zi s11=$&ac1.s11 gd=$&ac1.gd nf=$&nf
destroy all
alter LP = 1
alter CP = 2.7e-12
alter LP2 = 1
alter CP2 = 1e-18
alter LSER = 1e-12
alter CSER = 6.8e-12
ac lin 1 1.57542e+09 1.57542e+09
let zin = v(s1)/(-i(VRF))
let s11 = db((zin-50)/(zin+50))
let gd = db((v(rfp)-v(rfn))/v(s0)*2)
let zr = real(zin)
let zi = imag(zin)
noise v(rfp,rfn) VRF lin 1 1.57542e+09 1.57542e+09
setplot noise1
let nf = 10*log10(1+(inoise_spectrum^2-4*1.380649e-23*300*50)/(4*1.380649e-23*300*50))
echo RES lp=-2.7 se=-6.8 lp2=0 f=1.57542e+09 zr=$&ac1.zr zi=$&ac1.zi s11=$&ac1.s11 gd=$&ac1.gd nf=$&nf
destroy all
alter LP = 1
alter CP = 3.3e-12
alter LP2 = 1
alter CP2 = 1e-18
alter LSER = 3.3e-09
alter CSER = 1e-11
ac lin 1 1.57542e+09 1.57542e+09
let zin = v(s1)/(-i(VRF))
let s11 = db((zin-50)/(zin+50))
let gd = db((v(rfp)-v(rfn))/v(s0)*2)
let zr = real(zin)
let zi = imag(zin)
noise v(rfp,rfn) VRF lin 1 1.57542e+09 1.57542e+09
setplot noise1
let nf = 10*log10(1+(inoise_spectrum^2-4*1.380649e-23*300*50)/(4*1.380649e-23*300*50))
echo RES lp=-3.3 se=3.3 lp2=0 f=1.57542e+09 zr=$&ac1.zr zi=$&ac1.zi s11=$&ac1.s11 gd=$&ac1.gd nf=$&nf
destroy all
alter LP = 1
alter CP = 3.3e-12
alter LP2 = 1
alter CP2 = 1e-18
alter LSER = 1e-12
alter CSER = 1.5e-12
ac lin 1 1.57542e+09 1.57542e+09
let zin = v(s1)/(-i(VRF))
let s11 = db((zin-50)/(zin+50))
let gd = db((v(rfp)-v(rfn))/v(s0)*2)
let zr = real(zin)
let zi = imag(zin)
noise v(rfp,rfn) VRF lin 1 1.57542e+09 1.57542e+09
setplot noise1
let nf = 10*log10(1+(inoise_spectrum^2-4*1.380649e-23*300*50)/(4*1.380649e-23*300*50))
echo RES lp=-3.3 se=-1.5 lp2=0 f=1.57542e+09 zr=$&ac1.zr zi=$&ac1.zi s11=$&ac1.s11 gd=$&ac1.gd nf=$&nf
destroy all
alter LP = 1
alter CP = 3.3e-12
alter LP2 = 1
alter CP2 = 1e-18
alter LSER = 1e-12
alter CSER = 8.2e-13
ac lin 1 1.57542e+09 1.57542e+09
let zin = v(s1)/(-i(VRF))
let s11 = db((zin-50)/(zin+50))
let gd = db((v(rfp)-v(rfn))/v(s0)*2)
let zr = real(zin)
let zi = imag(zin)
noise v(rfp,rfn) VRF lin 1 1.57542e+09 1.57542e+09
setplot noise1
let nf = 10*log10(1+(inoise_spectrum^2-4*1.380649e-23*300*50)/(4*1.380649e-23*300*50))
echo RES lp=-3.3 se=-0.82 lp2=0 f=1.57542e+09 zr=$&ac1.zr zi=$&ac1.zi s11=$&ac1.s11 gd=$&ac1.gd nf=$&nf
destroy all
alter LP = 1
alter CP = 3.9e-12
alter LP2 = 1
alter CP2 = 1e-18
alter LSER = 6.8e-09
alter CSER = 1e-11
ac lin 1 1.57542e+09 1.57542e+09
let zin = v(s1)/(-i(VRF))
let s11 = db((zin-50)/(zin+50))
let gd = db((v(rfp)-v(rfn))/v(s0)*2)
let zr = real(zin)
let zi = imag(zin)
noise v(rfp,rfn) VRF lin 1 1.57542e+09 1.57542e+09
setplot noise1
let nf = 10*log10(1+(inoise_spectrum^2-4*1.380649e-23*300*50)/(4*1.380649e-23*300*50))
echo RES lp=-3.9 se=6.8 lp2=0 f=1.57542e+09 zr=$&ac1.zr zi=$&ac1.zi s11=$&ac1.s11 gd=$&ac1.gd nf=$&nf
destroy all
alter LP = 1
alter CP = 3.9e-12
alter LP2 = 1
alter CP2 = 1e-18
alter LSER = 1e-12
alter CSER = 3.3e-12
ac lin 1 1.57542e+09 1.57542e+09
let zin = v(s1)/(-i(VRF))
let s11 = db((zin-50)/(zin+50))
let gd = db((v(rfp)-v(rfn))/v(s0)*2)
let zr = real(zin)
let zi = imag(zin)
noise v(rfp,rfn) VRF lin 1 1.57542e+09 1.57542e+09
setplot noise1
let nf = 10*log10(1+(inoise_spectrum^2-4*1.380649e-23*300*50)/(4*1.380649e-23*300*50))
echo RES lp=-3.9 se=-3.3 lp2=0 f=1.57542e+09 zr=$&ac1.zr zi=$&ac1.zi s11=$&ac1.s11 gd=$&ac1.gd nf=$&nf
destroy all
alter LP = 1
alter CP = 4.7e-12
alter LP2 = 1
alter CP2 = 1e-18
alter LSER = 1.5e-09
alter CSER = 1e-11
ac lin 1 1.57542e+09 1.57542e+09
let zin = v(s1)/(-i(VRF))
let s11 = db((zin-50)/(zin+50))
let gd = db((v(rfp)-v(rfn))/v(s0)*2)
let zr = real(zin)
let zi = imag(zin)
noise v(rfp,rfn) VRF lin 1 1.57542e+09 1.57542e+09
setplot noise1
let nf = 10*log10(1+(inoise_spectrum^2-4*1.380649e-23*300*50)/(4*1.380649e-23*300*50))
echo RES lp=-4.7 se=1.5 lp2=0 f=1.57542e+09 zr=$&ac1.zr zi=$&ac1.zi s11=$&ac1.s11 gd=$&ac1.gd nf=$&nf
destroy all
alter LP = 1
alter CP = 4.7e-12
alter LP2 = 1
alter CP2 = 1e-18
alter LSER = 1.5e-08
alter CSER = 1e-11
ac lin 1 1.57542e+09 1.57542e+09
let zin = v(s1)/(-i(VRF))
let s11 = db((zin-50)/(zin+50))
let gd = db((v(rfp)-v(rfn))/v(s0)*2)
let zr = real(zin)
let zi = imag(zin)
noise v(rfp,rfn) VRF lin 1 1.57542e+09 1.57542e+09
setplot noise1
let nf = 10*log10(1+(inoise_spectrum^2-4*1.380649e-23*300*50)/(4*1.380649e-23*300*50))
echo RES lp=-4.7 se=15 lp2=0 f=1.57542e+09 zr=$&ac1.zr zi=$&ac1.zi s11=$&ac1.s11 gd=$&ac1.gd nf=$&nf
destroy all
alter LP = 1
alter CP = 4.7e-12
alter LP2 = 1
alter CP2 = 1e-18
alter LSER = 1e-12
alter CSER = 6.8e-12
ac lin 1 1.57542e+09 1.57542e+09
let zin = v(s1)/(-i(VRF))
let s11 = db((zin-50)/(zin+50))
let gd = db((v(rfp)-v(rfn))/v(s0)*2)
let zr = real(zin)
let zi = imag(zin)
noise v(rfp,rfn) VRF lin 1 1.57542e+09 1.57542e+09
setplot noise1
let nf = 10*log10(1+(inoise_spectrum^2-4*1.380649e-23*300*50)/(4*1.380649e-23*300*50))
echo RES lp=-4.7 se=-6.8 lp2=0 f=1.57542e+09 zr=$&ac1.zr zi=$&ac1.zi s11=$&ac1.s11 gd=$&ac1.gd nf=$&nf
destroy all
alter LP = 1
alter CP = 5.6e-12
alter LP2 = 1
alter CP2 = 1e-18
alter LSER = 3.3e-09
alter CSER = 1e-11
ac lin 1 1.57542e+09 1.57542e+09
let zin = v(s1)/(-i(VRF))
let s11 = db((zin-50)/(zin+50))
let gd = db((v(rfp)-v(rfn))/v(s0)*2)
let zr = real(zin)
let zi = imag(zin)
noise v(rfp,rfn) VRF lin 1 1.57542e+09 1.57542e+09
setplot noise1
let nf = 10*log10(1+(inoise_spectrum^2-4*1.380649e-23*300*50)/(4*1.380649e-23*300*50))
echo RES lp=-5.6 se=3.3 lp2=0 f=1.57542e+09 zr=$&ac1.zr zi=$&ac1.zi s11=$&ac1.s11 gd=$&ac1.gd nf=$&nf
destroy all
alter LP = 1
alter CP = 5.6e-12
alter LP2 = 1
alter CP2 = 1e-18
alter LSER = 1e-12
alter CSER = 1.5e-12
ac lin 1 1.57542e+09 1.57542e+09
let zin = v(s1)/(-i(VRF))
let s11 = db((zin-50)/(zin+50))
let gd = db((v(rfp)-v(rfn))/v(s0)*2)
let zr = real(zin)
let zi = imag(zin)
noise v(rfp,rfn) VRF lin 1 1.57542e+09 1.57542e+09
setplot noise1
let nf = 10*log10(1+(inoise_spectrum^2-4*1.380649e-23*300*50)/(4*1.380649e-23*300*50))
echo RES lp=-5.6 se=-1.5 lp2=0 f=1.57542e+09 zr=$&ac1.zr zi=$&ac1.zi s11=$&ac1.s11 gd=$&ac1.gd nf=$&nf
destroy all
alter LP = 1
alter CP = 5.6e-12
alter LP2 = 1
alter CP2 = 1e-18
alter LSER = 1e-12
alter CSER = 8.2e-13
ac lin 1 1.57542e+09 1.57542e+09
let zin = v(s1)/(-i(VRF))
let s11 = db((zin-50)/(zin+50))
let gd = db((v(rfp)-v(rfn))/v(s0)*2)
let zr = real(zin)
let zi = imag(zin)
noise v(rfp,rfn) VRF lin 1 1.57542e+09 1.57542e+09
setplot noise1
let nf = 10*log10(1+(inoise_spectrum^2-4*1.380649e-23*300*50)/(4*1.380649e-23*300*50))
echo RES lp=-5.6 se=-0.82 lp2=0 f=1.57542e+09 zr=$&ac1.zr zi=$&ac1.zi s11=$&ac1.s11 gd=$&ac1.gd nf=$&nf
destroy all
alter LP = 1
alter CP = 6.8e-12
alter LP2 = 1
alter CP2 = 1e-18
alter LSER = 6.8e-09
alter CSER = 1e-11
ac lin 1 1.57542e+09 1.57542e+09
let zin = v(s1)/(-i(VRF))
let s11 = db((zin-50)/(zin+50))
let gd = db((v(rfp)-v(rfn))/v(s0)*2)
let zr = real(zin)
let zi = imag(zin)
noise v(rfp,rfn) VRF lin 1 1.57542e+09 1.57542e+09
setplot noise1
let nf = 10*log10(1+(inoise_spectrum^2-4*1.380649e-23*300*50)/(4*1.380649e-23*300*50))
echo RES lp=-6.8 se=6.8 lp2=0 f=1.57542e+09 zr=$&ac1.zr zi=$&ac1.zi s11=$&ac1.s11 gd=$&ac1.gd nf=$&nf
destroy all
alter LP = 1
alter CP = 6.8e-12
alter LP2 = 1
alter CP2 = 1e-18
alter LSER = 1e-12
alter CSER = 3.3e-12
ac lin 1 1.57542e+09 1.57542e+09
let zin = v(s1)/(-i(VRF))
let s11 = db((zin-50)/(zin+50))
let gd = db((v(rfp)-v(rfn))/v(s0)*2)
let zr = real(zin)
let zi = imag(zin)
noise v(rfp,rfn) VRF lin 1 1.57542e+09 1.57542e+09
setplot noise1
let nf = 10*log10(1+(inoise_spectrum^2-4*1.380649e-23*300*50)/(4*1.380649e-23*300*50))
echo RES lp=-6.8 se=-3.3 lp2=0 f=1.57542e+09 zr=$&ac1.zr zi=$&ac1.zi s11=$&ac1.s11 gd=$&ac1.gd nf=$&nf
destroy all
alter LP = 1
alter CP = 8.2e-12
alter LP2 = 1
alter CP2 = 1e-18
alter LSER = 1.5e-09
alter CSER = 1e-11
ac lin 1 1.57542e+09 1.57542e+09
let zin = v(s1)/(-i(VRF))
let s11 = db((zin-50)/(zin+50))
let gd = db((v(rfp)-v(rfn))/v(s0)*2)
let zr = real(zin)
let zi = imag(zin)
noise v(rfp,rfn) VRF lin 1 1.57542e+09 1.57542e+09
setplot noise1
let nf = 10*log10(1+(inoise_spectrum^2-4*1.380649e-23*300*50)/(4*1.380649e-23*300*50))
echo RES lp=-8.2 se=1.5 lp2=0 f=1.57542e+09 zr=$&ac1.zr zi=$&ac1.zi s11=$&ac1.s11 gd=$&ac1.gd nf=$&nf
destroy all
alter LP = 1
alter CP = 8.2e-12
alter LP2 = 1
alter CP2 = 1e-18
alter LSER = 1.5e-08
alter CSER = 1e-11
ac lin 1 1.57542e+09 1.57542e+09
let zin = v(s1)/(-i(VRF))
let s11 = db((zin-50)/(zin+50))
let gd = db((v(rfp)-v(rfn))/v(s0)*2)
let zr = real(zin)
let zi = imag(zin)
noise v(rfp,rfn) VRF lin 1 1.57542e+09 1.57542e+09
setplot noise1
let nf = 10*log10(1+(inoise_spectrum^2-4*1.380649e-23*300*50)/(4*1.380649e-23*300*50))
echo RES lp=-8.2 se=15 lp2=0 f=1.57542e+09 zr=$&ac1.zr zi=$&ac1.zi s11=$&ac1.s11 gd=$&ac1.gd nf=$&nf
destroy all
alter LP = 1
alter CP = 8.2e-12
alter LP2 = 1
alter CP2 = 1e-18
alter LSER = 1e-12
alter CSER = 6.8e-12
ac lin 1 1.57542e+09 1.57542e+09
let zin = v(s1)/(-i(VRF))
let s11 = db((zin-50)/(zin+50))
let gd = db((v(rfp)-v(rfn))/v(s0)*2)
let zr = real(zin)
let zi = imag(zin)
noise v(rfp,rfn) VRF lin 1 1.57542e+09 1.57542e+09
setplot noise1
let nf = 10*log10(1+(inoise_spectrum^2-4*1.380649e-23*300*50)/(4*1.380649e-23*300*50))
echo RES lp=-8.2 se=-6.8 lp2=0 f=1.57542e+09 zr=$&ac1.zr zi=$&ac1.zi s11=$&ac1.s11 gd=$&ac1.gd nf=$&nf
destroy all
alter LP = 1
alter CP = 1e-11
alter LP2 = 1
alter CP2 = 1e-18
alter LSER = 3.3e-09
alter CSER = 1e-11
ac lin 1 1.57542e+09 1.57542e+09
let zin = v(s1)/(-i(VRF))
let s11 = db((zin-50)/(zin+50))
let gd = db((v(rfp)-v(rfn))/v(s0)*2)
let zr = real(zin)
let zi = imag(zin)
noise v(rfp,rfn) VRF lin 1 1.57542e+09 1.57542e+09
setplot noise1
let nf = 10*log10(1+(inoise_spectrum^2-4*1.380649e-23*300*50)/(4*1.380649e-23*300*50))
echo RES lp=-10 se=3.3 lp2=0 f=1.57542e+09 zr=$&ac1.zr zi=$&ac1.zi s11=$&ac1.s11 gd=$&ac1.gd nf=$&nf
destroy all
alter LP = 1
alter CP = 1e-11
alter LP2 = 1
alter CP2 = 1e-18
alter LSER = 1e-12
alter CSER = 1.5e-12
ac lin 1 1.57542e+09 1.57542e+09
let zin = v(s1)/(-i(VRF))
let s11 = db((zin-50)/(zin+50))
let gd = db((v(rfp)-v(rfn))/v(s0)*2)
let zr = real(zin)
let zi = imag(zin)
noise v(rfp,rfn) VRF lin 1 1.57542e+09 1.57542e+09
setplot noise1
let nf = 10*log10(1+(inoise_spectrum^2-4*1.380649e-23*300*50)/(4*1.380649e-23*300*50))
echo RES lp=-10 se=-1.5 lp2=0 f=1.57542e+09 zr=$&ac1.zr zi=$&ac1.zi s11=$&ac1.s11 gd=$&ac1.gd nf=$&nf
destroy all
alter LP = 1
alter CP = 1e-11
alter LP2 = 1
alter CP2 = 1e-18
alter LSER = 1e-12
alter CSER = 8.2e-13
ac lin 1 1.57542e+09 1.57542e+09
let zin = v(s1)/(-i(VRF))
let s11 = db((zin-50)/(zin+50))
let gd = db((v(rfp)-v(rfn))/v(s0)*2)
let zr = real(zin)
let zi = imag(zin)
noise v(rfp,rfn) VRF lin 1 1.57542e+09 1.57542e+09
setplot noise1
let nf = 10*log10(1+(inoise_spectrum^2-4*1.380649e-23*300*50)/(4*1.380649e-23*300*50))
echo RES lp=-10 se=-0.82 lp2=0 f=1.57542e+09 zr=$&ac1.zr zi=$&ac1.zi s11=$&ac1.s11 gd=$&ac1.gd nf=$&nf
destroy all
alter LP = 1
alter CP = 5e-13
alter LP2 = 1
alter CP2 = 1e-18
alter LSER = 6.8e-09
alter CSER = 1e-11
ac lin 1 1.57542e+09 1.57542e+09
let zin = v(s1)/(-i(VRF))
let s11 = db((zin-50)/(zin+50))
let gd = db((v(rfp)-v(rfn))/v(s0)*2)
let zr = real(zin)
let zi = imag(zin)
noise v(rfp,rfn) VRF lin 1 1.57542e+09 1.57542e+09
setplot noise1
let nf = 10*log10(1+(inoise_spectrum^2-4*1.380649e-23*300*50)/(4*1.380649e-23*300*50))
echo RES lp=-0.5 se=6.8 lp2=0 f=1.57542e+09 zr=$&ac1.zr zi=$&ac1.zi s11=$&ac1.s11 gd=$&ac1.gd nf=$&nf
destroy all
alter LP = 1
alter CP = 5e-13
alter LP2 = 1
alter CP2 = 1e-18
alter LSER = 1e-12
alter CSER = 3.3e-12
ac lin 1 1.57542e+09 1.57542e+09
let zin = v(s1)/(-i(VRF))
let s11 = db((zin-50)/(zin+50))
let gd = db((v(rfp)-v(rfn))/v(s0)*2)
let zr = real(zin)
let zi = imag(zin)
noise v(rfp,rfn) VRF lin 1 1.57542e+09 1.57542e+09
setplot noise1
let nf = 10*log10(1+(inoise_spectrum^2-4*1.380649e-23*300*50)/(4*1.380649e-23*300*50))
echo RES lp=-0.5 se=-3.3 lp2=0 f=1.57542e+09 zr=$&ac1.zr zi=$&ac1.zi s11=$&ac1.s11 gd=$&ac1.gd nf=$&nf
destroy all
alter LP = 1
alter CP = 6.8e-13
alter LP2 = 1
alter CP2 = 1e-18
alter LSER = 1.5e-09
alter CSER = 1e-11
ac lin 1 1.57542e+09 1.57542e+09
let zin = v(s1)/(-i(VRF))
let s11 = db((zin-50)/(zin+50))
let gd = db((v(rfp)-v(rfn))/v(s0)*2)
let zr = real(zin)
let zi = imag(zin)
noise v(rfp,rfn) VRF lin 1 1.57542e+09 1.57542e+09
setplot noise1
let nf = 10*log10(1+(inoise_spectrum^2-4*1.380649e-23*300*50)/(4*1.380649e-23*300*50))
echo RES lp=-0.68 se=1.5 lp2=0 f=1.57542e+09 zr=$&ac1.zr zi=$&ac1.zi s11=$&ac1.s11 gd=$&ac1.gd nf=$&nf
destroy all
alter LP = 1
alter CP = 6.8e-13
alter LP2 = 1
alter CP2 = 1e-18
alter LSER = 1.5e-08
alter CSER = 1e-11
ac lin 1 1.57542e+09 1.57542e+09
let zin = v(s1)/(-i(VRF))
let s11 = db((zin-50)/(zin+50))
let gd = db((v(rfp)-v(rfn))/v(s0)*2)
let zr = real(zin)
let zi = imag(zin)
noise v(rfp,rfn) VRF lin 1 1.57542e+09 1.57542e+09
setplot noise1
let nf = 10*log10(1+(inoise_spectrum^2-4*1.380649e-23*300*50)/(4*1.380649e-23*300*50))
echo RES lp=-0.68 se=15 lp2=0 f=1.57542e+09 zr=$&ac1.zr zi=$&ac1.zi s11=$&ac1.s11 gd=$&ac1.gd nf=$&nf
destroy all
alter LP = 1
alter CP = 6.8e-13
alter LP2 = 1
alter CP2 = 1e-18
alter LSER = 1e-12
alter CSER = 6.8e-12
ac lin 1 1.57542e+09 1.57542e+09
let zin = v(s1)/(-i(VRF))
let s11 = db((zin-50)/(zin+50))
let gd = db((v(rfp)-v(rfn))/v(s0)*2)
let zr = real(zin)
let zi = imag(zin)
noise v(rfp,rfn) VRF lin 1 1.57542e+09 1.57542e+09
setplot noise1
let nf = 10*log10(1+(inoise_spectrum^2-4*1.380649e-23*300*50)/(4*1.380649e-23*300*50))
echo RES lp=-0.68 se=-6.8 lp2=0 f=1.57542e+09 zr=$&ac1.zr zi=$&ac1.zi s11=$&ac1.s11 gd=$&ac1.gd nf=$&nf
destroy all
alter LP = 1
alter CP = 8.2e-13
alter LP2 = 1
alter CP2 = 1e-18
alter LSER = 3.3e-09
alter CSER = 1e-11
ac lin 1 1.57542e+09 1.57542e+09
let zin = v(s1)/(-i(VRF))
let s11 = db((zin-50)/(zin+50))
let gd = db((v(rfp)-v(rfn))/v(s0)*2)
let zr = real(zin)
let zi = imag(zin)
noise v(rfp,rfn) VRF lin 1 1.57542e+09 1.57542e+09
setplot noise1
let nf = 10*log10(1+(inoise_spectrum^2-4*1.380649e-23*300*50)/(4*1.380649e-23*300*50))
echo RES lp=-0.82 se=3.3 lp2=0 f=1.57542e+09 zr=$&ac1.zr zi=$&ac1.zi s11=$&ac1.s11 gd=$&ac1.gd nf=$&nf
destroy all
alter LP = 1
alter CP = 8.2e-13
alter LP2 = 1
alter CP2 = 1e-18
alter LSER = 1e-12
alter CSER = 1.5e-12
ac lin 1 1.57542e+09 1.57542e+09
let zin = v(s1)/(-i(VRF))
let s11 = db((zin-50)/(zin+50))
let gd = db((v(rfp)-v(rfn))/v(s0)*2)
let zr = real(zin)
let zi = imag(zin)
noise v(rfp,rfn) VRF lin 1 1.57542e+09 1.57542e+09
setplot noise1
let nf = 10*log10(1+(inoise_spectrum^2-4*1.380649e-23*300*50)/(4*1.380649e-23*300*50))
echo RES lp=-0.82 se=-1.5 lp2=0 f=1.57542e+09 zr=$&ac1.zr zi=$&ac1.zi s11=$&ac1.s11 gd=$&ac1.gd nf=$&nf
destroy all
alter LP = 1
alter CP = 8.2e-13
alter LP2 = 1
alter CP2 = 1e-18
alter LSER = 1e-12
alter CSER = 8.2e-13
ac lin 1 1.57542e+09 1.57542e+09
let zin = v(s1)/(-i(VRF))
let s11 = db((zin-50)/(zin+50))
let gd = db((v(rfp)-v(rfn))/v(s0)*2)
let zr = real(zin)
let zi = imag(zin)
noise v(rfp,rfn) VRF lin 1 1.57542e+09 1.57542e+09
setplot noise1
let nf = 10*log10(1+(inoise_spectrum^2-4*1.380649e-23*300*50)/(4*1.380649e-23*300*50))
echo RES lp=-0.82 se=-0.82 lp2=0 f=1.57542e+09 zr=$&ac1.zr zi=$&ac1.zi s11=$&ac1.s11 gd=$&ac1.gd nf=$&nf
destroy all
alter LP = 1
alter CP = 1e-18
alter LP2 = 1.5e-09
alter CP2 = 1e-18
alter LSER = 6.8e-09
alter CSER = 1e-11
ac lin 1 1.57542e+09 1.57542e+09
let zin = v(s1)/(-i(VRF))
let s11 = db((zin-50)/(zin+50))
let gd = db((v(rfp)-v(rfn))/v(s0)*2)
let zr = real(zin)
let zi = imag(zin)
noise v(rfp,rfn) VRF lin 1 1.57542e+09 1.57542e+09
setplot noise1
let nf = 10*log10(1+(inoise_spectrum^2-4*1.380649e-23*300*50)/(4*1.380649e-23*300*50))
echo RES lp=0 se=6.8 lp2=1.5 f=1.57542e+09 zr=$&ac1.zr zi=$&ac1.zi s11=$&ac1.s11 gd=$&ac1.gd nf=$&nf
destroy all
alter LP = 1
alter CP = 1e-18
alter LP2 = 1.5e-09
alter CP2 = 1e-18
alter LSER = 1e-12
alter CSER = 3.3e-12
ac lin 1 1.57542e+09 1.57542e+09
let zin = v(s1)/(-i(VRF))
let s11 = db((zin-50)/(zin+50))
let gd = db((v(rfp)-v(rfn))/v(s0)*2)
let zr = real(zin)
let zi = imag(zin)
noise v(rfp,rfn) VRF lin 1 1.57542e+09 1.57542e+09
setplot noise1
let nf = 10*log10(1+(inoise_spectrum^2-4*1.380649e-23*300*50)/(4*1.380649e-23*300*50))
echo RES lp=0 se=-3.3 lp2=1.5 f=1.57542e+09 zr=$&ac1.zr zi=$&ac1.zi s11=$&ac1.s11 gd=$&ac1.gd nf=$&nf
destroy all
alter LP = 1
alter CP = 1e-18
alter LP2 = 1.8e-09
alter CP2 = 1e-18
alter LSER = 1.5e-09
alter CSER = 1e-11
ac lin 1 1.57542e+09 1.57542e+09
let zin = v(s1)/(-i(VRF))
let s11 = db((zin-50)/(zin+50))
let gd = db((v(rfp)-v(rfn))/v(s0)*2)
let zr = real(zin)
let zi = imag(zin)
noise v(rfp,rfn) VRF lin 1 1.57542e+09 1.57542e+09
setplot noise1
let nf = 10*log10(1+(inoise_spectrum^2-4*1.380649e-23*300*50)/(4*1.380649e-23*300*50))
echo RES lp=0 se=1.5 lp2=1.8 f=1.57542e+09 zr=$&ac1.zr zi=$&ac1.zi s11=$&ac1.s11 gd=$&ac1.gd nf=$&nf
destroy all
alter LP = 1
alter CP = 1e-18
alter LP2 = 1.8e-09
alter CP2 = 1e-18
alter LSER = 1.5e-08
alter CSER = 1e-11
ac lin 1 1.57542e+09 1.57542e+09
let zin = v(s1)/(-i(VRF))
let s11 = db((zin-50)/(zin+50))
let gd = db((v(rfp)-v(rfn))/v(s0)*2)
let zr = real(zin)
let zi = imag(zin)
noise v(rfp,rfn) VRF lin 1 1.57542e+09 1.57542e+09
setplot noise1
let nf = 10*log10(1+(inoise_spectrum^2-4*1.380649e-23*300*50)/(4*1.380649e-23*300*50))
echo RES lp=0 se=15 lp2=1.8 f=1.57542e+09 zr=$&ac1.zr zi=$&ac1.zi s11=$&ac1.s11 gd=$&ac1.gd nf=$&nf
destroy all
alter LP = 1
alter CP = 1e-18
alter LP2 = 1.8e-09
alter CP2 = 1e-18
alter LSER = 1e-12
alter CSER = 6.8e-12
ac lin 1 1.57542e+09 1.57542e+09
let zin = v(s1)/(-i(VRF))
let s11 = db((zin-50)/(zin+50))
let gd = db((v(rfp)-v(rfn))/v(s0)*2)
let zr = real(zin)
let zi = imag(zin)
noise v(rfp,rfn) VRF lin 1 1.57542e+09 1.57542e+09
setplot noise1
let nf = 10*log10(1+(inoise_spectrum^2-4*1.380649e-23*300*50)/(4*1.380649e-23*300*50))
echo RES lp=0 se=-6.8 lp2=1.8 f=1.57542e+09 zr=$&ac1.zr zi=$&ac1.zi s11=$&ac1.s11 gd=$&ac1.gd nf=$&nf
destroy all
alter LP = 1
alter CP = 1e-18
alter LP2 = 2.2e-09
alter CP2 = 1e-18
alter LSER = 3.3e-09
alter CSER = 1e-11
ac lin 1 1.57542e+09 1.57542e+09
let zin = v(s1)/(-i(VRF))
let s11 = db((zin-50)/(zin+50))
let gd = db((v(rfp)-v(rfn))/v(s0)*2)
let zr = real(zin)
let zi = imag(zin)
noise v(rfp,rfn) VRF lin 1 1.57542e+09 1.57542e+09
setplot noise1
let nf = 10*log10(1+(inoise_spectrum^2-4*1.380649e-23*300*50)/(4*1.380649e-23*300*50))
echo RES lp=0 se=3.3 lp2=2.2 f=1.57542e+09 zr=$&ac1.zr zi=$&ac1.zi s11=$&ac1.s11 gd=$&ac1.gd nf=$&nf
destroy all
alter LP = 1
alter CP = 1e-18
alter LP2 = 2.2e-09
alter CP2 = 1e-18
alter LSER = 1e-12
alter CSER = 1.5e-12
ac lin 1 1.57542e+09 1.57542e+09
let zin = v(s1)/(-i(VRF))
let s11 = db((zin-50)/(zin+50))
let gd = db((v(rfp)-v(rfn))/v(s0)*2)
let zr = real(zin)
let zi = imag(zin)
noise v(rfp,rfn) VRF lin 1 1.57542e+09 1.57542e+09
setplot noise1
let nf = 10*log10(1+(inoise_spectrum^2-4*1.380649e-23*300*50)/(4*1.380649e-23*300*50))
echo RES lp=0 se=-1.5 lp2=2.2 f=1.57542e+09 zr=$&ac1.zr zi=$&ac1.zi s11=$&ac1.s11 gd=$&ac1.gd nf=$&nf
destroy all
alter LP = 1
alter CP = 1e-18
alter LP2 = 2.2e-09
alter CP2 = 1e-18
alter LSER = 1e-12
alter CSER = 8.2e-13
ac lin 1 1.57542e+09 1.57542e+09
let zin = v(s1)/(-i(VRF))
let s11 = db((zin-50)/(zin+50))
let gd = db((v(rfp)-v(rfn))/v(s0)*2)
let zr = real(zin)
let zi = imag(zin)
noise v(rfp,rfn) VRF lin 1 1.57542e+09 1.57542e+09
setplot noise1
let nf = 10*log10(1+(inoise_spectrum^2-4*1.380649e-23*300*50)/(4*1.380649e-23*300*50))
echo RES lp=0 se=-0.82 lp2=2.2 f=1.57542e+09 zr=$&ac1.zr zi=$&ac1.zi s11=$&ac1.s11 gd=$&ac1.gd nf=$&nf
destroy all
alter LP = 1
alter CP = 1e-18
alter LP2 = 2.7e-09
alter CP2 = 1e-18
alter LSER = 6.8e-09
alter CSER = 1e-11
ac lin 1 1.57542e+09 1.57542e+09
let zin = v(s1)/(-i(VRF))
let s11 = db((zin-50)/(zin+50))
let gd = db((v(rfp)-v(rfn))/v(s0)*2)
let zr = real(zin)
let zi = imag(zin)
noise v(rfp,rfn) VRF lin 1 1.57542e+09 1.57542e+09
setplot noise1
let nf = 10*log10(1+(inoise_spectrum^2-4*1.380649e-23*300*50)/(4*1.380649e-23*300*50))
echo RES lp=0 se=6.8 lp2=2.7 f=1.57542e+09 zr=$&ac1.zr zi=$&ac1.zi s11=$&ac1.s11 gd=$&ac1.gd nf=$&nf
destroy all
alter LP = 1
alter CP = 1e-18
alter LP2 = 2.7e-09
alter CP2 = 1e-18
alter LSER = 1e-12
alter CSER = 3.3e-12
ac lin 1 1.57542e+09 1.57542e+09
let zin = v(s1)/(-i(VRF))
let s11 = db((zin-50)/(zin+50))
let gd = db((v(rfp)-v(rfn))/v(s0)*2)
let zr = real(zin)
let zi = imag(zin)
noise v(rfp,rfn) VRF lin 1 1.57542e+09 1.57542e+09
setplot noise1
let nf = 10*log10(1+(inoise_spectrum^2-4*1.380649e-23*300*50)/(4*1.380649e-23*300*50))
echo RES lp=0 se=-3.3 lp2=2.7 f=1.57542e+09 zr=$&ac1.zr zi=$&ac1.zi s11=$&ac1.s11 gd=$&ac1.gd nf=$&nf
destroy all
alter LP = 1
alter CP = 1e-18
alter LP2 = 3.3e-09
alter CP2 = 1e-18
alter LSER = 1.5e-09
alter CSER = 1e-11
ac lin 1 1.57542e+09 1.57542e+09
let zin = v(s1)/(-i(VRF))
let s11 = db((zin-50)/(zin+50))
let gd = db((v(rfp)-v(rfn))/v(s0)*2)
let zr = real(zin)
let zi = imag(zin)
noise v(rfp,rfn) VRF lin 1 1.57542e+09 1.57542e+09
setplot noise1
let nf = 10*log10(1+(inoise_spectrum^2-4*1.380649e-23*300*50)/(4*1.380649e-23*300*50))
echo RES lp=0 se=1.5 lp2=3.3 f=1.57542e+09 zr=$&ac1.zr zi=$&ac1.zi s11=$&ac1.s11 gd=$&ac1.gd nf=$&nf
destroy all
alter LP = 1
alter CP = 1e-18
alter LP2 = 3.3e-09
alter CP2 = 1e-18
alter LSER = 1.5e-08
alter CSER = 1e-11
ac lin 1 1.57542e+09 1.57542e+09
let zin = v(s1)/(-i(VRF))
let s11 = db((zin-50)/(zin+50))
let gd = db((v(rfp)-v(rfn))/v(s0)*2)
let zr = real(zin)
let zi = imag(zin)
noise v(rfp,rfn) VRF lin 1 1.57542e+09 1.57542e+09
setplot noise1
let nf = 10*log10(1+(inoise_spectrum^2-4*1.380649e-23*300*50)/(4*1.380649e-23*300*50))
echo RES lp=0 se=15 lp2=3.3 f=1.57542e+09 zr=$&ac1.zr zi=$&ac1.zi s11=$&ac1.s11 gd=$&ac1.gd nf=$&nf
destroy all
alter LP = 1
alter CP = 1e-18
alter LP2 = 3.3e-09
alter CP2 = 1e-18
alter LSER = 1e-12
alter CSER = 6.8e-12
ac lin 1 1.57542e+09 1.57542e+09
let zin = v(s1)/(-i(VRF))
let s11 = db((zin-50)/(zin+50))
let gd = db((v(rfp)-v(rfn))/v(s0)*2)
let zr = real(zin)
let zi = imag(zin)
noise v(rfp,rfn) VRF lin 1 1.57542e+09 1.57542e+09
setplot noise1
let nf = 10*log10(1+(inoise_spectrum^2-4*1.380649e-23*300*50)/(4*1.380649e-23*300*50))
echo RES lp=0 se=-6.8 lp2=3.3 f=1.57542e+09 zr=$&ac1.zr zi=$&ac1.zi s11=$&ac1.s11 gd=$&ac1.gd nf=$&nf
destroy all
alter LP = 1
alter CP = 1e-18
alter LP2 = 3.9e-09
alter CP2 = 1e-18
alter LSER = 3.3e-09
alter CSER = 1e-11
ac lin 1 1.57542e+09 1.57542e+09
let zin = v(s1)/(-i(VRF))
let s11 = db((zin-50)/(zin+50))
let gd = db((v(rfp)-v(rfn))/v(s0)*2)
let zr = real(zin)
let zi = imag(zin)
noise v(rfp,rfn) VRF lin 1 1.57542e+09 1.57542e+09
setplot noise1
let nf = 10*log10(1+(inoise_spectrum^2-4*1.380649e-23*300*50)/(4*1.380649e-23*300*50))
echo RES lp=0 se=3.3 lp2=3.9 f=1.57542e+09 zr=$&ac1.zr zi=$&ac1.zi s11=$&ac1.s11 gd=$&ac1.gd nf=$&nf
destroy all
alter LP = 1
alter CP = 1e-18
alter LP2 = 3.9e-09
alter CP2 = 1e-18
alter LSER = 1e-12
alter CSER = 1.5e-12
ac lin 1 1.57542e+09 1.57542e+09
let zin = v(s1)/(-i(VRF))
let s11 = db((zin-50)/(zin+50))
let gd = db((v(rfp)-v(rfn))/v(s0)*2)
let zr = real(zin)
let zi = imag(zin)
noise v(rfp,rfn) VRF lin 1 1.57542e+09 1.57542e+09
setplot noise1
let nf = 10*log10(1+(inoise_spectrum^2-4*1.380649e-23*300*50)/(4*1.380649e-23*300*50))
echo RES lp=0 se=-1.5 lp2=3.9 f=1.57542e+09 zr=$&ac1.zr zi=$&ac1.zi s11=$&ac1.s11 gd=$&ac1.gd nf=$&nf
destroy all
alter LP = 1
alter CP = 1e-18
alter LP2 = 3.9e-09
alter CP2 = 1e-18
alter LSER = 1e-12
alter CSER = 8.2e-13
ac lin 1 1.57542e+09 1.57542e+09
let zin = v(s1)/(-i(VRF))
let s11 = db((zin-50)/(zin+50))
let gd = db((v(rfp)-v(rfn))/v(s0)*2)
let zr = real(zin)
let zi = imag(zin)
noise v(rfp,rfn) VRF lin 1 1.57542e+09 1.57542e+09
setplot noise1
let nf = 10*log10(1+(inoise_spectrum^2-4*1.380649e-23*300*50)/(4*1.380649e-23*300*50))
echo RES lp=0 se=-0.82 lp2=3.9 f=1.57542e+09 zr=$&ac1.zr zi=$&ac1.zi s11=$&ac1.s11 gd=$&ac1.gd nf=$&nf
destroy all
alter LP = 1
alter CP = 1e-18
alter LP2 = 4.7e-09
alter CP2 = 1e-18
alter LSER = 6.8e-09
alter CSER = 1e-11
ac lin 1 1.57542e+09 1.57542e+09
let zin = v(s1)/(-i(VRF))
let s11 = db((zin-50)/(zin+50))
let gd = db((v(rfp)-v(rfn))/v(s0)*2)
let zr = real(zin)
let zi = imag(zin)
noise v(rfp,rfn) VRF lin 1 1.57542e+09 1.57542e+09
setplot noise1
let nf = 10*log10(1+(inoise_spectrum^2-4*1.380649e-23*300*50)/(4*1.380649e-23*300*50))
echo RES lp=0 se=6.8 lp2=4.7 f=1.57542e+09 zr=$&ac1.zr zi=$&ac1.zi s11=$&ac1.s11 gd=$&ac1.gd nf=$&nf
destroy all
alter LP = 1
alter CP = 1e-18
alter LP2 = 4.7e-09
alter CP2 = 1e-18
alter LSER = 1e-12
alter CSER = 3.3e-12
ac lin 1 1.57542e+09 1.57542e+09
let zin = v(s1)/(-i(VRF))
let s11 = db((zin-50)/(zin+50))
let gd = db((v(rfp)-v(rfn))/v(s0)*2)
let zr = real(zin)
let zi = imag(zin)
noise v(rfp,rfn) VRF lin 1 1.57542e+09 1.57542e+09
setplot noise1
let nf = 10*log10(1+(inoise_spectrum^2-4*1.380649e-23*300*50)/(4*1.380649e-23*300*50))
echo RES lp=0 se=-3.3 lp2=4.7 f=1.57542e+09 zr=$&ac1.zr zi=$&ac1.zi s11=$&ac1.s11 gd=$&ac1.gd nf=$&nf
destroy all
alter LP = 1
alter CP = 1e-18
alter LP2 = 5.6e-09
alter CP2 = 1e-18
alter LSER = 1.5e-09
alter CSER = 1e-11
ac lin 1 1.57542e+09 1.57542e+09
let zin = v(s1)/(-i(VRF))
let s11 = db((zin-50)/(zin+50))
let gd = db((v(rfp)-v(rfn))/v(s0)*2)
let zr = real(zin)
let zi = imag(zin)
noise v(rfp,rfn) VRF lin 1 1.57542e+09 1.57542e+09
setplot noise1
let nf = 10*log10(1+(inoise_spectrum^2-4*1.380649e-23*300*50)/(4*1.380649e-23*300*50))
echo RES lp=0 se=1.5 lp2=5.6 f=1.57542e+09 zr=$&ac1.zr zi=$&ac1.zi s11=$&ac1.s11 gd=$&ac1.gd nf=$&nf
destroy all
alter LP = 1
alter CP = 1e-18
alter LP2 = 5.6e-09
alter CP2 = 1e-18
alter LSER = 1.5e-08
alter CSER = 1e-11
ac lin 1 1.57542e+09 1.57542e+09
let zin = v(s1)/(-i(VRF))
let s11 = db((zin-50)/(zin+50))
let gd = db((v(rfp)-v(rfn))/v(s0)*2)
let zr = real(zin)
let zi = imag(zin)
noise v(rfp,rfn) VRF lin 1 1.57542e+09 1.57542e+09
setplot noise1
let nf = 10*log10(1+(inoise_spectrum^2-4*1.380649e-23*300*50)/(4*1.380649e-23*300*50))
echo RES lp=0 se=15 lp2=5.6 f=1.57542e+09 zr=$&ac1.zr zi=$&ac1.zi s11=$&ac1.s11 gd=$&ac1.gd nf=$&nf
destroy all
alter LP = 1
alter CP = 1e-18
alter LP2 = 5.6e-09
alter CP2 = 1e-18
alter LSER = 1e-12
alter CSER = 6.8e-12
ac lin 1 1.57542e+09 1.57542e+09
let zin = v(s1)/(-i(VRF))
let s11 = db((zin-50)/(zin+50))
let gd = db((v(rfp)-v(rfn))/v(s0)*2)
let zr = real(zin)
let zi = imag(zin)
noise v(rfp,rfn) VRF lin 1 1.57542e+09 1.57542e+09
setplot noise1
let nf = 10*log10(1+(inoise_spectrum^2-4*1.380649e-23*300*50)/(4*1.380649e-23*300*50))
echo RES lp=0 se=-6.8 lp2=5.6 f=1.57542e+09 zr=$&ac1.zr zi=$&ac1.zi s11=$&ac1.s11 gd=$&ac1.gd nf=$&nf
destroy all
alter LP = 1
alter CP = 1e-18
alter LP2 = 6.8e-09
alter CP2 = 1e-18
alter LSER = 3.3e-09
alter CSER = 1e-11
ac lin 1 1.57542e+09 1.57542e+09
let zin = v(s1)/(-i(VRF))
let s11 = db((zin-50)/(zin+50))
let gd = db((v(rfp)-v(rfn))/v(s0)*2)
let zr = real(zin)
let zi = imag(zin)
noise v(rfp,rfn) VRF lin 1 1.57542e+09 1.57542e+09
setplot noise1
let nf = 10*log10(1+(inoise_spectrum^2-4*1.380649e-23*300*50)/(4*1.380649e-23*300*50))
echo RES lp=0 se=3.3 lp2=6.8 f=1.57542e+09 zr=$&ac1.zr zi=$&ac1.zi s11=$&ac1.s11 gd=$&ac1.gd nf=$&nf
destroy all
alter LP = 1
alter CP = 1e-18
alter LP2 = 6.8e-09
alter CP2 = 1e-18
alter LSER = 1e-12
alter CSER = 1.5e-12
ac lin 1 1.57542e+09 1.57542e+09
let zin = v(s1)/(-i(VRF))
let s11 = db((zin-50)/(zin+50))
let gd = db((v(rfp)-v(rfn))/v(s0)*2)
let zr = real(zin)
let zi = imag(zin)
noise v(rfp,rfn) VRF lin 1 1.57542e+09 1.57542e+09
setplot noise1
let nf = 10*log10(1+(inoise_spectrum^2-4*1.380649e-23*300*50)/(4*1.380649e-23*300*50))
echo RES lp=0 se=-1.5 lp2=6.8 f=1.57542e+09 zr=$&ac1.zr zi=$&ac1.zi s11=$&ac1.s11 gd=$&ac1.gd nf=$&nf
destroy all
alter LP = 1
alter CP = 1e-18
alter LP2 = 6.8e-09
alter CP2 = 1e-18
alter LSER = 1e-12
alter CSER = 8.2e-13
ac lin 1 1.57542e+09 1.57542e+09
let zin = v(s1)/(-i(VRF))
let s11 = db((zin-50)/(zin+50))
let gd = db((v(rfp)-v(rfn))/v(s0)*2)
let zr = real(zin)
let zi = imag(zin)
noise v(rfp,rfn) VRF lin 1 1.57542e+09 1.57542e+09
setplot noise1
let nf = 10*log10(1+(inoise_spectrum^2-4*1.380649e-23*300*50)/(4*1.380649e-23*300*50))
echo RES lp=0 se=-0.82 lp2=6.8 f=1.57542e+09 zr=$&ac1.zr zi=$&ac1.zi s11=$&ac1.s11 gd=$&ac1.gd nf=$&nf
destroy all
alter LP = 1
alter CP = 1e-18
alter LP2 = 8.2e-09
alter CP2 = 1e-18
alter LSER = 6.8e-09
alter CSER = 1e-11
ac lin 1 1.57542e+09 1.57542e+09
let zin = v(s1)/(-i(VRF))
let s11 = db((zin-50)/(zin+50))
let gd = db((v(rfp)-v(rfn))/v(s0)*2)
let zr = real(zin)
let zi = imag(zin)
noise v(rfp,rfn) VRF lin 1 1.57542e+09 1.57542e+09
setplot noise1
let nf = 10*log10(1+(inoise_spectrum^2-4*1.380649e-23*300*50)/(4*1.380649e-23*300*50))
echo RES lp=0 se=6.8 lp2=8.2 f=1.57542e+09 zr=$&ac1.zr zi=$&ac1.zi s11=$&ac1.s11 gd=$&ac1.gd nf=$&nf
destroy all
alter LP = 1
alter CP = 1e-18
alter LP2 = 8.2e-09
alter CP2 = 1e-18
alter LSER = 1e-12
alter CSER = 3.3e-12
ac lin 1 1.57542e+09 1.57542e+09
let zin = v(s1)/(-i(VRF))
let s11 = db((zin-50)/(zin+50))
let gd = db((v(rfp)-v(rfn))/v(s0)*2)
let zr = real(zin)
let zi = imag(zin)
noise v(rfp,rfn) VRF lin 1 1.57542e+09 1.57542e+09
setplot noise1
let nf = 10*log10(1+(inoise_spectrum^2-4*1.380649e-23*300*50)/(4*1.380649e-23*300*50))
echo RES lp=0 se=-3.3 lp2=8.2 f=1.57542e+09 zr=$&ac1.zr zi=$&ac1.zi s11=$&ac1.s11 gd=$&ac1.gd nf=$&nf
destroy all
alter LP = 1
alter CP = 1e-18
alter LP2 = 1e-08
alter CP2 = 1e-18
alter LSER = 1.5e-09
alter CSER = 1e-11
ac lin 1 1.57542e+09 1.57542e+09
let zin = v(s1)/(-i(VRF))
let s11 = db((zin-50)/(zin+50))
let gd = db((v(rfp)-v(rfn))/v(s0)*2)
let zr = real(zin)
let zi = imag(zin)
noise v(rfp,rfn) VRF lin 1 1.57542e+09 1.57542e+09
setplot noise1
let nf = 10*log10(1+(inoise_spectrum^2-4*1.380649e-23*300*50)/(4*1.380649e-23*300*50))
echo RES lp=0 se=1.5 lp2=10 f=1.57542e+09 zr=$&ac1.zr zi=$&ac1.zi s11=$&ac1.s11 gd=$&ac1.gd nf=$&nf
destroy all
alter LP = 1
alter CP = 1e-18
alter LP2 = 1e-08
alter CP2 = 1e-18
alter LSER = 1.5e-08
alter CSER = 1e-11
ac lin 1 1.57542e+09 1.57542e+09
let zin = v(s1)/(-i(VRF))
let s11 = db((zin-50)/(zin+50))
let gd = db((v(rfp)-v(rfn))/v(s0)*2)
let zr = real(zin)
let zi = imag(zin)
noise v(rfp,rfn) VRF lin 1 1.57542e+09 1.57542e+09
setplot noise1
let nf = 10*log10(1+(inoise_spectrum^2-4*1.380649e-23*300*50)/(4*1.380649e-23*300*50))
echo RES lp=0 se=15 lp2=10 f=1.57542e+09 zr=$&ac1.zr zi=$&ac1.zi s11=$&ac1.s11 gd=$&ac1.gd nf=$&nf
destroy all
alter LP = 1
alter CP = 1e-18
alter LP2 = 1e-08
alter CP2 = 1e-18
alter LSER = 1e-12
alter CSER = 6.8e-12
ac lin 1 1.57542e+09 1.57542e+09
let zin = v(s1)/(-i(VRF))
let s11 = db((zin-50)/(zin+50))
let gd = db((v(rfp)-v(rfn))/v(s0)*2)
let zr = real(zin)
let zi = imag(zin)
noise v(rfp,rfn) VRF lin 1 1.57542e+09 1.57542e+09
setplot noise1
let nf = 10*log10(1+(inoise_spectrum^2-4*1.380649e-23*300*50)/(4*1.380649e-23*300*50))
echo RES lp=0 se=-6.8 lp2=10 f=1.57542e+09 zr=$&ac1.zr zi=$&ac1.zi s11=$&ac1.s11 gd=$&ac1.gd nf=$&nf
destroy all
alter LP = 1
alter CP = 1e-18
alter LP2 = 1.2e-08
alter CP2 = 1e-18
alter LSER = 3.3e-09
alter CSER = 1e-11
ac lin 1 1.57542e+09 1.57542e+09
let zin = v(s1)/(-i(VRF))
let s11 = db((zin-50)/(zin+50))
let gd = db((v(rfp)-v(rfn))/v(s0)*2)
let zr = real(zin)
let zi = imag(zin)
noise v(rfp,rfn) VRF lin 1 1.57542e+09 1.57542e+09
setplot noise1
let nf = 10*log10(1+(inoise_spectrum^2-4*1.380649e-23*300*50)/(4*1.380649e-23*300*50))
echo RES lp=0 se=3.3 lp2=12 f=1.57542e+09 zr=$&ac1.zr zi=$&ac1.zi s11=$&ac1.s11 gd=$&ac1.gd nf=$&nf
destroy all
alter LP = 1
alter CP = 1e-18
alter LP2 = 1.2e-08
alter CP2 = 1e-18
alter LSER = 1e-12
alter CSER = 1.5e-12
ac lin 1 1.57542e+09 1.57542e+09
let zin = v(s1)/(-i(VRF))
let s11 = db((zin-50)/(zin+50))
let gd = db((v(rfp)-v(rfn))/v(s0)*2)
let zr = real(zin)
let zi = imag(zin)
noise v(rfp,rfn) VRF lin 1 1.57542e+09 1.57542e+09
setplot noise1
let nf = 10*log10(1+(inoise_spectrum^2-4*1.380649e-23*300*50)/(4*1.380649e-23*300*50))
echo RES lp=0 se=-1.5 lp2=12 f=1.57542e+09 zr=$&ac1.zr zi=$&ac1.zi s11=$&ac1.s11 gd=$&ac1.gd nf=$&nf
destroy all
alter LP = 1
alter CP = 1e-18
alter LP2 = 1.2e-08
alter CP2 = 1e-18
alter LSER = 1e-12
alter CSER = 8.2e-13
ac lin 1 1.57542e+09 1.57542e+09
let zin = v(s1)/(-i(VRF))
let s11 = db((zin-50)/(zin+50))
let gd = db((v(rfp)-v(rfn))/v(s0)*2)
let zr = real(zin)
let zi = imag(zin)
noise v(rfp,rfn) VRF lin 1 1.57542e+09 1.57542e+09
setplot noise1
let nf = 10*log10(1+(inoise_spectrum^2-4*1.380649e-23*300*50)/(4*1.380649e-23*300*50))
echo RES lp=0 se=-0.82 lp2=12 f=1.57542e+09 zr=$&ac1.zr zi=$&ac1.zi s11=$&ac1.s11 gd=$&ac1.gd nf=$&nf
destroy all
alter LP = 1
alter CP = 1e-18
alter LP2 = 1.5e-08
alter CP2 = 1e-18
alter LSER = 6.8e-09
alter CSER = 1e-11
ac lin 1 1.57542e+09 1.57542e+09
let zin = v(s1)/(-i(VRF))
let s11 = db((zin-50)/(zin+50))
let gd = db((v(rfp)-v(rfn))/v(s0)*2)
let zr = real(zin)
let zi = imag(zin)
noise v(rfp,rfn) VRF lin 1 1.57542e+09 1.57542e+09
setplot noise1
let nf = 10*log10(1+(inoise_spectrum^2-4*1.380649e-23*300*50)/(4*1.380649e-23*300*50))
echo RES lp=0 se=6.8 lp2=15 f=1.57542e+09 zr=$&ac1.zr zi=$&ac1.zi s11=$&ac1.s11 gd=$&ac1.gd nf=$&nf
destroy all
alter LP = 1
alter CP = 1e-18
alter LP2 = 1.5e-08
alter CP2 = 1e-18
alter LSER = 1e-12
alter CSER = 3.3e-12
ac lin 1 1.57542e+09 1.57542e+09
let zin = v(s1)/(-i(VRF))
let s11 = db((zin-50)/(zin+50))
let gd = db((v(rfp)-v(rfn))/v(s0)*2)
let zr = real(zin)
let zi = imag(zin)
noise v(rfp,rfn) VRF lin 1 1.57542e+09 1.57542e+09
setplot noise1
let nf = 10*log10(1+(inoise_spectrum^2-4*1.380649e-23*300*50)/(4*1.380649e-23*300*50))
echo RES lp=0 se=-3.3 lp2=15 f=1.57542e+09 zr=$&ac1.zr zi=$&ac1.zi s11=$&ac1.s11 gd=$&ac1.gd nf=$&nf
destroy all
alter LP = 1
alter CP = 1e-18
alter LP2 = 1.8e-08
alter CP2 = 1e-18
alter LSER = 1.5e-09
alter CSER = 1e-11
ac lin 1 1.57542e+09 1.57542e+09
let zin = v(s1)/(-i(VRF))
let s11 = db((zin-50)/(zin+50))
let gd = db((v(rfp)-v(rfn))/v(s0)*2)
let zr = real(zin)
let zi = imag(zin)
noise v(rfp,rfn) VRF lin 1 1.57542e+09 1.57542e+09
setplot noise1
let nf = 10*log10(1+(inoise_spectrum^2-4*1.380649e-23*300*50)/(4*1.380649e-23*300*50))
echo RES lp=0 se=1.5 lp2=18 f=1.57542e+09 zr=$&ac1.zr zi=$&ac1.zi s11=$&ac1.s11 gd=$&ac1.gd nf=$&nf
destroy all
alter LP = 1
alter CP = 1e-18
alter LP2 = 1.8e-08
alter CP2 = 1e-18
alter LSER = 1.5e-08
alter CSER = 1e-11
ac lin 1 1.57542e+09 1.57542e+09
let zin = v(s1)/(-i(VRF))
let s11 = db((zin-50)/(zin+50))
let gd = db((v(rfp)-v(rfn))/v(s0)*2)
let zr = real(zin)
let zi = imag(zin)
noise v(rfp,rfn) VRF lin 1 1.57542e+09 1.57542e+09
setplot noise1
let nf = 10*log10(1+(inoise_spectrum^2-4*1.380649e-23*300*50)/(4*1.380649e-23*300*50))
echo RES lp=0 se=15 lp2=18 f=1.57542e+09 zr=$&ac1.zr zi=$&ac1.zi s11=$&ac1.s11 gd=$&ac1.gd nf=$&nf
destroy all
alter LP = 1
alter CP = 1e-18
alter LP2 = 1.8e-08
alter CP2 = 1e-18
alter LSER = 1e-12
alter CSER = 6.8e-12
ac lin 1 1.57542e+09 1.57542e+09
let zin = v(s1)/(-i(VRF))
let s11 = db((zin-50)/(zin+50))
let gd = db((v(rfp)-v(rfn))/v(s0)*2)
let zr = real(zin)
let zi = imag(zin)
noise v(rfp,rfn) VRF lin 1 1.57542e+09 1.57542e+09
setplot noise1
let nf = 10*log10(1+(inoise_spectrum^2-4*1.380649e-23*300*50)/(4*1.380649e-23*300*50))
echo RES lp=0 se=-6.8 lp2=18 f=1.57542e+09 zr=$&ac1.zr zi=$&ac1.zi s11=$&ac1.s11 gd=$&ac1.gd nf=$&nf
destroy all
alter LP = 1
alter CP = 1e-18
alter LP2 = 2.2e-08
alter CP2 = 1e-18
alter LSER = 3.3e-09
alter CSER = 1e-11
ac lin 1 1.57542e+09 1.57542e+09
let zin = v(s1)/(-i(VRF))
let s11 = db((zin-50)/(zin+50))
let gd = db((v(rfp)-v(rfn))/v(s0)*2)
let zr = real(zin)
let zi = imag(zin)
noise v(rfp,rfn) VRF lin 1 1.57542e+09 1.57542e+09
setplot noise1
let nf = 10*log10(1+(inoise_spectrum^2-4*1.380649e-23*300*50)/(4*1.380649e-23*300*50))
echo RES lp=0 se=3.3 lp2=22 f=1.57542e+09 zr=$&ac1.zr zi=$&ac1.zi s11=$&ac1.s11 gd=$&ac1.gd nf=$&nf
destroy all
alter LP = 1
alter CP = 1e-18
alter LP2 = 2.2e-08
alter CP2 = 1e-18
alter LSER = 1e-12
alter CSER = 1.5e-12
ac lin 1 1.57542e+09 1.57542e+09
let zin = v(s1)/(-i(VRF))
let s11 = db((zin-50)/(zin+50))
let gd = db((v(rfp)-v(rfn))/v(s0)*2)
let zr = real(zin)
let zi = imag(zin)
noise v(rfp,rfn) VRF lin 1 1.57542e+09 1.57542e+09
setplot noise1
let nf = 10*log10(1+(inoise_spectrum^2-4*1.380649e-23*300*50)/(4*1.380649e-23*300*50))
echo RES lp=0 se=-1.5 lp2=22 f=1.57542e+09 zr=$&ac1.zr zi=$&ac1.zi s11=$&ac1.s11 gd=$&ac1.gd nf=$&nf
destroy all
alter LP = 1
alter CP = 1e-18
alter LP2 = 2.2e-08
alter CP2 = 1e-18
alter LSER = 1e-12
alter CSER = 8.2e-13
ac lin 1 1.57542e+09 1.57542e+09
let zin = v(s1)/(-i(VRF))
let s11 = db((zin-50)/(zin+50))
let gd = db((v(rfp)-v(rfn))/v(s0)*2)
let zr = real(zin)
let zi = imag(zin)
noise v(rfp,rfn) VRF lin 1 1.57542e+09 1.57542e+09
setplot noise1
let nf = 10*log10(1+(inoise_spectrum^2-4*1.380649e-23*300*50)/(4*1.380649e-23*300*50))
echo RES lp=0 se=-0.82 lp2=22 f=1.57542e+09 zr=$&ac1.zr zi=$&ac1.zi s11=$&ac1.s11 gd=$&ac1.gd nf=$&nf
destroy all
alter LP = 1
alter CP = 1e-18
alter LP2 = 1
alter CP2 = 1e-12
alter LSER = 6.8e-09
alter CSER = 1e-11
ac lin 1 1.57542e+09 1.57542e+09
let zin = v(s1)/(-i(VRF))
let s11 = db((zin-50)/(zin+50))
let gd = db((v(rfp)-v(rfn))/v(s0)*2)
let zr = real(zin)
let zi = imag(zin)
noise v(rfp,rfn) VRF lin 1 1.57542e+09 1.57542e+09
setplot noise1
let nf = 10*log10(1+(inoise_spectrum^2-4*1.380649e-23*300*50)/(4*1.380649e-23*300*50))
echo RES lp=0 se=6.8 lp2=-1 f=1.57542e+09 zr=$&ac1.zr zi=$&ac1.zi s11=$&ac1.s11 gd=$&ac1.gd nf=$&nf
destroy all
alter LP = 1
alter CP = 1e-18
alter LP2 = 1
alter CP2 = 1e-12
alter LSER = 1e-12
alter CSER = 3.3e-12
ac lin 1 1.57542e+09 1.57542e+09
let zin = v(s1)/(-i(VRF))
let s11 = db((zin-50)/(zin+50))
let gd = db((v(rfp)-v(rfn))/v(s0)*2)
let zr = real(zin)
let zi = imag(zin)
noise v(rfp,rfn) VRF lin 1 1.57542e+09 1.57542e+09
setplot noise1
let nf = 10*log10(1+(inoise_spectrum^2-4*1.380649e-23*300*50)/(4*1.380649e-23*300*50))
echo RES lp=0 se=-3.3 lp2=-1 f=1.57542e+09 zr=$&ac1.zr zi=$&ac1.zi s11=$&ac1.s11 gd=$&ac1.gd nf=$&nf
destroy all
alter LP = 1
alter CP = 1e-18
alter LP2 = 1
alter CP2 = 1.2e-12
alter LSER = 1.5e-09
alter CSER = 1e-11
ac lin 1 1.57542e+09 1.57542e+09
let zin = v(s1)/(-i(VRF))
let s11 = db((zin-50)/(zin+50))
let gd = db((v(rfp)-v(rfn))/v(s0)*2)
let zr = real(zin)
let zi = imag(zin)
noise v(rfp,rfn) VRF lin 1 1.57542e+09 1.57542e+09
setplot noise1
let nf = 10*log10(1+(inoise_spectrum^2-4*1.380649e-23*300*50)/(4*1.380649e-23*300*50))
echo RES lp=0 se=1.5 lp2=-1.2 f=1.57542e+09 zr=$&ac1.zr zi=$&ac1.zi s11=$&ac1.s11 gd=$&ac1.gd nf=$&nf
destroy all
alter LP = 1
alter CP = 1e-18
alter LP2 = 1
alter CP2 = 1.2e-12
alter LSER = 1.5e-08
alter CSER = 1e-11
ac lin 1 1.57542e+09 1.57542e+09
let zin = v(s1)/(-i(VRF))
let s11 = db((zin-50)/(zin+50))
let gd = db((v(rfp)-v(rfn))/v(s0)*2)
let zr = real(zin)
let zi = imag(zin)
noise v(rfp,rfn) VRF lin 1 1.57542e+09 1.57542e+09
setplot noise1
let nf = 10*log10(1+(inoise_spectrum^2-4*1.380649e-23*300*50)/(4*1.380649e-23*300*50))
echo RES lp=0 se=15 lp2=-1.2 f=1.57542e+09 zr=$&ac1.zr zi=$&ac1.zi s11=$&ac1.s11 gd=$&ac1.gd nf=$&nf
destroy all
alter LP = 1
alter CP = 1e-18
alter LP2 = 1
alter CP2 = 1.2e-12
alter LSER = 1e-12
alter CSER = 6.8e-12
ac lin 1 1.57542e+09 1.57542e+09
let zin = v(s1)/(-i(VRF))
let s11 = db((zin-50)/(zin+50))
let gd = db((v(rfp)-v(rfn))/v(s0)*2)
let zr = real(zin)
let zi = imag(zin)
noise v(rfp,rfn) VRF lin 1 1.57542e+09 1.57542e+09
setplot noise1
let nf = 10*log10(1+(inoise_spectrum^2-4*1.380649e-23*300*50)/(4*1.380649e-23*300*50))
echo RES lp=0 se=-6.8 lp2=-1.2 f=1.57542e+09 zr=$&ac1.zr zi=$&ac1.zi s11=$&ac1.s11 gd=$&ac1.gd nf=$&nf
destroy all
alter LP = 1
alter CP = 1e-18
alter LP2 = 1
alter CP2 = 1.5e-12
alter LSER = 3.3e-09
alter CSER = 1e-11
ac lin 1 1.57542e+09 1.57542e+09
let zin = v(s1)/(-i(VRF))
let s11 = db((zin-50)/(zin+50))
let gd = db((v(rfp)-v(rfn))/v(s0)*2)
let zr = real(zin)
let zi = imag(zin)
noise v(rfp,rfn) VRF lin 1 1.57542e+09 1.57542e+09
setplot noise1
let nf = 10*log10(1+(inoise_spectrum^2-4*1.380649e-23*300*50)/(4*1.380649e-23*300*50))
echo RES lp=0 se=3.3 lp2=-1.5 f=1.57542e+09 zr=$&ac1.zr zi=$&ac1.zi s11=$&ac1.s11 gd=$&ac1.gd nf=$&nf
destroy all
alter LP = 1
alter CP = 1e-18
alter LP2 = 1
alter CP2 = 1.5e-12
alter LSER = 1e-12
alter CSER = 1.5e-12
ac lin 1 1.57542e+09 1.57542e+09
let zin = v(s1)/(-i(VRF))
let s11 = db((zin-50)/(zin+50))
let gd = db((v(rfp)-v(rfn))/v(s0)*2)
let zr = real(zin)
let zi = imag(zin)
noise v(rfp,rfn) VRF lin 1 1.57542e+09 1.57542e+09
setplot noise1
let nf = 10*log10(1+(inoise_spectrum^2-4*1.380649e-23*300*50)/(4*1.380649e-23*300*50))
echo RES lp=0 se=-1.5 lp2=-1.5 f=1.57542e+09 zr=$&ac1.zr zi=$&ac1.zi s11=$&ac1.s11 gd=$&ac1.gd nf=$&nf
destroy all
alter LP = 1
alter CP = 1e-18
alter LP2 = 1
alter CP2 = 1.5e-12
alter LSER = 1e-12
alter CSER = 8.2e-13
ac lin 1 1.57542e+09 1.57542e+09
let zin = v(s1)/(-i(VRF))
let s11 = db((zin-50)/(zin+50))
let gd = db((v(rfp)-v(rfn))/v(s0)*2)
let zr = real(zin)
let zi = imag(zin)
noise v(rfp,rfn) VRF lin 1 1.57542e+09 1.57542e+09
setplot noise1
let nf = 10*log10(1+(inoise_spectrum^2-4*1.380649e-23*300*50)/(4*1.380649e-23*300*50))
echo RES lp=0 se=-0.82 lp2=-1.5 f=1.57542e+09 zr=$&ac1.zr zi=$&ac1.zi s11=$&ac1.s11 gd=$&ac1.gd nf=$&nf
destroy all
alter LP = 1
alter CP = 1e-18
alter LP2 = 1
alter CP2 = 1.8e-12
alter LSER = 6.8e-09
alter CSER = 1e-11
ac lin 1 1.57542e+09 1.57542e+09
let zin = v(s1)/(-i(VRF))
let s11 = db((zin-50)/(zin+50))
let gd = db((v(rfp)-v(rfn))/v(s0)*2)
let zr = real(zin)
let zi = imag(zin)
noise v(rfp,rfn) VRF lin 1 1.57542e+09 1.57542e+09
setplot noise1
let nf = 10*log10(1+(inoise_spectrum^2-4*1.380649e-23*300*50)/(4*1.380649e-23*300*50))
echo RES lp=0 se=6.8 lp2=-1.8 f=1.57542e+09 zr=$&ac1.zr zi=$&ac1.zi s11=$&ac1.s11 gd=$&ac1.gd nf=$&nf
destroy all
alter LP = 1
alter CP = 1e-18
alter LP2 = 1
alter CP2 = 1.8e-12
alter LSER = 1e-12
alter CSER = 3.3e-12
ac lin 1 1.57542e+09 1.57542e+09
let zin = v(s1)/(-i(VRF))
let s11 = db((zin-50)/(zin+50))
let gd = db((v(rfp)-v(rfn))/v(s0)*2)
let zr = real(zin)
let zi = imag(zin)
noise v(rfp,rfn) VRF lin 1 1.57542e+09 1.57542e+09
setplot noise1
let nf = 10*log10(1+(inoise_spectrum^2-4*1.380649e-23*300*50)/(4*1.380649e-23*300*50))
echo RES lp=0 se=-3.3 lp2=-1.8 f=1.57542e+09 zr=$&ac1.zr zi=$&ac1.zi s11=$&ac1.s11 gd=$&ac1.gd nf=$&nf
destroy all
alter LP = 1
alter CP = 1e-18
alter LP2 = 1
alter CP2 = 2.2e-12
alter LSER = 1.5e-09
alter CSER = 1e-11
ac lin 1 1.57542e+09 1.57542e+09
let zin = v(s1)/(-i(VRF))
let s11 = db((zin-50)/(zin+50))
let gd = db((v(rfp)-v(rfn))/v(s0)*2)
let zr = real(zin)
let zi = imag(zin)
noise v(rfp,rfn) VRF lin 1 1.57542e+09 1.57542e+09
setplot noise1
let nf = 10*log10(1+(inoise_spectrum^2-4*1.380649e-23*300*50)/(4*1.380649e-23*300*50))
echo RES lp=0 se=1.5 lp2=-2.2 f=1.57542e+09 zr=$&ac1.zr zi=$&ac1.zi s11=$&ac1.s11 gd=$&ac1.gd nf=$&nf
destroy all
alter LP = 1
alter CP = 1e-18
alter LP2 = 1
alter CP2 = 2.2e-12
alter LSER = 1.5e-08
alter CSER = 1e-11
ac lin 1 1.57542e+09 1.57542e+09
let zin = v(s1)/(-i(VRF))
let s11 = db((zin-50)/(zin+50))
let gd = db((v(rfp)-v(rfn))/v(s0)*2)
let zr = real(zin)
let zi = imag(zin)
noise v(rfp,rfn) VRF lin 1 1.57542e+09 1.57542e+09
setplot noise1
let nf = 10*log10(1+(inoise_spectrum^2-4*1.380649e-23*300*50)/(4*1.380649e-23*300*50))
echo RES lp=0 se=15 lp2=-2.2 f=1.57542e+09 zr=$&ac1.zr zi=$&ac1.zi s11=$&ac1.s11 gd=$&ac1.gd nf=$&nf
destroy all
alter LP = 1
alter CP = 1e-18
alter LP2 = 1
alter CP2 = 2.2e-12
alter LSER = 1e-12
alter CSER = 6.8e-12
ac lin 1 1.57542e+09 1.57542e+09
let zin = v(s1)/(-i(VRF))
let s11 = db((zin-50)/(zin+50))
let gd = db((v(rfp)-v(rfn))/v(s0)*2)
let zr = real(zin)
let zi = imag(zin)
noise v(rfp,rfn) VRF lin 1 1.57542e+09 1.57542e+09
setplot noise1
let nf = 10*log10(1+(inoise_spectrum^2-4*1.380649e-23*300*50)/(4*1.380649e-23*300*50))
echo RES lp=0 se=-6.8 lp2=-2.2 f=1.57542e+09 zr=$&ac1.zr zi=$&ac1.zi s11=$&ac1.s11 gd=$&ac1.gd nf=$&nf
destroy all
alter LP = 1
alter CP = 1e-18
alter LP2 = 1
alter CP2 = 2.7e-12
alter LSER = 3.3e-09
alter CSER = 1e-11
ac lin 1 1.57542e+09 1.57542e+09
let zin = v(s1)/(-i(VRF))
let s11 = db((zin-50)/(zin+50))
let gd = db((v(rfp)-v(rfn))/v(s0)*2)
let zr = real(zin)
let zi = imag(zin)
noise v(rfp,rfn) VRF lin 1 1.57542e+09 1.57542e+09
setplot noise1
let nf = 10*log10(1+(inoise_spectrum^2-4*1.380649e-23*300*50)/(4*1.380649e-23*300*50))
echo RES lp=0 se=3.3 lp2=-2.7 f=1.57542e+09 zr=$&ac1.zr zi=$&ac1.zi s11=$&ac1.s11 gd=$&ac1.gd nf=$&nf
destroy all
alter LP = 1
alter CP = 1e-18
alter LP2 = 1
alter CP2 = 2.7e-12
alter LSER = 1e-12
alter CSER = 1.5e-12
ac lin 1 1.57542e+09 1.57542e+09
let zin = v(s1)/(-i(VRF))
let s11 = db((zin-50)/(zin+50))
let gd = db((v(rfp)-v(rfn))/v(s0)*2)
let zr = real(zin)
let zi = imag(zin)
noise v(rfp,rfn) VRF lin 1 1.57542e+09 1.57542e+09
setplot noise1
let nf = 10*log10(1+(inoise_spectrum^2-4*1.380649e-23*300*50)/(4*1.380649e-23*300*50))
echo RES lp=0 se=-1.5 lp2=-2.7 f=1.57542e+09 zr=$&ac1.zr zi=$&ac1.zi s11=$&ac1.s11 gd=$&ac1.gd nf=$&nf
destroy all
alter LP = 1
alter CP = 1e-18
alter LP2 = 1
alter CP2 = 2.7e-12
alter LSER = 1e-12
alter CSER = 8.2e-13
ac lin 1 1.57542e+09 1.57542e+09
let zin = v(s1)/(-i(VRF))
let s11 = db((zin-50)/(zin+50))
let gd = db((v(rfp)-v(rfn))/v(s0)*2)
let zr = real(zin)
let zi = imag(zin)
noise v(rfp,rfn) VRF lin 1 1.57542e+09 1.57542e+09
setplot noise1
let nf = 10*log10(1+(inoise_spectrum^2-4*1.380649e-23*300*50)/(4*1.380649e-23*300*50))
echo RES lp=0 se=-0.82 lp2=-2.7 f=1.57542e+09 zr=$&ac1.zr zi=$&ac1.zi s11=$&ac1.s11 gd=$&ac1.gd nf=$&nf
destroy all
alter LP = 1
alter CP = 1e-18
alter LP2 = 1
alter CP2 = 3.3e-12
alter LSER = 6.8e-09
alter CSER = 1e-11
ac lin 1 1.57542e+09 1.57542e+09
let zin = v(s1)/(-i(VRF))
let s11 = db((zin-50)/(zin+50))
let gd = db((v(rfp)-v(rfn))/v(s0)*2)
let zr = real(zin)
let zi = imag(zin)
noise v(rfp,rfn) VRF lin 1 1.57542e+09 1.57542e+09
setplot noise1
let nf = 10*log10(1+(inoise_spectrum^2-4*1.380649e-23*300*50)/(4*1.380649e-23*300*50))
echo RES lp=0 se=6.8 lp2=-3.3 f=1.57542e+09 zr=$&ac1.zr zi=$&ac1.zi s11=$&ac1.s11 gd=$&ac1.gd nf=$&nf
destroy all
alter LP = 1
alter CP = 1e-18
alter LP2 = 1
alter CP2 = 3.3e-12
alter LSER = 1e-12
alter CSER = 3.3e-12
ac lin 1 1.57542e+09 1.57542e+09
let zin = v(s1)/(-i(VRF))
let s11 = db((zin-50)/(zin+50))
let gd = db((v(rfp)-v(rfn))/v(s0)*2)
let zr = real(zin)
let zi = imag(zin)
noise v(rfp,rfn) VRF lin 1 1.57542e+09 1.57542e+09
setplot noise1
let nf = 10*log10(1+(inoise_spectrum^2-4*1.380649e-23*300*50)/(4*1.380649e-23*300*50))
echo RES lp=0 se=-3.3 lp2=-3.3 f=1.57542e+09 zr=$&ac1.zr zi=$&ac1.zi s11=$&ac1.s11 gd=$&ac1.gd nf=$&nf
destroy all
alter LP = 1
alter CP = 1e-18
alter LP2 = 1
alter CP2 = 3.9e-12
alter LSER = 1.5e-09
alter CSER = 1e-11
ac lin 1 1.57542e+09 1.57542e+09
let zin = v(s1)/(-i(VRF))
let s11 = db((zin-50)/(zin+50))
let gd = db((v(rfp)-v(rfn))/v(s0)*2)
let zr = real(zin)
let zi = imag(zin)
noise v(rfp,rfn) VRF lin 1 1.57542e+09 1.57542e+09
setplot noise1
let nf = 10*log10(1+(inoise_spectrum^2-4*1.380649e-23*300*50)/(4*1.380649e-23*300*50))
echo RES lp=0 se=1.5 lp2=-3.9 f=1.57542e+09 zr=$&ac1.zr zi=$&ac1.zi s11=$&ac1.s11 gd=$&ac1.gd nf=$&nf
destroy all
alter LP = 1
alter CP = 1e-18
alter LP2 = 1
alter CP2 = 3.9e-12
alter LSER = 1.5e-08
alter CSER = 1e-11
ac lin 1 1.57542e+09 1.57542e+09
let zin = v(s1)/(-i(VRF))
let s11 = db((zin-50)/(zin+50))
let gd = db((v(rfp)-v(rfn))/v(s0)*2)
let zr = real(zin)
let zi = imag(zin)
noise v(rfp,rfn) VRF lin 1 1.57542e+09 1.57542e+09
setplot noise1
let nf = 10*log10(1+(inoise_spectrum^2-4*1.380649e-23*300*50)/(4*1.380649e-23*300*50))
echo RES lp=0 se=15 lp2=-3.9 f=1.57542e+09 zr=$&ac1.zr zi=$&ac1.zi s11=$&ac1.s11 gd=$&ac1.gd nf=$&nf
destroy all
alter LP = 1
alter CP = 1e-18
alter LP2 = 1
alter CP2 = 3.9e-12
alter LSER = 1e-12
alter CSER = 6.8e-12
ac lin 1 1.57542e+09 1.57542e+09
let zin = v(s1)/(-i(VRF))
let s11 = db((zin-50)/(zin+50))
let gd = db((v(rfp)-v(rfn))/v(s0)*2)
let zr = real(zin)
let zi = imag(zin)
noise v(rfp,rfn) VRF lin 1 1.57542e+09 1.57542e+09
setplot noise1
let nf = 10*log10(1+(inoise_spectrum^2-4*1.380649e-23*300*50)/(4*1.380649e-23*300*50))
echo RES lp=0 se=-6.8 lp2=-3.9 f=1.57542e+09 zr=$&ac1.zr zi=$&ac1.zi s11=$&ac1.s11 gd=$&ac1.gd nf=$&nf
destroy all
alter LP = 1
alter CP = 1e-18
alter LP2 = 1
alter CP2 = 4.7e-12
alter LSER = 3.3e-09
alter CSER = 1e-11
ac lin 1 1.57542e+09 1.57542e+09
let zin = v(s1)/(-i(VRF))
let s11 = db((zin-50)/(zin+50))
let gd = db((v(rfp)-v(rfn))/v(s0)*2)
let zr = real(zin)
let zi = imag(zin)
noise v(rfp,rfn) VRF lin 1 1.57542e+09 1.57542e+09
setplot noise1
let nf = 10*log10(1+(inoise_spectrum^2-4*1.380649e-23*300*50)/(4*1.380649e-23*300*50))
echo RES lp=0 se=3.3 lp2=-4.7 f=1.57542e+09 zr=$&ac1.zr zi=$&ac1.zi s11=$&ac1.s11 gd=$&ac1.gd nf=$&nf
destroy all
alter LP = 1
alter CP = 1e-18
alter LP2 = 1
alter CP2 = 4.7e-12
alter LSER = 1e-12
alter CSER = 1.5e-12
ac lin 1 1.57542e+09 1.57542e+09
let zin = v(s1)/(-i(VRF))
let s11 = db((zin-50)/(zin+50))
let gd = db((v(rfp)-v(rfn))/v(s0)*2)
let zr = real(zin)
let zi = imag(zin)
noise v(rfp,rfn) VRF lin 1 1.57542e+09 1.57542e+09
setplot noise1
let nf = 10*log10(1+(inoise_spectrum^2-4*1.380649e-23*300*50)/(4*1.380649e-23*300*50))
echo RES lp=0 se=-1.5 lp2=-4.7 f=1.57542e+09 zr=$&ac1.zr zi=$&ac1.zi s11=$&ac1.s11 gd=$&ac1.gd nf=$&nf
destroy all
alter LP = 1
alter CP = 1e-18
alter LP2 = 1
alter CP2 = 4.7e-12
alter LSER = 1e-12
alter CSER = 8.2e-13
ac lin 1 1.57542e+09 1.57542e+09
let zin = v(s1)/(-i(VRF))
let s11 = db((zin-50)/(zin+50))
let gd = db((v(rfp)-v(rfn))/v(s0)*2)
let zr = real(zin)
let zi = imag(zin)
noise v(rfp,rfn) VRF lin 1 1.57542e+09 1.57542e+09
setplot noise1
let nf = 10*log10(1+(inoise_spectrum^2-4*1.380649e-23*300*50)/(4*1.380649e-23*300*50))
echo RES lp=0 se=-0.82 lp2=-4.7 f=1.57542e+09 zr=$&ac1.zr zi=$&ac1.zi s11=$&ac1.s11 gd=$&ac1.gd nf=$&nf
destroy all
alter LP = 1
alter CP = 1e-18
alter LP2 = 1
alter CP2 = 5.6e-12
alter LSER = 6.8e-09
alter CSER = 1e-11
ac lin 1 1.57542e+09 1.57542e+09
let zin = v(s1)/(-i(VRF))
let s11 = db((zin-50)/(zin+50))
let gd = db((v(rfp)-v(rfn))/v(s0)*2)
let zr = real(zin)
let zi = imag(zin)
noise v(rfp,rfn) VRF lin 1 1.57542e+09 1.57542e+09
setplot noise1
let nf = 10*log10(1+(inoise_spectrum^2-4*1.380649e-23*300*50)/(4*1.380649e-23*300*50))
echo RES lp=0 se=6.8 lp2=-5.6 f=1.57542e+09 zr=$&ac1.zr zi=$&ac1.zi s11=$&ac1.s11 gd=$&ac1.gd nf=$&nf
destroy all
alter LP = 1
alter CP = 1e-18
alter LP2 = 1
alter CP2 = 5.6e-12
alter LSER = 1e-12
alter CSER = 3.3e-12
ac lin 1 1.57542e+09 1.57542e+09
let zin = v(s1)/(-i(VRF))
let s11 = db((zin-50)/(zin+50))
let gd = db((v(rfp)-v(rfn))/v(s0)*2)
let zr = real(zin)
let zi = imag(zin)
noise v(rfp,rfn) VRF lin 1 1.57542e+09 1.57542e+09
setplot noise1
let nf = 10*log10(1+(inoise_spectrum^2-4*1.380649e-23*300*50)/(4*1.380649e-23*300*50))
echo RES lp=0 se=-3.3 lp2=-5.6 f=1.57542e+09 zr=$&ac1.zr zi=$&ac1.zi s11=$&ac1.s11 gd=$&ac1.gd nf=$&nf
destroy all
alter LP = 1
alter CP = 1e-18
alter LP2 = 1
alter CP2 = 6.8e-12
alter LSER = 1.5e-09
alter CSER = 1e-11
ac lin 1 1.57542e+09 1.57542e+09
let zin = v(s1)/(-i(VRF))
let s11 = db((zin-50)/(zin+50))
let gd = db((v(rfp)-v(rfn))/v(s0)*2)
let zr = real(zin)
let zi = imag(zin)
noise v(rfp,rfn) VRF lin 1 1.57542e+09 1.57542e+09
setplot noise1
let nf = 10*log10(1+(inoise_spectrum^2-4*1.380649e-23*300*50)/(4*1.380649e-23*300*50))
echo RES lp=0 se=1.5 lp2=-6.8 f=1.57542e+09 zr=$&ac1.zr zi=$&ac1.zi s11=$&ac1.s11 gd=$&ac1.gd nf=$&nf
destroy all
alter LP = 1
alter CP = 1e-18
alter LP2 = 1
alter CP2 = 6.8e-12
alter LSER = 1.5e-08
alter CSER = 1e-11
ac lin 1 1.57542e+09 1.57542e+09
let zin = v(s1)/(-i(VRF))
let s11 = db((zin-50)/(zin+50))
let gd = db((v(rfp)-v(rfn))/v(s0)*2)
let zr = real(zin)
let zi = imag(zin)
noise v(rfp,rfn) VRF lin 1 1.57542e+09 1.57542e+09
setplot noise1
let nf = 10*log10(1+(inoise_spectrum^2-4*1.380649e-23*300*50)/(4*1.380649e-23*300*50))
echo RES lp=0 se=15 lp2=-6.8 f=1.57542e+09 zr=$&ac1.zr zi=$&ac1.zi s11=$&ac1.s11 gd=$&ac1.gd nf=$&nf
destroy all
alter LP = 1
alter CP = 1e-18
alter LP2 = 1
alter CP2 = 6.8e-12
alter LSER = 1e-12
alter CSER = 6.8e-12
ac lin 1 1.57542e+09 1.57542e+09
let zin = v(s1)/(-i(VRF))
let s11 = db((zin-50)/(zin+50))
let gd = db((v(rfp)-v(rfn))/v(s0)*2)
let zr = real(zin)
let zi = imag(zin)
noise v(rfp,rfn) VRF lin 1 1.57542e+09 1.57542e+09
setplot noise1
let nf = 10*log10(1+(inoise_spectrum^2-4*1.380649e-23*300*50)/(4*1.380649e-23*300*50))
echo RES lp=0 se=-6.8 lp2=-6.8 f=1.57542e+09 zr=$&ac1.zr zi=$&ac1.zi s11=$&ac1.s11 gd=$&ac1.gd nf=$&nf
destroy all
alter LP = 1
alter CP = 1e-18
alter LP2 = 1
alter CP2 = 8.2e-12
alter LSER = 3.3e-09
alter CSER = 1e-11
ac lin 1 1.57542e+09 1.57542e+09
let zin = v(s1)/(-i(VRF))
let s11 = db((zin-50)/(zin+50))
let gd = db((v(rfp)-v(rfn))/v(s0)*2)
let zr = real(zin)
let zi = imag(zin)
noise v(rfp,rfn) VRF lin 1 1.57542e+09 1.57542e+09
setplot noise1
let nf = 10*log10(1+(inoise_spectrum^2-4*1.380649e-23*300*50)/(4*1.380649e-23*300*50))
echo RES lp=0 se=3.3 lp2=-8.2 f=1.57542e+09 zr=$&ac1.zr zi=$&ac1.zi s11=$&ac1.s11 gd=$&ac1.gd nf=$&nf
destroy all
alter LP = 1
alter CP = 1e-18
alter LP2 = 1
alter CP2 = 8.2e-12
alter LSER = 1e-12
alter CSER = 1.5e-12
ac lin 1 1.57542e+09 1.57542e+09
let zin = v(s1)/(-i(VRF))
let s11 = db((zin-50)/(zin+50))
let gd = db((v(rfp)-v(rfn))/v(s0)*2)
let zr = real(zin)
let zi = imag(zin)
noise v(rfp,rfn) VRF lin 1 1.57542e+09 1.57542e+09
setplot noise1
let nf = 10*log10(1+(inoise_spectrum^2-4*1.380649e-23*300*50)/(4*1.380649e-23*300*50))
echo RES lp=0 se=-1.5 lp2=-8.2 f=1.57542e+09 zr=$&ac1.zr zi=$&ac1.zi s11=$&ac1.s11 gd=$&ac1.gd nf=$&nf
destroy all
alter LP = 1
alter CP = 1e-18
alter LP2 = 1
alter CP2 = 8.2e-12
alter LSER = 1e-12
alter CSER = 8.2e-13
ac lin 1 1.57542e+09 1.57542e+09
let zin = v(s1)/(-i(VRF))
let s11 = db((zin-50)/(zin+50))
let gd = db((v(rfp)-v(rfn))/v(s0)*2)
let zr = real(zin)
let zi = imag(zin)
noise v(rfp,rfn) VRF lin 1 1.57542e+09 1.57542e+09
setplot noise1
let nf = 10*log10(1+(inoise_spectrum^2-4*1.380649e-23*300*50)/(4*1.380649e-23*300*50))
echo RES lp=0 se=-0.82 lp2=-8.2 f=1.57542e+09 zr=$&ac1.zr zi=$&ac1.zi s11=$&ac1.s11 gd=$&ac1.gd nf=$&nf
destroy all
alter LP = 1
alter CP = 1e-18
alter LP2 = 1
alter CP2 = 1e-11
alter LSER = 6.8e-09
alter CSER = 1e-11
ac lin 1 1.57542e+09 1.57542e+09
let zin = v(s1)/(-i(VRF))
let s11 = db((zin-50)/(zin+50))
let gd = db((v(rfp)-v(rfn))/v(s0)*2)
let zr = real(zin)
let zi = imag(zin)
noise v(rfp,rfn) VRF lin 1 1.57542e+09 1.57542e+09
setplot noise1
let nf = 10*log10(1+(inoise_spectrum^2-4*1.380649e-23*300*50)/(4*1.380649e-23*300*50))
echo RES lp=0 se=6.8 lp2=-10 f=1.57542e+09 zr=$&ac1.zr zi=$&ac1.zi s11=$&ac1.s11 gd=$&ac1.gd nf=$&nf
destroy all
alter LP = 1
alter CP = 1e-18
alter LP2 = 1
alter CP2 = 1e-11
alter LSER = 1e-12
alter CSER = 3.3e-12
ac lin 1 1.57542e+09 1.57542e+09
let zin = v(s1)/(-i(VRF))
let s11 = db((zin-50)/(zin+50))
let gd = db((v(rfp)-v(rfn))/v(s0)*2)
let zr = real(zin)
let zi = imag(zin)
noise v(rfp,rfn) VRF lin 1 1.57542e+09 1.57542e+09
setplot noise1
let nf = 10*log10(1+(inoise_spectrum^2-4*1.380649e-23*300*50)/(4*1.380649e-23*300*50))
echo RES lp=0 se=-3.3 lp2=-10 f=1.57542e+09 zr=$&ac1.zr zi=$&ac1.zi s11=$&ac1.s11 gd=$&ac1.gd nf=$&nf
destroy all
alter LP = 1
alter CP = 1e-18
alter LP2 = 1
alter CP2 = 5e-13
alter LSER = 1.5e-09
alter CSER = 1e-11
ac lin 1 1.57542e+09 1.57542e+09
let zin = v(s1)/(-i(VRF))
let s11 = db((zin-50)/(zin+50))
let gd = db((v(rfp)-v(rfn))/v(s0)*2)
let zr = real(zin)
let zi = imag(zin)
noise v(rfp,rfn) VRF lin 1 1.57542e+09 1.57542e+09
setplot noise1
let nf = 10*log10(1+(inoise_spectrum^2-4*1.380649e-23*300*50)/(4*1.380649e-23*300*50))
echo RES lp=0 se=1.5 lp2=-0.5 f=1.57542e+09 zr=$&ac1.zr zi=$&ac1.zi s11=$&ac1.s11 gd=$&ac1.gd nf=$&nf
destroy all
alter LP = 1
alter CP = 1e-18
alter LP2 = 1
alter CP2 = 5e-13
alter LSER = 1.5e-08
alter CSER = 1e-11
ac lin 1 1.57542e+09 1.57542e+09
let zin = v(s1)/(-i(VRF))
let s11 = db((zin-50)/(zin+50))
let gd = db((v(rfp)-v(rfn))/v(s0)*2)
let zr = real(zin)
let zi = imag(zin)
noise v(rfp,rfn) VRF lin 1 1.57542e+09 1.57542e+09
setplot noise1
let nf = 10*log10(1+(inoise_spectrum^2-4*1.380649e-23*300*50)/(4*1.380649e-23*300*50))
echo RES lp=0 se=15 lp2=-0.5 f=1.57542e+09 zr=$&ac1.zr zi=$&ac1.zi s11=$&ac1.s11 gd=$&ac1.gd nf=$&nf
destroy all
alter LP = 1
alter CP = 1e-18
alter LP2 = 1
alter CP2 = 5e-13
alter LSER = 1e-12
alter CSER = 6.8e-12
ac lin 1 1.57542e+09 1.57542e+09
let zin = v(s1)/(-i(VRF))
let s11 = db((zin-50)/(zin+50))
let gd = db((v(rfp)-v(rfn))/v(s0)*2)
let zr = real(zin)
let zi = imag(zin)
noise v(rfp,rfn) VRF lin 1 1.57542e+09 1.57542e+09
setplot noise1
let nf = 10*log10(1+(inoise_spectrum^2-4*1.380649e-23*300*50)/(4*1.380649e-23*300*50))
echo RES lp=0 se=-6.8 lp2=-0.5 f=1.57542e+09 zr=$&ac1.zr zi=$&ac1.zi s11=$&ac1.s11 gd=$&ac1.gd nf=$&nf
destroy all
alter LP = 1
alter CP = 1e-18
alter LP2 = 1
alter CP2 = 6.8e-13
alter LSER = 3.3e-09
alter CSER = 1e-11
ac lin 1 1.57542e+09 1.57542e+09
let zin = v(s1)/(-i(VRF))
let s11 = db((zin-50)/(zin+50))
let gd = db((v(rfp)-v(rfn))/v(s0)*2)
let zr = real(zin)
let zi = imag(zin)
noise v(rfp,rfn) VRF lin 1 1.57542e+09 1.57542e+09
setplot noise1
let nf = 10*log10(1+(inoise_spectrum^2-4*1.380649e-23*300*50)/(4*1.380649e-23*300*50))
echo RES lp=0 se=3.3 lp2=-0.68 f=1.57542e+09 zr=$&ac1.zr zi=$&ac1.zi s11=$&ac1.s11 gd=$&ac1.gd nf=$&nf
destroy all
alter LP = 1
alter CP = 1e-18
alter LP2 = 1
alter CP2 = 6.8e-13
alter LSER = 1e-12
alter CSER = 1.5e-12
ac lin 1 1.57542e+09 1.57542e+09
let zin = v(s1)/(-i(VRF))
let s11 = db((zin-50)/(zin+50))
let gd = db((v(rfp)-v(rfn))/v(s0)*2)
let zr = real(zin)
let zi = imag(zin)
noise v(rfp,rfn) VRF lin 1 1.57542e+09 1.57542e+09
setplot noise1
let nf = 10*log10(1+(inoise_spectrum^2-4*1.380649e-23*300*50)/(4*1.380649e-23*300*50))
echo RES lp=0 se=-1.5 lp2=-0.68 f=1.57542e+09 zr=$&ac1.zr zi=$&ac1.zi s11=$&ac1.s11 gd=$&ac1.gd nf=$&nf
destroy all
alter LP = 1
alter CP = 1e-18
alter LP2 = 1
alter CP2 = 6.8e-13
alter LSER = 1e-12
alter CSER = 8.2e-13
ac lin 1 1.57542e+09 1.57542e+09
let zin = v(s1)/(-i(VRF))
let s11 = db((zin-50)/(zin+50))
let gd = db((v(rfp)-v(rfn))/v(s0)*2)
let zr = real(zin)
let zi = imag(zin)
noise v(rfp,rfn) VRF lin 1 1.57542e+09 1.57542e+09
setplot noise1
let nf = 10*log10(1+(inoise_spectrum^2-4*1.380649e-23*300*50)/(4*1.380649e-23*300*50))
echo RES lp=0 se=-0.82 lp2=-0.68 f=1.57542e+09 zr=$&ac1.zr zi=$&ac1.zi s11=$&ac1.s11 gd=$&ac1.gd nf=$&nf
destroy all
alter LP = 1
alter CP = 1e-18
alter LP2 = 1
alter CP2 = 8.2e-13
alter LSER = 6.8e-09
alter CSER = 1e-11
ac lin 1 1.57542e+09 1.57542e+09
let zin = v(s1)/(-i(VRF))
let s11 = db((zin-50)/(zin+50))
let gd = db((v(rfp)-v(rfn))/v(s0)*2)
let zr = real(zin)
let zi = imag(zin)
noise v(rfp,rfn) VRF lin 1 1.57542e+09 1.57542e+09
setplot noise1
let nf = 10*log10(1+(inoise_spectrum^2-4*1.380649e-23*300*50)/(4*1.380649e-23*300*50))
echo RES lp=0 se=6.8 lp2=-0.82 f=1.57542e+09 zr=$&ac1.zr zi=$&ac1.zi s11=$&ac1.s11 gd=$&ac1.gd nf=$&nf
destroy all
alter LP = 1
alter CP = 1e-18
alter LP2 = 1
alter CP2 = 8.2e-13
alter LSER = 1e-12
alter CSER = 3.3e-12
ac lin 1 1.57542e+09 1.57542e+09
let zin = v(s1)/(-i(VRF))
let s11 = db((zin-50)/(zin+50))
let gd = db((v(rfp)-v(rfn))/v(s0)*2)
let zr = real(zin)
let zi = imag(zin)
noise v(rfp,rfn) VRF lin 1 1.57542e+09 1.57542e+09
setplot noise1
let nf = 10*log10(1+(inoise_spectrum^2-4*1.380649e-23*300*50)/(4*1.380649e-23*300*50))
echo RES lp=0 se=-3.3 lp2=-0.82 f=1.57542e+09 zr=$&ac1.zr zi=$&ac1.zi s11=$&ac1.s11 gd=$&ac1.gd nf=$&nf
destroy all
.endc

**** end user architecture code
**.ends

* expanding   symbol:  bias_gen.sym # of pins=4
** sym_path: /home/noritsuna/GPS/xschem/bias_gen.sym
** sch_path: /home/noritsuna/GPS/xschem/bias_gen.sch
.subckt bias_gen NB PB VDD VSS
*.opin NB
*.opin PB
*.iopin VDD
*.iopin VSS
XMN1 nbc nbc VSS VSS nfet_03v3 L=2u W=4u nf=1 ad='int((nf+1)/2) * W/nf * 0.18u' as='int((nf+2)/2) * W/nf * 0.18u' pd='2*int((nf+1)/2) * (W/nf + 0.18u)'
+ ps='2*int((nf+2)/2) * (W/nf + 0.18u)' nrd='0.18u / W' nrs='0.18u / W' sa=0 sb=0 sd=0 m=1 par=1
XMN2 pbc nbc nr VSS nfet_03v3 L=2u W=16u nf=2 ad='int((nf+1)/2) * W/nf * 0.18u' as='int((nf+2)/2) * W/nf * 0.18u' pd='2*int((nf+1)/2) * (W/nf + 0.18u)'
+ ps='2*int((nf+2)/2) * (W/nf + 0.18u)' nrd='0.18u / W' nrs='0.18u / W' sa=0 sb=0 sd=0 m=1 par=1
XRB VSS nr VSS ppolyf_u_1k r_width=1u r_length=4.6u
XMP1 nbc pbc VDD VDD pfet_03v3 L=2u W=8u nf=1 ad='int((nf+1)/2) * W/nf * 0.18u' as='int((nf+2)/2) * W/nf * 0.18u' pd='2*int((nf+1)/2) * (W/nf + 0.18u)'
+ ps='2*int((nf+2)/2) * (W/nf + 0.18u)' nrd='0.18u / W' nrs='0.18u / W' sa=0 sb=0 sd=0 m=1 par=1
XMP2 pbc pbc VDD VDD pfet_03v3 L=2u W=8u nf=1 ad='int((nf+1)/2) * W/nf * 0.18u' as='int((nf+2)/2) * W/nf * 0.18u' pd='2*int((nf+1)/2) * (W/nf + 0.18u)'
+ ps='2*int((nf+2)/2) * (W/nf + 0.18u)' nrd='0.18u / W' nrs='0.18u / W' sa=0 sb=0 sd=0 m=1 par=1
XMSP st VSS VDD VDD pfet_03v3 L=20u W=1u nf=1 ad='int((nf+1)/2) * W/nf * 0.18u' as='int((nf+2)/2) * W/nf * 0.18u' pd='2*int((nf+1)/2) * (W/nf + 0.18u)'
+ ps='2*int((nf+2)/2) * (W/nf + 0.18u)' nrd='0.18u / W' nrs='0.18u / W' sa=0 sb=0 sd=0 m=1 par=1
XMSN st nbc VSS VSS nfet_03v3 L=1u W=2u nf=1 ad='int((nf+1)/2) * W/nf * 0.18u' as='int((nf+2)/2) * W/nf * 0.18u' pd='2*int((nf+1)/2) * (W/nf + 0.18u)'
+ ps='2*int((nf+2)/2) * (W/nf + 0.18u)' nrd='0.18u / W' nrs='0.18u / W' sa=0 sb=0 sd=0 m=1 par=1
XMSU pbc st VSS VSS nfet_03v3 L=1u W=1u nf=1 ad='int((nf+1)/2) * W/nf * 0.18u' as='int((nf+2)/2) * W/nf * 0.18u' pd='2*int((nf+1)/2) * (W/nf + 0.18u)'
+ ps='2*int((nf+2)/2) * (W/nf + 0.18u)' nrd='0.18u / W' nrs='0.18u / W' sa=0 sb=0 sd=0 m=1 par=1
XMP3 NB pbc VDD VDD pfet_03v3 L=2u W=8u nf=1 ad='int((nf+1)/2) * W/nf * 0.18u' as='int((nf+2)/2) * W/nf * 0.18u' pd='2*int((nf+1)/2) * (W/nf + 0.18u)'
+ ps='2*int((nf+2)/2) * (W/nf + 0.18u)' nrd='0.18u / W' nrs='0.18u / W' sa=0 sb=0 sd=0 m=1 par=1
XMN3 NB NB VSS VSS nfet_03v3 L=2u W=16u nf=2 ad='int((nf+1)/2) * W/nf * 0.18u' as='int((nf+2)/2) * W/nf * 0.18u' pd='2*int((nf+1)/2) * (W/nf + 0.18u)'
+ ps='2*int((nf+2)/2) * (W/nf + 0.18u)' nrd='0.18u / W' nrs='0.18u / W' sa=0 sb=0 sd=0 m=1 par=1
XMN4 PB nbc VSS VSS nfet_03v3 L=2u W=4u nf=1 ad='int((nf+1)/2) * W/nf * 0.18u' as='int((nf+2)/2) * W/nf * 0.18u' pd='2*int((nf+1)/2) * (W/nf + 0.18u)'
+ ps='2*int((nf+2)/2) * (W/nf + 0.18u)' nrd='0.18u / W' nrs='0.18u / W' sa=0 sb=0 sd=0 m=1 par=1
XMP4 PB PB VDD VDD pfet_03v3 L=2u W=32u nf=4 ad='int((nf+1)/2) * W/nf * 0.18u' as='int((nf+2)/2) * W/nf * 0.18u' pd='2*int((nf+1)/2) * (W/nf + 0.18u)'
+ ps='2*int((nf+2)/2) * (W/nf + 0.18u)' nrd='0.18u / W' nrs='0.18u / W' sa=0 sb=0 sd=0 m=1 par=1
XCNB NB VSS cap_mim_2f0_m4m5_noshield c_width=20e-6 c_length=20e-6
XCPB VDD PB cap_mim_2f0_m4m5_noshield c_width=20e-6 c_length=20e-6
.ends

* expanding   symbol:  lna_nc.sym # of pins=6
** sym_path: /home/noritsuna/GPS/xschem/lna_nc.sym
** sch_path: /home/noritsuna/GPS/xschem/lna_nc.sch

* expanding   symbol:  mixer_iq.sym # of pins=17
** sym_path: /home/noritsuna/GPS/xschem/mixer_iq.sym
** sch_path: /home/noritsuna/GPS/xschem/mixer_iq.sch
.subckt mixer_iq RFP RFN L1P L1N L2P L2N L3P L3N L4P L4N NB IFIP IFIN IFQP IFQN VDD VSS
*.ipin RFP
*.ipin RFN
*.ipin L1P
*.ipin L1N
*.ipin L2P
*.ipin L2N
*.ipin L3P
*.ipin L3N
*.ipin L4P
*.ipin L4N
*.ipin NB
*.opin IFIP
*.opin IFIN
*.opin IFQP
*.opin IFQN
*.iopin VDD
*.iopin VSS
XRT1 vbrf RFP VSS ppolyf_u_1k r_width=1u r_length=5u
XRT2 vbrf RFN VSS ppolyf_u_1k r_width=1u r_length=5u
XRBA vbrf VDD VSS ppolyf_u_1k r_width=1u r_length=20u
XRBB VSS vbrf VSS ppolyf_u_1k r_width=1u r_length=13u
XCBRF vbrf VSS cap_mim_2f0_m4m5_noshield c_width=70e-6 c_length=70e-6
XRLUA vlou VDD VSS ppolyf_u_1k r_width=1u r_length=47u
XRLUB VSS vlou VSS ppolyf_u_1k r_width=1u r_length=56u
XCLOU vlou VSS cap_mim_2f0_m4m5_noshield c_width=50e-6 c_length=50e-6
XRLLA vlol VDD VSS ppolyf_u_1k r_width=1u r_length=65u
XRLLB VSS vlol VSS ppolyf_u_1k r_width=1u r_length=37u
XCLOL vlol VSS cap_mim_2f0_m4m5_noshield c_width=50e-6 c_length=50e-6
XCACL1P L1P gl1p cap_mim_2f0_m4m5_noshield c_width=31.6e-6 c_length=31.6e-6
XRACL1P vlou gl1p VSS ppolyf_u_1k r_width=1u r_length=20u
XCACL1N L1N gl1n cap_mim_2f0_m4m5_noshield c_width=31.6e-6 c_length=31.6e-6
XRACL1N vlou gl1n VSS ppolyf_u_1k r_width=1u r_length=20u
XCACL2P L2P gl2p cap_mim_2f0_m4m5_noshield c_width=31.6e-6 c_length=31.6e-6
XRACL2P vlou gl2p VSS ppolyf_u_1k r_width=1u r_length=20u
XCACL2N L2N gl2n cap_mim_2f0_m4m5_noshield c_width=31.6e-6 c_length=31.6e-6
XRACL2N vlou gl2n VSS ppolyf_u_1k r_width=1u r_length=20u
XCACL3P L3P gl3p cap_mim_2f0_m4m5_noshield c_width=31.6e-6 c_length=31.6e-6
XRACL3P vlol gl3p VSS ppolyf_u_1k r_width=1u r_length=20u
XCACL3N L3N gl3n cap_mim_2f0_m4m5_noshield c_width=31.6e-6 c_length=31.6e-6
XRACL3N vlol gl3n VSS ppolyf_u_1k r_width=1u r_length=20u
XCACL4P L4P gl4p cap_mim_2f0_m4m5_noshield c_width=31.6e-6 c_length=31.6e-6
XRACL4P vlol gl4p VSS ppolyf_u_1k r_width=1u r_length=20u
XCACL4N L4N gl4n cap_mim_2f0_m4m5_noshield c_width=31.6e-6 c_length=31.6e-6
XRACL4N vlol gl4n VSS ppolyf_u_1k r_width=1u r_length=20u
XMCTL1P VSS gl1p VSS VSS nfet_03v3 L=2u W=4.96u nf=1 ad='int((nf+1)/2) * W/nf * 0.18u' as='int((nf+2)/2) * W/nf * 0.18u' pd='2*int((nf+1)/2) * (W/nf + 0.18u)'
+ ps='2*int((nf+2)/2) * (W/nf + 0.18u)' nrd='0.18u / W' nrs='0.18u / W' sa=0 sb=0 sd=0 m=1 par=1
XMCTL1N VSS gl1n VSS VSS nfet_03v3 L=2u W=6.08u nf=1 ad='int((nf+1)/2) * W/nf * 0.18u' as='int((nf+2)/2) * W/nf * 0.18u' pd='2*int((nf+1)/2) * (W/nf + 0.18u)'
+ ps='2*int((nf+2)/2) * (W/nf + 0.18u)' nrd='0.18u / W' nrs='0.18u / W' sa=0 sb=0 sd=0 m=1 par=1
XMCTL2P VSS gl2p VSS VSS nfet_03v3 L=2u W=3.97u nf=1 ad='int((nf+1)/2) * W/nf * 0.18u' as='int((nf+2)/2) * W/nf * 0.18u' pd='2*int((nf+1)/2) * (W/nf + 0.18u)'
+ ps='2*int((nf+2)/2) * (W/nf + 0.18u)' nrd='0.18u / W' nrs='0.18u / W' sa=0 sb=0 sd=0 m=1 par=1
XMCTL2N VSS gl2n VSS VSS nfet_03v3 L=2u W=4.25u nf=1 ad='int((nf+1)/2) * W/nf * 0.18u' as='int((nf+2)/2) * W/nf * 0.18u' pd='2*int((nf+1)/2) * (W/nf + 0.18u)'
+ ps='2*int((nf+2)/2) * (W/nf + 0.18u)' nrd='0.18u / W' nrs='0.18u / W' sa=0 sb=0 sd=0 m=1 par=1
XMCTL3P VSS gl3p VSS VSS nfet_03v3 L=2u W=0.83u nf=1 ad='int((nf+1)/2) * W/nf * 0.18u' as='int((nf+2)/2) * W/nf * 0.18u' pd='2*int((nf+1)/2) * (W/nf + 0.18u)'
+ ps='2*int((nf+2)/2) * (W/nf + 0.18u)' nrd='0.18u / W' nrs='0.18u / W' sa=0 sb=0 sd=0 m=1 par=1
XMCTL3N VSS gl3n VSS VSS nfet_03v3 L=2u W=0.8u nf=1 ad='int((nf+1)/2) * W/nf * 0.18u' as='int((nf+2)/2) * W/nf * 0.18u' pd='2*int((nf+1)/2) * (W/nf + 0.18u)'
+ ps='2*int((nf+2)/2) * (W/nf + 0.18u)' nrd='0.18u / W' nrs='0.18u / W' sa=0 sb=0 sd=0 m=1 par=1
XMCTL4P VSS gl4p VSS VSS nfet_03v3 L=2u W=1.3u nf=1 ad='int((nf+1)/2) * W/nf * 0.18u' as='int((nf+2)/2) * W/nf * 0.18u' pd='2*int((nf+1)/2) * (W/nf + 0.18u)'
+ ps='2*int((nf+2)/2) * (W/nf + 0.18u)' nrd='0.18u / W' nrs='0.18u / W' sa=0 sb=0 sd=0 m=1 par=1
XMCTL4N VSS gl4n VSS VSS nfet_03v3 L=2u W=1.65u nf=1 ad='int((nf+1)/2) * W/nf * 0.18u' as='int((nf+2)/2) * W/nf * 0.18u' pd='2*int((nf+1)/2) * (W/nf + 0.18u)'
+ ps='2*int((nf+2)/2) * (W/nf + 0.18u)' nrd='0.18u / W' nrs='0.18u / W' sa=0 sb=0 sd=0 m=1 par=1
XMTI tI NB VSS VSS nfet_03v3 L=2u W=40u nf=4 ad='int((nf+1)/2) * W/nf * 0.18u' as='int((nf+2)/2) * W/nf * 0.18u' pd='2*int((nf+1)/2) * (W/nf + 0.18u)'
+ ps='2*int((nf+2)/2) * (W/nf + 0.18u)' nrd='0.18u / W' nrs='0.18u / W' sa=0 sb=0 sd=0 m=16 par=16
XMG1I xpI RFP tI VSS nfet_03v3 L=0.28u W=80u nf=16 ad='int((nf+1)/2) * W/nf * 0.18u' as='int((nf+2)/2) * W/nf * 0.18u' pd='2*int((nf+1)/2) * (W/nf + 0.18u)'
+ ps='2*int((nf+2)/2) * (W/nf + 0.18u)' nrd='0.18u / W' nrs='0.18u / W' sa=0 sb=0 sd=0 m=1 par=1
XMG2I xnI RFN tI VSS nfet_03v3 L=0.28u W=80u nf=16 ad='int((nf+1)/2) * W/nf * 0.18u' as='int((nf+2)/2) * W/nf * 0.18u' pd='2*int((nf+1)/2) * (W/nf + 0.18u)'
+ ps='2*int((nf+2)/2) * (W/nf + 0.18u)' nrd='0.18u / W' nrs='0.18u / W' sa=0 sb=0 sd=0 m=1 par=1
XMLApI mpaI gl3n xpI VSS nfet_03v3 L=0.28u W=40u nf=8 ad='int((nf+1)/2) * W/nf * 0.18u' as='int((nf+2)/2) * W/nf * 0.18u' pd='2*int((nf+1)/2) * (W/nf + 0.18u)'
+ ps='2*int((nf+2)/2) * (W/nf + 0.18u)' nrd='0.18u / W' nrs='0.18u / W' sa=0 sb=0 sd=0 m=1 par=1
XMLBpI mpbI gl3p xpI VSS nfet_03v3 L=0.28u W=40u nf=8 ad='int((nf+1)/2) * W/nf * 0.18u' as='int((nf+2)/2) * W/nf * 0.18u' pd='2*int((nf+1)/2) * (W/nf + 0.18u)'
+ ps='2*int((nf+2)/2) * (W/nf + 0.18u)' nrd='0.18u / W' nrs='0.18u / W' sa=0 sb=0 sd=0 m=1 par=1
XMU1pI IFIP gl1p mpaI VSS nfet_03v3 L=0.28u W=20u nf=4 ad='int((nf+1)/2) * W/nf * 0.18u' as='int((nf+2)/2) * W/nf * 0.18u' pd='2*int((nf+1)/2) * (W/nf + 0.18u)'
+ ps='2*int((nf+2)/2) * (W/nf + 0.18u)' nrd='0.18u / W' nrs='0.18u / W' sa=0 sb=0 sd=0 m=1 par=1
XMU2pI IFIN gl1n mpaI VSS nfet_03v3 L=0.28u W=20u nf=4 ad='int((nf+1)/2) * W/nf * 0.18u' as='int((nf+2)/2) * W/nf * 0.18u' pd='2*int((nf+1)/2) * (W/nf + 0.18u)'
+ ps='2*int((nf+2)/2) * (W/nf + 0.18u)' nrd='0.18u / W' nrs='0.18u / W' sa=0 sb=0 sd=0 m=1 par=1
XMU3pI IFIN gl1p mpbI VSS nfet_03v3 L=0.28u W=20u nf=4 ad='int((nf+1)/2) * W/nf * 0.18u' as='int((nf+2)/2) * W/nf * 0.18u' pd='2*int((nf+1)/2) * (W/nf + 0.18u)'
+ ps='2*int((nf+2)/2) * (W/nf + 0.18u)' nrd='0.18u / W' nrs='0.18u / W' sa=0 sb=0 sd=0 m=1 par=1
XMU4pI IFIP gl1n mpbI VSS nfet_03v3 L=0.28u W=20u nf=4 ad='int((nf+1)/2) * W/nf * 0.18u' as='int((nf+2)/2) * W/nf * 0.18u' pd='2*int((nf+1)/2) * (W/nf + 0.18u)'
+ ps='2*int((nf+2)/2) * (W/nf + 0.18u)' nrd='0.18u / W' nrs='0.18u / W' sa=0 sb=0 sd=0 m=1 par=1
XMLAnI mnaI gl3n xnI VSS nfet_03v3 L=0.28u W=40u nf=8 ad='int((nf+1)/2) * W/nf * 0.18u' as='int((nf+2)/2) * W/nf * 0.18u' pd='2*int((nf+1)/2) * (W/nf + 0.18u)'
+ ps='2*int((nf+2)/2) * (W/nf + 0.18u)' nrd='0.18u / W' nrs='0.18u / W' sa=0 sb=0 sd=0 m=1 par=1
XMLBnI mnbI gl3p xnI VSS nfet_03v3 L=0.28u W=40u nf=8 ad='int((nf+1)/2) * W/nf * 0.18u' as='int((nf+2)/2) * W/nf * 0.18u' pd='2*int((nf+1)/2) * (W/nf + 0.18u)'
+ ps='2*int((nf+2)/2) * (W/nf + 0.18u)' nrd='0.18u / W' nrs='0.18u / W' sa=0 sb=0 sd=0 m=1 par=1
XMU1nI IFIN gl1p mnaI VSS nfet_03v3 L=0.28u W=20u nf=4 ad='int((nf+1)/2) * W/nf * 0.18u' as='int((nf+2)/2) * W/nf * 0.18u' pd='2*int((nf+1)/2) * (W/nf + 0.18u)'
+ ps='2*int((nf+2)/2) * (W/nf + 0.18u)' nrd='0.18u / W' nrs='0.18u / W' sa=0 sb=0 sd=0 m=1 par=1
XMU2nI IFIP gl1n mnaI VSS nfet_03v3 L=0.28u W=20u nf=4 ad='int((nf+1)/2) * W/nf * 0.18u' as='int((nf+2)/2) * W/nf * 0.18u' pd='2*int((nf+1)/2) * (W/nf + 0.18u)'
+ ps='2*int((nf+2)/2) * (W/nf + 0.18u)' nrd='0.18u / W' nrs='0.18u / W' sa=0 sb=0 sd=0 m=1 par=1
XMU3nI IFIP gl1p mnbI VSS nfet_03v3 L=0.28u W=20u nf=4 ad='int((nf+1)/2) * W/nf * 0.18u' as='int((nf+2)/2) * W/nf * 0.18u' pd='2*int((nf+1)/2) * (W/nf + 0.18u)'
+ ps='2*int((nf+2)/2) * (W/nf + 0.18u)' nrd='0.18u / W' nrs='0.18u / W' sa=0 sb=0 sd=0 m=1 par=1
XMU4nI IFIN gl1n mnbI VSS nfet_03v3 L=0.28u W=20u nf=4 ad='int((nf+1)/2) * W/nf * 0.18u' as='int((nf+2)/2) * W/nf * 0.18u' pd='2*int((nf+1)/2) * (W/nf + 0.18u)'
+ ps='2*int((nf+2)/2) * (W/nf + 0.18u)' nrd='0.18u / W' nrs='0.18u / W' sa=0 sb=0 sd=0 m=1 par=1
XRL1I IFIP VDD VSS ppolyf_u_1k r_width=4u r_length=5u
XRL2I IFIN VDD VSS ppolyf_u_1k r_width=4u r_length=5u
XCL1I IFIP VSS cap_mim_2f0_m4m5_noshield c_width=45e-6 c_length=45e-6
XCL2I IFIN VSS cap_mim_2f0_m4m5_noshield c_width=45e-6 c_length=45e-6
XMTQ tQ NB VSS VSS nfet_03v3 L=2u W=40u nf=4 ad='int((nf+1)/2) * W/nf * 0.18u' as='int((nf+2)/2) * W/nf * 0.18u' pd='2*int((nf+1)/2) * (W/nf + 0.18u)'
+ ps='2*int((nf+2)/2) * (W/nf + 0.18u)' nrd='0.18u / W' nrs='0.18u / W' sa=0 sb=0 sd=0 m=16 par=16
XMG1Q xpQ RFP tQ VSS nfet_03v3 L=0.28u W=80u nf=16 ad='int((nf+1)/2) * W/nf * 0.18u' as='int((nf+2)/2) * W/nf * 0.18u' pd='2*int((nf+1)/2) * (W/nf + 0.18u)'
+ ps='2*int((nf+2)/2) * (W/nf + 0.18u)' nrd='0.18u / W' nrs='0.18u / W' sa=0 sb=0 sd=0 m=1 par=1
XMG2Q xnQ RFN tQ VSS nfet_03v3 L=0.28u W=80u nf=16 ad='int((nf+1)/2) * W/nf * 0.18u' as='int((nf+2)/2) * W/nf * 0.18u' pd='2*int((nf+1)/2) * (W/nf + 0.18u)'
+ ps='2*int((nf+2)/2) * (W/nf + 0.18u)' nrd='0.18u / W' nrs='0.18u / W' sa=0 sb=0 sd=0 m=1 par=1
XMLApQ mpaQ gl4n xpQ VSS nfet_03v3 L=0.28u W=40u nf=8 ad='int((nf+1)/2) * W/nf * 0.18u' as='int((nf+2)/2) * W/nf * 0.18u' pd='2*int((nf+1)/2) * (W/nf + 0.18u)'
+ ps='2*int((nf+2)/2) * (W/nf + 0.18u)' nrd='0.18u / W' nrs='0.18u / W' sa=0 sb=0 sd=0 m=1 par=1
XMLBpQ mpbQ gl4p xpQ VSS nfet_03v3 L=0.28u W=40u nf=8 ad='int((nf+1)/2) * W/nf * 0.18u' as='int((nf+2)/2) * W/nf * 0.18u' pd='2*int((nf+1)/2) * (W/nf + 0.18u)'
+ ps='2*int((nf+2)/2) * (W/nf + 0.18u)' nrd='0.18u / W' nrs='0.18u / W' sa=0 sb=0 sd=0 m=1 par=1
XMU1pQ IFQP gl2p mpaQ VSS nfet_03v3 L=0.28u W=20u nf=4 ad='int((nf+1)/2) * W/nf * 0.18u' as='int((nf+2)/2) * W/nf * 0.18u' pd='2*int((nf+1)/2) * (W/nf + 0.18u)'
+ ps='2*int((nf+2)/2) * (W/nf + 0.18u)' nrd='0.18u / W' nrs='0.18u / W' sa=0 sb=0 sd=0 m=1 par=1
XMU2pQ IFQN gl2n mpaQ VSS nfet_03v3 L=0.28u W=20u nf=4 ad='int((nf+1)/2) * W/nf * 0.18u' as='int((nf+2)/2) * W/nf * 0.18u' pd='2*int((nf+1)/2) * (W/nf + 0.18u)'
+ ps='2*int((nf+2)/2) * (W/nf + 0.18u)' nrd='0.18u / W' nrs='0.18u / W' sa=0 sb=0 sd=0 m=1 par=1
XMU3pQ IFQN gl2p mpbQ VSS nfet_03v3 L=0.28u W=20u nf=4 ad='int((nf+1)/2) * W/nf * 0.18u' as='int((nf+2)/2) * W/nf * 0.18u' pd='2*int((nf+1)/2) * (W/nf + 0.18u)'
+ ps='2*int((nf+2)/2) * (W/nf + 0.18u)' nrd='0.18u / W' nrs='0.18u / W' sa=0 sb=0 sd=0 m=1 par=1
XMU4pQ IFQP gl2n mpbQ VSS nfet_03v3 L=0.28u W=20u nf=4 ad='int((nf+1)/2) * W/nf * 0.18u' as='int((nf+2)/2) * W/nf * 0.18u' pd='2*int((nf+1)/2) * (W/nf + 0.18u)'
+ ps='2*int((nf+2)/2) * (W/nf + 0.18u)' nrd='0.18u / W' nrs='0.18u / W' sa=0 sb=0 sd=0 m=1 par=1
XMLAnQ mnaQ gl4n xnQ VSS nfet_03v3 L=0.28u W=40u nf=8 ad='int((nf+1)/2) * W/nf * 0.18u' as='int((nf+2)/2) * W/nf * 0.18u' pd='2*int((nf+1)/2) * (W/nf + 0.18u)'
+ ps='2*int((nf+2)/2) * (W/nf + 0.18u)' nrd='0.18u / W' nrs='0.18u / W' sa=0 sb=0 sd=0 m=1 par=1
XMLBnQ mnbQ gl4p xnQ VSS nfet_03v3 L=0.28u W=40u nf=8 ad='int((nf+1)/2) * W/nf * 0.18u' as='int((nf+2)/2) * W/nf * 0.18u' pd='2*int((nf+1)/2) * (W/nf + 0.18u)'
+ ps='2*int((nf+2)/2) * (W/nf + 0.18u)' nrd='0.18u / W' nrs='0.18u / W' sa=0 sb=0 sd=0 m=1 par=1
XMU1nQ IFQN gl2p mnaQ VSS nfet_03v3 L=0.28u W=20u nf=4 ad='int((nf+1)/2) * W/nf * 0.18u' as='int((nf+2)/2) * W/nf * 0.18u' pd='2*int((nf+1)/2) * (W/nf + 0.18u)'
+ ps='2*int((nf+2)/2) * (W/nf + 0.18u)' nrd='0.18u / W' nrs='0.18u / W' sa=0 sb=0 sd=0 m=1 par=1
XMU2nQ IFQP gl2n mnaQ VSS nfet_03v3 L=0.28u W=20u nf=4 ad='int((nf+1)/2) * W/nf * 0.18u' as='int((nf+2)/2) * W/nf * 0.18u' pd='2*int((nf+1)/2) * (W/nf + 0.18u)'
+ ps='2*int((nf+2)/2) * (W/nf + 0.18u)' nrd='0.18u / W' nrs='0.18u / W' sa=0 sb=0 sd=0 m=1 par=1
XMU3nQ IFQP gl2p mnbQ VSS nfet_03v3 L=0.28u W=20u nf=4 ad='int((nf+1)/2) * W/nf * 0.18u' as='int((nf+2)/2) * W/nf * 0.18u' pd='2*int((nf+1)/2) * (W/nf + 0.18u)'
+ ps='2*int((nf+2)/2) * (W/nf + 0.18u)' nrd='0.18u / W' nrs='0.18u / W' sa=0 sb=0 sd=0 m=1 par=1
XMU4nQ IFQN gl2n mnbQ VSS nfet_03v3 L=0.28u W=20u nf=4 ad='int((nf+1)/2) * W/nf * 0.18u' as='int((nf+2)/2) * W/nf * 0.18u' pd='2*int((nf+1)/2) * (W/nf + 0.18u)'
+ ps='2*int((nf+2)/2) * (W/nf + 0.18u)' nrd='0.18u / W' nrs='0.18u / W' sa=0 sb=0 sd=0 m=1 par=1
XRL1Q IFQP VDD VSS ppolyf_u_1k r_width=4u r_length=5u
XRL2Q IFQN VDD VSS ppolyf_u_1k r_width=4u r_length=5u
XCL1Q IFQP VSS cap_mim_2f0_m4m5_noshield c_width=45e-6 c_length=45e-6
XCL2Q IFQN VSS cap_mim_2f0_m4m5_noshield c_width=45e-6 c_length=45e-6
.ends
* NGSPICE file created from lna_nc_flat.ext - technology: gf180mcuD

.subckt lna_nc_flat VSS VDD RFIN PB OUTP OUTN
X0 a_7845_15740.t2 OUTN cap_mim_2f0_m4m5_noshield c_width=5u c_length=5u
X1 a_7845_15740.t2 OUTN cap_mim_2f0_m4m5_noshield c_width=5u c_length=5u
X2 a_1825_15740# OUTP cap_mim_2f0_m4m5_noshield c_width=5u c_length=5u
X3 a_1825_15740# OUTP cap_mim_2f0_m4m5_noshield c_width=5u c_length=5u
X4 RFIN a_7040_32046# cap_mim_2f0_m4m5_noshield c_width=5u c_length=5u
X5 VSS a_7040_32046# a_7845_15740.t0 VSS nfet_03v3 ad=1.325p pd=5.53u as=1.325p ps=5.53u w=5u l=0.28u
X6 VSS a_7040_32046# a_7845_15740.t0 VSS nfet_03v3 ad=1.325p pd=5.53u as=1.325p ps=5.53u w=5u l=0.28u
X7 a_1825_15740# OUTP cap_mim_2f0_m4m5_noshield c_width=5u c_length=5u
X8 VSS a_7040_32046# a_7845_15740.t0 VSS nfet_03v3 ad=1.325p pd=5.53u as=1.325p ps=5.53u w=5u l=0.28u
X9 a_1825_15740# OUTP cap_mim_2f0_m4m5_noshield c_width=5u c_length=5u
X10 a_1825_15740# OUTP cap_mim_2f0_m4m5_noshield c_width=5u c_length=5u
X11 a_7845_15740.t0 a_7040_32046# VSS VSS nfet_03v3 ad=1.325p pd=5.53u as=1.325p ps=5.53u w=5u l=0.28u
X12 RFIN a_7040_32046# cap_mim_2f0_m4m5_noshield c_width=5u c_length=5u
X13 a_7845_15740.t2 OUTN cap_mim_2f0_m4m5_noshield c_width=5u c_length=5u
X14 a_1825_15740# OUTP cap_mim_2f0_m4m5_noshield c_width=5u c_length=5u
X15 a_7460_30646# VSS VSS ppolyf_u_1k r_width=1u r_length=3u
X16 a_7845_15740.t2 OUTN cap_mim_2f0_m4m5_noshield c_width=5u c_length=5u
X17 VSS a_7040_32046# a_7845_15740.t0 VSS nfet_03v3 ad=1.325p pd=5.53u as=1.325p ps=5.53u w=5u l=0.28u
X18 a_1825_15740# OUTP cap_mim_2f0_m4m5_noshield c_width=5u c_length=5u
X19 VSS a_7040_32046# a_7845_15740.t0 VSS nfet_03v3 ad=1.325p pd=5.53u as=1.325p ps=5.53u w=5u l=0.28u
X20 RFIN a_7040_32046# cap_mim_2f0_m4m5_noshield c_width=5u c_length=5u
X21 VSS a_7040_32046# a_7845_15740.t0 VSS nfet_03v3 ad=1.325p pd=5.53u as=1.325p ps=5.53u w=5u l=0.28u
X22 RFIN a_7040_32046# cap_mim_2f0_m4m5_noshield c_width=5u c_length=5u
X23 a_7040_29924.t8 VSS cap_mim_2f0_m4m5_noshield c_width=50u c_length=50u
X24 VSS a_7040_32046# a_7845_15740.t0 VSS nfet_03v3 ad=1.325p pd=5.53u as=1.325p ps=5.53u w=5u l=0.28u
X25 a_7845_15740.t2 OUTN cap_mim_2f0_m4m5_noshield c_width=5u c_length=5u
X26 a_1825_15740# OUTP cap_mim_2f0_m4m5_noshield c_width=5u c_length=5u
X27 RFIN a_7040_32046# cap_mim_2f0_m4m5_noshield c_width=5u c_length=5u
X28 a_7845_15740.t0 a_7040_32046# VSS VSS nfet_03v3 ad=1.325p pd=5.53u as=1.325p ps=5.53u w=5u l=0.28u
X29 VDD PB.t16 a_1749_16889.t1 VDD pfet_03v3 ad=2.12p pd=8.53u as=2.12p ps=8.53u w=8u l=2u
X30 a_7845_15740.t2 OUTN cap_mim_2f0_m4m5_noshield c_width=5u c_length=5u
X31 a_1749_16889.t1 PB.t21 VDD VDD pfet_03v3 ad=2.12p pd=8.53u as=3.56p ps=16.89u w=8u l=2u
X32 VSS a_7040_32046# a_7845_15740.t0 VSS nfet_03v3 ad=1.325p pd=5.53u as=1.325p ps=5.53u w=5u l=0.28u
X33 VSS a_7040_32046# a_7845_15740.t0 VSS nfet_03v3 ad=1.325p pd=5.53u as=1.325p ps=5.53u w=5u l=0.28u
X34 RFIN a_7040_32046# cap_mim_2f0_m4m5_noshield c_width=5u c_length=5u
X35 a_7845_15740.t2 OUTN cap_mim_2f0_m4m5_noshield c_width=5u c_length=5u
X36 RFIN a_7040_32046# cap_mim_2f0_m4m5_noshield c_width=5u c_length=5u
X37 a_7845_15740.t2 OUTN cap_mim_2f0_m4m5_noshield c_width=5u c_length=5u
X38 a_7845_15740.t0 a_7040_32046# VSS VSS nfet_03v3 ad=1.325p pd=5.53u as=1.325p ps=5.53u w=5u l=0.28u
X39 VSS a_7040_32046# a_7845_15740.t0 VSS nfet_03v3 ad=1.325p pd=5.53u as=1.325p ps=5.53u w=5u l=0.28u
X40 a_7845_15740.t0 a_7040_32046# VSS VSS nfet_03v3 ad=1.325p pd=5.53u as=2.225p ps=10.89u w=5u l=0.28u
X41 a_7845_15740.t0 a_7040_32046# VSS VSS nfet_03v3 ad=1.325p pd=5.53u as=1.325p ps=5.53u w=5u l=0.28u
X42 a_1749_16889.t0 PB.t23 VDD VDD pfet_03v3 ad=2.12p pd=8.53u as=2.12p ps=8.53u w=8u l=2u
X43 a_7845_15740.t2 OUTN cap_mim_2f0_m4m5_noshield c_width=5u c_length=5u
X44 VDD PB.t28 a_7040_29924.t0 VDD pfet_03v3 ad=2.12p pd=8.53u as=2.12p ps=8.53u w=8u l=2u
X45 RFIN a_7040_32046# cap_mim_2f0_m4m5_noshield c_width=5u c_length=5u
X46 RFIN a_7040_32046# cap_mim_2f0_m4m5_noshield c_width=5u c_length=5u
X47 a_7845_15740.t0 a_7040_32046# VSS VSS nfet_03v3 ad=1.325p pd=5.53u as=1.325p ps=5.53u w=5u l=0.28u
X48 VDD PB.t40 a_7040_29924.t0 VDD pfet_03v3 ad=2.12p pd=8.53u as=2.12p ps=8.53u w=8u l=2u
X49 VSS a_7040_32046# a_7845_15740.t0 VSS nfet_03v3 ad=1.325p pd=5.53u as=1.325p ps=5.53u w=5u l=0.28u
X50 a_1825_15740# OUTP cap_mim_2f0_m4m5_noshield c_width=5u c_length=5u
X51 a_1749_16889.t2 PB.t13 VDD VDD pfet_03v3 ad=2.12p pd=8.53u as=2.12p ps=8.53u w=8u l=2u
X52 RFIN a_7040_32046# cap_mim_2f0_m4m5_noshield c_width=5u c_length=5u
X53 a_1825_15740# OUTP cap_mim_2f0_m4m5_noshield c_width=5u c_length=5u
X54 a_7845_15740.t0 a_7040_32046# VSS VSS nfet_03v3 ad=1.325p pd=5.53u as=1.325p ps=5.53u w=5u l=0.28u
X55 a_7845_15740.t2 OUTN cap_mim_2f0_m4m5_noshield c_width=5u c_length=5u
X56 a_7845_15740.t2 OUTN cap_mim_2f0_m4m5_noshield c_width=5u c_length=5u
X57 a_7845_15740.t0 a_7040_32046# VSS VSS nfet_03v3 ad=1.325p pd=5.53u as=1.325p ps=5.53u w=5u l=0.28u
X58 a_7845_15740.t0 a_7040_32046# VSS VSS nfet_03v3 ad=1.325p pd=5.53u as=2.225p ps=10.89u w=5u l=0.28u
X59 a_7845_15740.t2 OUTN cap_mim_2f0_m4m5_noshield c_width=5u c_length=5u
X60 a_1825_15740# OUTP cap_mim_2f0_m4m5_noshield c_width=5u c_length=5u
X61 VSS a_7040_32046# a_7845_15740.t0 VSS nfet_03v3 ad=1.325p pd=5.53u as=1.325p ps=5.53u w=5u l=0.28u
X62 a_1749_16889.t2 PB.t9 VDD VDD pfet_03v3 ad=2.12p pd=8.53u as=2.12p ps=8.53u w=8u l=2u
X63 RFIN a_7040_32046# cap_mim_2f0_m4m5_noshield c_width=5u c_length=5u
X64 a_7845_15740.t0 a_7040_32046# VSS VSS nfet_03v3 ad=1.325p pd=5.53u as=1.325p ps=5.53u w=5u l=0.28u
X65 a_7845_15740.t2 OUTN cap_mim_2f0_m4m5_noshield c_width=5u c_length=5u
X66 a_1825_15740# OUTP cap_mim_2f0_m4m5_noshield c_width=5u c_length=5u
X67 a_7845_15740.t0 a_7040_32046# VSS VSS nfet_03v3 ad=1.325p pd=5.53u as=1.325p ps=5.53u w=5u l=0.28u
X68 a_7845_15740.t2 OUTN cap_mim_2f0_m4m5_noshield c_width=5u c_length=5u
X69 a_7845_15740.t2 OUTN cap_mim_2f0_m4m5_noshield c_width=5u c_length=5u
X70 a_7845_15740.t0 a_7040_32046# VSS VSS nfet_03v3 ad=1.325p pd=5.53u as=1.325p ps=5.53u w=5u l=0.28u
X71 RFIN a_7040_32046# cap_mim_2f0_m4m5_noshield c_width=5u c_length=5u
X72 a_1825_15740# OUTP cap_mim_2f0_m4m5_noshield c_width=5u c_length=5u
X73 RFIN a_7040_32046# cap_mim_2f0_m4m5_noshield c_width=5u c_length=5u
X74 VSS a_7040_32046# a_7845_15740.t0 VSS nfet_03v3 ad=1.325p pd=5.53u as=1.325p ps=5.53u w=5u l=0.28u
X75 a_7845_15740.t0 a_7040_32046# VSS VSS nfet_03v3 ad=1.325p pd=5.53u as=1.325p ps=5.53u w=5u l=0.28u
X76 a_7460_30646# a_1749_16889.t5 a_1749_16889.t6 VSS nfet_03v3 ad=2.67p pd=12.89u as=1.59p ps=6.53u w=6u l=0.28u
X77 a_1825_15740# OUTP cap_mim_2f0_m4m5_noshield c_width=5u c_length=5u
X78 a_7845_15740.t2 OUTN cap_mim_2f0_m4m5_noshield c_width=5u c_length=5u
X79 VSS a_7040_32046# a_7845_15740.t1 VSS nfet_03v3 ad=2.225p pd=10.89u as=1.325p ps=5.53u w=5u l=0.28u
X80 VSS a_7040_32046# a_7845_15740.t0 VSS nfet_03v3 ad=1.325p pd=5.53u as=1.325p ps=5.53u w=5u l=0.28u
X81 a_1825_15740# OUTP cap_mim_2f0_m4m5_noshield c_width=5u c_length=5u
X82 a_7845_15740.t2 OUTN cap_mim_2f0_m4m5_noshield c_width=5u c_length=5u
X83 a_7845_15740.t0 a_7040_32046# VSS VSS nfet_03v3 ad=1.325p pd=5.53u as=1.325p ps=5.53u w=5u l=0.28u
X84 RFIN a_7040_32046# cap_mim_2f0_m4m5_noshield c_width=5u c_length=5u
X85 a_7845_15740.t0 a_7040_32046# VSS VSS nfet_03v3 ad=1.325p pd=5.53u as=1.325p ps=5.53u w=5u l=0.28u
X86 RFIN a_7040_32046# cap_mim_2f0_m4m5_noshield c_width=5u c_length=5u
X87 a_7845_15740.t0 a_7040_32046# VSS VSS nfet_03v3 ad=1.325p pd=5.53u as=1.325p ps=5.53u w=5u l=0.28u
X88 a_7845_15740.t0 a_7040_32046# VSS VSS nfet_03v3 ad=1.325p pd=5.53u as=1.325p ps=5.53u w=5u l=0.28u
X89 a_1825_15740# OUTP cap_mim_2f0_m4m5_noshield c_width=5u c_length=5u
X90 a_1825_15740# OUTP cap_mim_2f0_m4m5_noshield c_width=5u c_length=5u
X91 a_7845_15740.t2 OUTN cap_mim_2f0_m4m5_noshield c_width=5u c_length=5u
X92 RFIN a_7040_32046# cap_mim_2f0_m4m5_noshield c_width=5u c_length=5u
X93 VSS a_7040_32046# a_7845_15740.t0 VSS nfet_03v3 ad=1.325p pd=5.53u as=1.325p ps=5.53u w=5u l=0.28u
X94 VSS a_7040_32046# a_7845_15740.t0 VSS nfet_03v3 ad=1.325p pd=5.53u as=1.325p ps=5.53u w=5u l=0.28u
X95 RFIN a_7040_32046# cap_mim_2f0_m4m5_noshield c_width=5u c_length=5u
X96 a_7845_15740.t2 OUTN cap_mim_2f0_m4m5_noshield c_width=5u c_length=5u
X97 VSS a_7040_32046# a_7845_15740.t0 VSS nfet_03v3 ad=2.225p pd=10.89u as=1.325p ps=5.53u w=5u l=0.28u
X98 a_7845_15740.t0 a_7040_32046# VSS VSS nfet_03v3 ad=1.325p pd=5.53u as=1.325p ps=5.53u w=5u l=0.28u
X99 a_7845_15740.t2 OUTN cap_mim_2f0_m4m5_noshield c_width=5u c_length=5u
X100 a_1825_15740# OUTP cap_mim_2f0_m4m5_noshield c_width=5u c_length=5u
X101 a_1825_15740# OUTP cap_mim_2f0_m4m5_noshield c_width=5u c_length=5u
X102 a_1825_15740# OUTP cap_mim_2f0_m4m5_noshield c_width=5u c_length=5u
X103 a_1749_16889.t6 a_1749_16889.t5 a_7460_30646# VSS nfet_03v3 ad=1.59p pd=6.53u as=2.67p ps=12.89u w=6u l=0.28u
X104 RFIN a_7040_32046# cap_mim_2f0_m4m5_noshield c_width=5u c_length=5u
X105 a_7845_15740.t0 a_7040_32046# VSS VSS nfet_03v3 ad=1.325p pd=5.53u as=1.325p ps=5.53u w=5u l=0.28u
X106 a_7845_15740.t1 a_7040_32046# VSS VSS nfet_03v3 ad=1.325p pd=5.53u as=1.325p ps=5.53u w=5u l=0.28u
X107 RFIN a_7040_32046# cap_mim_2f0_m4m5_noshield c_width=5u c_length=5u
X108 RFIN a_7040_32046# cap_mim_2f0_m4m5_noshield c_width=5u c_length=5u
X109 a_7845_15740.t2 OUTN cap_mim_2f0_m4m5_noshield c_width=5u c_length=5u
X110 a_1825_15740# OUTP cap_mim_2f0_m4m5_noshield c_width=5u c_length=5u
X111 VDD PB.t38 a_1749_16889.t0 VDD pfet_03v3 ad=2.12p pd=8.53u as=2.12p ps=8.53u w=8u l=2u
X112 VSS a_7040_29924.t4 a_7040_29924.t5 VSS nfet_03v3 ad=1.78p pd=8.89u as=1.06p ps=4.53u w=4u l=0.28u
X113 a_1749_16889.t0 PB.t43 VDD VDD pfet_03v3 ad=2.12p pd=8.53u as=3.56p ps=16.89u w=8u l=2u
X114 RFIN a_7040_32046# cap_mim_2f0_m4m5_noshield c_width=5u c_length=5u
X115 a_7845_15740.t2 OUTN cap_mim_2f0_m4m5_noshield c_width=5u c_length=5u
X116 a_1825_15740# OUTP cap_mim_2f0_m4m5_noshield c_width=5u c_length=5u
X117 VSS a_7040_32046# a_7845_15740.t0 VSS nfet_03v3 ad=1.325p pd=5.53u as=1.325p ps=5.53u w=5u l=0.28u
X118 a_7040_29924.t1 PB.t11 VDD VDD pfet_03v3 ad=2.12p pd=8.53u as=2.12p ps=8.53u w=8u l=2u
X119 a_7845_15740.t2 OUTN cap_mim_2f0_m4m5_noshield c_width=5u c_length=5u
X120 a_7845_15740.t2 OUTN cap_mim_2f0_m4m5_noshield c_width=5u c_length=5u
X121 RFIN a_7040_32046# cap_mim_2f0_m4m5_noshield c_width=5u c_length=5u
X122 a_1825_15740# OUTP cap_mim_2f0_m4m5_noshield c_width=5u c_length=5u
X123 a_7845_15740.t0 a_7040_32046# VSS VSS nfet_03v3 ad=1.325p pd=5.53u as=1.325p ps=5.53u w=5u l=0.28u
X124 a_1825_15740# OUTP cap_mim_2f0_m4m5_noshield c_width=5u c_length=5u
X125 a_1825_15740# OUTP cap_mim_2f0_m4m5_noshield c_width=5u c_length=5u
X126 a_1825_15740# OUTP cap_mim_2f0_m4m5_noshield c_width=5u c_length=5u
X127 VDD PB.t2 a_7040_29924.t3 VDD pfet_03v3 ad=2.12p pd=8.53u as=2.12p ps=8.53u w=8u l=2u
X128 VSS a_7040_32046# a_7845_15740.t0 VSS nfet_03v3 ad=1.325p pd=5.53u as=1.325p ps=5.53u w=5u l=0.28u
X129 a_7040_29924.t2 PB.t7 VDD VDD pfet_03v3 ad=2.12p pd=8.53u as=2.12p ps=8.53u w=8u l=2u
X130 RFIN a_7040_32046# cap_mim_2f0_m4m5_noshield c_width=5u c_length=5u
X131 a_7845_15740.t0 a_7040_32046# VSS VSS nfet_03v3 ad=1.325p pd=5.53u as=1.325p ps=5.53u w=5u l=0.28u
X132 RFIN a_7040_32046# cap_mim_2f0_m4m5_noshield c_width=5u c_length=5u
X133 a_1825_15740# OUTP cap_mim_2f0_m4m5_noshield c_width=5u c_length=5u
X134 a_7040_29924.t1 PB.t19 VDD VDD pfet_03v3 ad=2.12p pd=8.53u as=2.12p ps=8.53u w=8u l=2u
X135 a_7845_15740.t2 OUTN cap_mim_2f0_m4m5_noshield c_width=5u c_length=5u
X136 RFIN a_7040_32046# cap_mim_2f0_m4m5_noshield c_width=5u c_length=5u
X137 a_1825_15740# OUTP cap_mim_2f0_m4m5_noshield c_width=5u c_length=5u
X138 a_7845_15740.t0 a_7040_32046# VSS VSS nfet_03v3 ad=1.325p pd=5.53u as=1.325p ps=5.53u w=5u l=0.28u
X139 a_7845_15740.t2 OUTN cap_mim_2f0_m4m5_noshield c_width=5u c_length=5u
X140 a_1825_15740# OUTP cap_mim_2f0_m4m5_noshield c_width=5u c_length=5u
X141 RFIN a_7040_32046# cap_mim_2f0_m4m5_noshield c_width=5u c_length=5u
X142 a_7845_15740.t0 a_7040_32046# VSS VSS nfet_03v3 ad=1.325p pd=5.53u as=1.325p ps=5.53u w=5u l=0.28u
X143 RFIN a_7040_32046# cap_mim_2f0_m4m5_noshield c_width=5u c_length=5u
X144 a_7040_29924.t5 a_7040_29924.t4 VSS VSS nfet_03v3 ad=1.06p pd=4.53u as=1.78p ps=8.89u w=4u l=0.28u
X145 a_7845_15740.t2 OUTN cap_mim_2f0_m4m5_noshield c_width=5u c_length=5u
X146 a_1749_16889.t0 PB.t35 VDD VDD pfet_03v3 ad=2.12p pd=8.53u as=2.12p ps=8.53u w=8u l=2u
X147 VSS a_7040_32046# a_7845_15740.t0 VSS nfet_03v3 ad=1.325p pd=5.53u as=1.325p ps=5.53u w=5u l=0.28u
X148 RFIN a_1749_16889.t11 a_1825_15740# VSS nfet_03v3 ad=1.325p pd=5.53u as=1.325p ps=5.53u w=5u l=0.28u
X149 VSS a_7040_32046# a_7845_15740.t0 VSS nfet_03v3 ad=1.325p pd=5.53u as=1.325p ps=5.53u w=5u l=0.28u
X150 RFIN a_7040_32046# cap_mim_2f0_m4m5_noshield c_width=5u c_length=5u
X151 a_1749_16889.t0 PB.t31 VDD VDD pfet_03v3 ad=2.12p pd=8.53u as=2.12p ps=8.53u w=8u l=2u
X152 a_7845_15740.t0 a_7040_32046# VSS VSS nfet_03v3 ad=1.325p pd=5.53u as=1.325p ps=5.53u w=5u l=0.28u
X153 a_7845_15740.t2 OUTN cap_mim_2f0_m4m5_noshield c_width=5u c_length=5u
X154 a_1825_15740# OUTP cap_mim_2f0_m4m5_noshield c_width=5u c_length=5u
X155 a_7845_15740.t2 OUTN cap_mim_2f0_m4m5_noshield c_width=5u c_length=5u
X156 RFIN a_7040_32046# cap_mim_2f0_m4m5_noshield c_width=5u c_length=5u
X157 RFIN a_7040_32046# cap_mim_2f0_m4m5_noshield c_width=5u c_length=5u
X158 a_7845_15740.t2 OUTN cap_mim_2f0_m4m5_noshield c_width=5u c_length=5u
X159 a_7845_15740.t0 a_7040_32046# VSS VSS nfet_03v3 ad=1.325p pd=5.53u as=1.325p ps=5.53u w=5u l=0.28u
X160 a_7845_15740.t2 OUTN cap_mim_2f0_m4m5_noshield c_width=5u c_length=5u
X161 VSS a_7040_32046# a_7845_15740.t0 VSS nfet_03v3 ad=1.325p pd=5.53u as=1.325p ps=5.53u w=5u l=0.28u
X162 RFIN a_1749_16889.t9 a_1825_15740# VSS nfet_03v3 ad=2.225p pd=10.89u as=1.325p ps=5.53u w=5u l=0.28u
X163 a_1825_15740# OUTP cap_mim_2f0_m4m5_noshield c_width=5u c_length=5u
X164 RFIN a_7040_32046# cap_mim_2f0_m4m5_noshield c_width=5u c_length=5u
X165 a_7845_15740.t2 OUTN cap_mim_2f0_m4m5_noshield c_width=5u c_length=5u
X166 a_1825_15740# OUTP cap_mim_2f0_m4m5_noshield c_width=5u c_length=5u
X167 VDD PB.t14 a_7040_29924.t1 VDD pfet_03v3 ad=2.12p pd=8.53u as=2.12p ps=8.53u w=8u l=2u
X168 a_7845_15740.t2 OUTN cap_mim_2f0_m4m5_noshield c_width=5u c_length=5u
X169 VSS a_7040_32046# a_7845_15740.t0 VSS nfet_03v3 ad=1.325p pd=5.53u as=1.325p ps=5.53u w=5u l=0.28u
X170 a_1825_15740# OUTP cap_mim_2f0_m4m5_noshield c_width=5u c_length=5u
X171 RFIN a_7040_32046# cap_mim_2f0_m4m5_noshield c_width=5u c_length=5u
X172 RFIN a_7040_32046# cap_mim_2f0_m4m5_noshield c_width=5u c_length=5u
X173 RFIN a_7040_32046# cap_mim_2f0_m4m5_noshield c_width=5u c_length=5u
X174 a_1825_15740# a_1749_16889.t30 RFIN VSS nfet_03v3 ad=1.325p pd=5.53u as=1.325p ps=5.53u w=5u l=0.28u
X175 RFIN a_7040_32046# cap_mim_2f0_m4m5_noshield c_width=5u c_length=5u
X176 a_7845_15740.t2 OUTN cap_mim_2f0_m4m5_noshield c_width=5u c_length=5u
X177 a_7845_15740.t0 a_7040_32046# VSS VSS nfet_03v3 ad=1.325p pd=5.53u as=1.325p ps=5.53u w=5u l=0.28u
X178 a_1825_15740# a_1749_16889.t16 RFIN VSS nfet_03v3 ad=1.325p pd=5.53u as=1.325p ps=5.53u w=5u l=0.28u
X179 VDD PB.t0 a_1749_16889.t4 VDD pfet_03v3 ad=3.56p pd=16.89u as=2.12p ps=8.53u w=8u l=2u
X180 a_1749_16889.t3 PB.t5 VDD VDD pfet_03v3 ad=2.12p pd=8.53u as=2.12p ps=8.53u w=8u l=2u
X181 RFIN a_7040_32046# cap_mim_2f0_m4m5_noshield c_width=5u c_length=5u
X182 a_1825_15740# OUTP cap_mim_2f0_m4m5_noshield c_width=5u c_length=5u
X183 VSS a_7040_32046# a_7845_15740.t0 VSS nfet_03v3 ad=1.325p pd=5.53u as=1.325p ps=5.53u w=5u l=0.28u
X184 a_1825_15740# OUTP cap_mim_2f0_m4m5_noshield c_width=5u c_length=5u
X185 a_7845_15740.t2 OUTN cap_mim_2f0_m4m5_noshield c_width=5u c_length=5u
X186 a_7845_15740.t2 OUTN cap_mim_2f0_m4m5_noshield c_width=5u c_length=5u
X187 a_1749_16889.t1 PB.t17 VDD VDD pfet_03v3 ad=2.12p pd=8.53u as=2.12p ps=8.53u w=8u l=2u
X188 RFIN a_7040_32046# cap_mim_2f0_m4m5_noshield c_width=5u c_length=5u
X189 a_7845_15740.t2 OUTN cap_mim_2f0_m4m5_noshield c_width=5u c_length=5u
X190 a_1825_15740# OUTP cap_mim_2f0_m4m5_noshield c_width=5u c_length=5u
X191 RFIN a_7040_32046# cap_mim_2f0_m4m5_noshield c_width=5u c_length=5u
X192 a_7845_15740.t2 OUTN cap_mim_2f0_m4m5_noshield c_width=5u c_length=5u
X193 a_7845_15740.t2 OUTN cap_mim_2f0_m4m5_noshield c_width=5u c_length=5u
X194 VDD PB.t20 a_1749_16889.t1 VDD pfet_03v3 ad=2.12p pd=8.53u as=2.12p ps=8.53u w=8u l=2u
X195 a_7040_29924.t0 PB.t33 VDD VDD pfet_03v3 ad=2.12p pd=8.53u as=2.12p ps=8.53u w=8u l=2u
X196 a_1825_15740# a_1749_16889.t14 RFIN VSS nfet_03v3 ad=1.325p pd=5.53u as=1.325p ps=5.53u w=5u l=0.28u
X197 RFIN a_7040_32046# cap_mim_2f0_m4m5_noshield c_width=5u c_length=5u
X198 RFIN a_7040_32046# cap_mim_2f0_m4m5_noshield c_width=5u c_length=5u
X199 a_1825_15740# OUTP cap_mim_2f0_m4m5_noshield c_width=5u c_length=5u
X200 RFIN a_7040_32046# cap_mim_2f0_m4m5_noshield c_width=5u c_length=5u
X201 a_1825_15740# OUTP cap_mim_2f0_m4m5_noshield c_width=5u c_length=5u
X202 a_1825_15740# OUTP cap_mim_2f0_m4m5_noshield c_width=5u c_length=5u
X203 RFIN a_1749_16889.t17 a_1825_15740# VSS nfet_03v3 ad=1.325p pd=5.53u as=1.325p ps=5.53u w=5u l=0.28u
X204 VDD PB.t24 a_7040_29924.t0 VDD pfet_03v3 ad=2.12p pd=8.53u as=2.12p ps=8.53u w=8u l=2u
X205 a_7040_29924.t0 PB.t29 VDD VDD pfet_03v3 ad=2.12p pd=8.53u as=2.12p ps=8.53u w=8u l=2u
X206 a_7845_15740.t2 OUTN cap_mim_2f0_m4m5_noshield c_width=5u c_length=5u
X207 RFIN a_7040_32046# cap_mim_2f0_m4m5_noshield c_width=5u c_length=5u
X208 a_7040_29924.t0 PB.t41 VDD VDD pfet_03v3 ad=2.12p pd=8.53u as=2.12p ps=8.53u w=8u l=2u
X209 RFIN a_7040_32046# cap_mim_2f0_m4m5_noshield c_width=5u c_length=5u
X210 RFIN a_7040_32046# cap_mim_2f0_m4m5_noshield c_width=5u c_length=5u
X211 a_1825_15740# OUTP cap_mim_2f0_m4m5_noshield c_width=5u c_length=5u
X212 RFIN a_1749_16889.t21 a_1825_15740# VSS nfet_03v3 ad=1.325p pd=5.53u as=1.325p ps=5.53u w=5u l=0.28u
X213 RFIN a_7040_32046# cap_mim_2f0_m4m5_noshield c_width=5u c_length=5u
X214 a_7845_15740.t2 OUTN cap_mim_2f0_m4m5_noshield c_width=5u c_length=5u
X215 a_1825_15740# OUTP cap_mim_2f0_m4m5_noshield c_width=5u c_length=5u
X216 a_1825_15740# OUTP cap_mim_2f0_m4m5_noshield c_width=5u c_length=5u
X217 a_1825_15740# a_1749_16889.t24 RFIN VSS nfet_03v3 ad=1.325p pd=5.53u as=1.325p ps=5.53u w=5u l=0.28u
X218 VDD PB.t12 a_1749_16889.t2 VDD pfet_03v3 ad=2.12p pd=8.53u as=2.12p ps=8.53u w=8u l=2u
X219 RFIN a_7040_32046# cap_mim_2f0_m4m5_noshield c_width=5u c_length=5u
X220 a_1825_15740# a_1749_16889.t10 RFIN VSS nfet_03v3 ad=1.325p pd=5.53u as=1.325p ps=5.53u w=5u l=0.28u
X221 a_7845_15740.t2 OUTN cap_mim_2f0_m4m5_noshield c_width=5u c_length=5u
X222 a_7845_15740.t2 OUTN cap_mim_2f0_m4m5_noshield c_width=5u c_length=5u
X223 a_1825_15740# OUTP cap_mim_2f0_m4m5_noshield c_width=5u c_length=5u
X224 a_7845_15740.t2 OUTN cap_mim_2f0_m4m5_noshield c_width=5u c_length=5u
X225 RFIN a_7040_32046# cap_mim_2f0_m4m5_noshield c_width=5u c_length=5u
X226 a_7845_15740.t2 OUTN cap_mim_2f0_m4m5_noshield c_width=5u c_length=5u
X227 RFIN a_1749_16889.t19 a_1825_15740# VSS nfet_03v3 ad=1.325p pd=5.53u as=1.325p ps=5.53u w=5u l=0.28u
X228 RFIN a_7040_32046# cap_mim_2f0_m4m5_noshield c_width=5u c_length=5u
X229 RFIN a_7040_32046# cap_mim_2f0_m4m5_noshield c_width=5u c_length=5u
X230 a_7845_15740.t2 OUTN cap_mim_2f0_m4m5_noshield c_width=5u c_length=5u
X231 a_1825_15740# OUTP cap_mim_2f0_m4m5_noshield c_width=5u c_length=5u
X232 a_1825_15740# OUTP cap_mim_2f0_m4m5_noshield c_width=5u c_length=5u
X233 a_7845_15740.t2 OUTN cap_mim_2f0_m4m5_noshield c_width=5u c_length=5u
X234 a_1825_15740# a_1749_16889.t22 RFIN VSS nfet_03v3 ad=1.325p pd=5.53u as=1.325p ps=5.53u w=5u l=0.28u
X235 a_7040_29924.t3 PB.t3 VDD VDD pfet_03v3 ad=2.12p pd=8.53u as=2.12p ps=8.53u w=8u l=2u
X236 a_7845_15740.t2 OUTN cap_mim_2f0_m4m5_noshield c_width=5u c_length=5u
X237 RFIN a_7040_32046# cap_mim_2f0_m4m5_noshield c_width=5u c_length=5u
X238 a_7040_29924.t1 PB.t15 VDD VDD pfet_03v3 ad=2.12p pd=8.53u as=2.12p ps=8.53u w=8u l=2u
X239 RFIN a_7040_32046# cap_mim_2f0_m4m5_noshield c_width=5u c_length=5u
X240 a_7845_15740.t2 OUTN cap_mim_2f0_m4m5_noshield c_width=5u c_length=5u
X241 VDD PB.t36 a_7040_29924.t0 VDD pfet_03v3 ad=2.12p pd=8.53u as=2.12p ps=8.53u w=8u l=2u
X242 a_1825_15740# OUTP cap_mim_2f0_m4m5_noshield c_width=5u c_length=5u
X243 a_1825_15740# OUTP cap_mim_2f0_m4m5_noshield c_width=5u c_length=5u
X244 a_1825_15740# a_1749_16889.t26 RFIN VSS nfet_03v3 ad=1.325p pd=5.53u as=1.325p ps=5.53u w=5u l=0.28u
X245 RFIN a_7040_32046# cap_mim_2f0_m4m5_noshield c_width=5u c_length=5u
X246 RFIN a_7040_32046# cap_mim_2f0_m4m5_noshield c_width=5u c_length=5u
X247 RFIN a_1749_16889.t29 a_1825_15740# VSS nfet_03v3 ad=1.325p pd=5.53u as=1.325p ps=5.53u w=5u l=0.28u
X248 a_7845_15740.t2 OUTN cap_mim_2f0_m4m5_noshield c_width=5u c_length=5u
X249 a_1825_15740# OUTP cap_mim_2f0_m4m5_noshield c_width=5u c_length=5u
X250 RFIN a_1749_16889.t15 a_1825_15740# VSS nfet_03v3 ad=1.325p pd=5.53u as=1.325p ps=5.53u w=5u l=0.28u
X251 a_1825_15740# OUTP cap_mim_2f0_m4m5_noshield c_width=5u c_length=5u
X252 RFIN a_7040_32046# cap_mim_2f0_m4m5_noshield c_width=5u c_length=5u
X253 VDD PB.t22 a_1749_16889.t0 VDD pfet_03v3 ad=3.56p pd=16.89u as=2.12p ps=8.53u w=8u l=2u
X254 a_1749_16889.t0 PB.t27 VDD VDD pfet_03v3 ad=2.12p pd=8.53u as=2.12p ps=8.53u w=8u l=2u
X255 a_1825_15740# a_1749_16889.t18 RFIN VSS nfet_03v3 ad=1.325p pd=5.53u as=1.325p ps=5.53u w=5u l=0.28u
X256 a_1749_16889.t0 PB.t39 VDD VDD pfet_03v3 ad=2.12p pd=8.53u as=2.12p ps=8.53u w=8u l=2u
X257 a_1825_15740# OUTP cap_mim_2f0_m4m5_noshield c_width=5u c_length=5u
X258 RFIN a_7040_32046# cap_mim_2f0_m4m5_noshield c_width=5u c_length=5u
X259 a_7845_15740.t2 OUTN cap_mim_2f0_m4m5_noshield c_width=5u c_length=5u
X260 a_7845_15740.t2 OUTN cap_mim_2f0_m4m5_noshield c_width=5u c_length=5u
X261 RFIN a_1749_16889.t27 a_1825_15740# VSS nfet_03v3 ad=1.325p pd=5.53u as=1.325p ps=5.53u w=5u l=0.28u
X262 RFIN a_7040_32046# cap_mim_2f0_m4m5_noshield c_width=5u c_length=5u
X263 RFIN a_7040_32046# cap_mim_2f0_m4m5_noshield c_width=5u c_length=5u
X264 a_1825_15740# OUTP cap_mim_2f0_m4m5_noshield c_width=5u c_length=5u
X265 VDD PB.t42 a_1749_16889.t0 VDD pfet_03v3 ad=2.12p pd=8.53u as=2.12p ps=8.53u w=8u l=2u
X266 RFIN a_1749_16889.t13 a_1825_15740# VSS nfet_03v3 ad=1.325p pd=5.53u as=1.325p ps=5.53u w=5u l=0.28u
X267 a_1825_15740# OUTP cap_mim_2f0_m4m5_noshield c_width=5u c_length=5u
X268 a_1825_15740# OUTP cap_mim_2f0_m4m5_noshield c_width=5u c_length=5u
X269 VDD PB.t10 a_7040_29924.t1 VDD pfet_03v3 ad=2.12p pd=8.53u as=2.12p ps=8.53u w=8u l=2u
X270 a_7845_15740.t2 OUTN cap_mim_2f0_m4m5_noshield c_width=5u c_length=5u
X271 a_7845_15740.t2 OUTN cap_mim_2f0_m4m5_noshield c_width=5u c_length=5u
X272 RFIN a_1749_16889.t31 a_1825_15740# VSS nfet_03v3 ad=1.325p pd=5.53u as=1.325p ps=5.53u w=5u l=0.28u
X273 a_7845_15740.t2 OUTN cap_mim_2f0_m4m5_noshield c_width=5u c_length=5u
X274 a_1825_15740# OUTP cap_mim_2f0_m4m5_noshield c_width=5u c_length=5u
X275 RFIN a_7040_32046# cap_mim_2f0_m4m5_noshield c_width=5u c_length=5u
X276 RFIN a_7040_32046# cap_mim_2f0_m4m5_noshield c_width=5u c_length=5u
X277 a_7845_15740.t2 OUTN cap_mim_2f0_m4m5_noshield c_width=5u c_length=5u
X278 a_1825_15740# OUTP cap_mim_2f0_m4m5_noshield c_width=5u c_length=5u
X279 a_1825_15740# a_1749_16889.t20 RFIN VSS nfet_03v3 ad=1.325p pd=5.53u as=1.325p ps=5.53u w=5u l=0.28u
X280 RFIN a_7040_32046# cap_mim_2f0_m4m5_noshield c_width=5u c_length=5u
X281 RFIN a_7040_32046# cap_mim_2f0_m4m5_noshield c_width=5u c_length=5u
X282 a_1825_15740# OUTP cap_mim_2f0_m4m5_noshield c_width=5u c_length=5u
X283 a_7845_15740.t2 OUTN cap_mim_2f0_m4m5_noshield c_width=5u c_length=5u
X284 RFIN a_1749_16889.t23 a_1825_15740# VSS nfet_03v3 ad=1.325p pd=5.53u as=1.325p ps=5.53u w=5u l=0.28u
X285 a_7845_15740.t2 OUTN cap_mim_2f0_m4m5_noshield c_width=5u c_length=5u
X286 VDD PB.t34 a_1749_16889.t0 VDD pfet_03v3 ad=2.12p pd=8.53u as=2.12p ps=8.53u w=8u l=2u
X287 a_7845_15740.t2 OUTN cap_mim_2f0_m4m5_noshield c_width=5u c_length=5u
X288 a_1825_15740# OUTP cap_mim_2f0_m4m5_noshield c_width=5u c_length=5u
X289 a_1825_15740# OUTP cap_mim_2f0_m4m5_noshield c_width=5u c_length=5u
X290 a_7845_15740.t2 OUTN cap_mim_2f0_m4m5_noshield c_width=5u c_length=5u
X291 RFIN a_7040_32046# cap_mim_2f0_m4m5_noshield c_width=5u c_length=5u
X292 RFIN a_7040_32046# cap_mim_2f0_m4m5_noshield c_width=5u c_length=5u
X293 a_1825_15740# a_1749_16889.t32 RFIN VSS nfet_03v3 ad=1.325p pd=5.53u as=2.225p ps=10.89u w=5u l=0.28u
X294 RFIN a_7040_32046# cap_mim_2f0_m4m5_noshield c_width=5u c_length=5u
X295 a_1825_15740# a_1749_16889.t12 RFIN VSS nfet_03v3 ad=1.325p pd=5.53u as=1.325p ps=5.53u w=5u l=0.28u
X296 a_1825_15740# OUTP cap_mim_2f0_m4m5_noshield c_width=5u c_length=5u
X297 a_7845_15740.t2 OUTN cap_mim_2f0_m4m5_noshield c_width=5u c_length=5u
X298 a_1825_15740# OUTP cap_mim_2f0_m4m5_noshield c_width=5u c_length=5u
X299 RFIN a_7040_32046# cap_mim_2f0_m4m5_noshield c_width=5u c_length=5u
X300 a_7040_29924.t0 PB.t25 VDD VDD pfet_03v3 ad=2.12p pd=8.53u as=2.12p ps=8.53u w=8u l=2u
X301 a_7040_29924.t0 PB.t37 VDD VDD pfet_03v3 ad=2.12p pd=8.53u as=2.12p ps=8.53u w=8u l=2u
X302 a_1825_15740# OUTP cap_mim_2f0_m4m5_noshield c_width=5u c_length=5u
X303 a_1825_15740# OUTP cap_mim_2f0_m4m5_noshield c_width=5u c_length=5u
X304 RFIN a_7040_32046# cap_mim_2f0_m4m5_noshield c_width=5u c_length=5u
X305 a_1825_15740# OUTP cap_mim_2f0_m4m5_noshield c_width=5u c_length=5u
X306 RFIN a_1749_16889.t25 a_1825_15740# VSS nfet_03v3 ad=1.325p pd=5.53u as=1.325p ps=5.53u w=5u l=0.28u
X307 VSS RFIN VSS ppolyf_u_1k r_width=10u r_length=3u
X308 a_7845_15740.t2 OUTN cap_mim_2f0_m4m5_noshield c_width=5u c_length=5u
X309 RFIN a_7040_32046# cap_mim_2f0_m4m5_noshield c_width=5u c_length=5u
X310 a_1825_15740# a_1749_16889.t28 RFIN VSS nfet_03v3 ad=1.325p pd=5.53u as=1.325p ps=5.53u w=5u l=0.28u
X311 a_1825_15740# OUTP cap_mim_2f0_m4m5_noshield c_width=5u c_length=5u
X312 VDD PB.t8 a_1749_16889.t2 VDD pfet_03v3 ad=2.12p pd=8.53u as=2.12p ps=8.53u w=8u l=2u
X313 RFIN a_7040_32046# cap_mim_2f0_m4m5_noshield c_width=5u c_length=5u
X314 a_1825_15740# OUTP cap_mim_2f0_m4m5_noshield c_width=5u c_length=5u
X315 a_7845_15740.t2 OUTN cap_mim_2f0_m4m5_noshield c_width=5u c_length=5u
X316 a_7845_15740.t2 OUTN cap_mim_2f0_m4m5_noshield c_width=5u c_length=5u
X317 a_7845_15740.t2 OUTN cap_mim_2f0_m4m5_noshield c_width=5u c_length=5u
X318 VDD PB.t4 a_1749_16889.t3 VDD pfet_03v3 ad=2.12p pd=8.53u as=2.12p ps=8.53u w=8u l=2u
X319 a_1825_15740# OUTP cap_mim_2f0_m4m5_noshield c_width=5u c_length=5u
X320 a_7845_15740.t2 OUTN cap_mim_2f0_m4m5_noshield c_width=5u c_length=5u
X321 a_7845_15740.t2 OUTN cap_mim_2f0_m4m5_noshield c_width=5u c_length=5u
X322 RFIN a_7040_32046# cap_mim_2f0_m4m5_noshield c_width=5u c_length=5u
X323 RFIN a_7040_32046# cap_mim_2f0_m4m5_noshield c_width=5u c_length=5u
X324 a_1825_15740# OUTP cap_mim_2f0_m4m5_noshield c_width=5u c_length=5u
X325 VDD PB.t32 a_7040_29924.t0 VDD pfet_03v3 ad=2.12p pd=8.53u as=2.12p ps=8.53u w=8u l=2u
X326 VDD a_7845_15740.t0 VSS ppolyf_u_1k r_width=30u r_length=2.17u
X327 a_7845_15740.t2 OUTN cap_mim_2f0_m4m5_noshield c_width=5u c_length=5u
X328 RFIN a_7040_32046# cap_mim_2f0_m4m5_noshield c_width=5u c_length=5u
X329 a_7845_15740.t2 OUTN cap_mim_2f0_m4m5_noshield c_width=5u c_length=5u
X330 a_1825_15740# OUTP cap_mim_2f0_m4m5_noshield c_width=5u c_length=5u
X331 a_1825_15740# OUTP cap_mim_2f0_m4m5_noshield c_width=5u c_length=5u
X332 a_7845_15740.t2 OUTN cap_mim_2f0_m4m5_noshield c_width=5u c_length=5u
X333 VSS a_7040_32046# a_7845_15740.t0 VSS nfet_03v3 ad=1.325p pd=5.53u as=1.325p ps=5.53u w=5u l=0.28u
X334 a_7845_15740.t2 OUTN cap_mim_2f0_m4m5_noshield c_width=5u c_length=5u
X335 RFIN a_7040_32046# cap_mim_2f0_m4m5_noshield c_width=5u c_length=5u
X336 RFIN a_7040_32046# cap_mim_2f0_m4m5_noshield c_width=5u c_length=5u
X337 a_7040_32046# a_7040_29924.t7 VSS ppolyf_u_1k r_width=1u r_length=10u
X338 RFIN a_7040_32046# cap_mim_2f0_m4m5_noshield c_width=5u c_length=5u
X339 a_7845_15740.t0 a_7040_32046# VSS VSS nfet_03v3 ad=1.325p pd=5.53u as=1.325p ps=5.53u w=5u l=0.28u
X340 a_1825_15740# OUTP cap_mim_2f0_m4m5_noshield c_width=5u c_length=5u
X341 a_7845_15740.t2 OUTN cap_mim_2f0_m4m5_noshield c_width=5u c_length=5u
X342 a_7845_15740.t2 OUTN cap_mim_2f0_m4m5_noshield c_width=5u c_length=5u
X343 a_7845_15740.t2 OUTN cap_mim_2f0_m4m5_noshield c_width=5u c_length=5u
X344 a_1825_15740# OUTP cap_mim_2f0_m4m5_noshield c_width=5u c_length=5u
X345 VSS a_7040_32046# a_7845_15740.t0 VSS nfet_03v3 ad=1.325p pd=5.53u as=1.325p ps=5.53u w=5u l=0.28u
X346 RFIN a_7040_32046# cap_mim_2f0_m4m5_noshield c_width=5u c_length=5u
X347 VDD a_1825_15740# VSS ppolyf_u_1k r_width=10u r_length=2u
X348 a_1825_15740# OUTP cap_mim_2f0_m4m5_noshield c_width=5u c_length=5u
X349 VSS a_7040_32046# a_7845_15740.t0 VSS nfet_03v3 ad=1.325p pd=5.53u as=1.325p ps=5.53u w=5u l=0.28u
X350 a_1825_15740# OUTP cap_mim_2f0_m4m5_noshield c_width=5u c_length=5u
X351 VSS a_7040_32046# a_7845_15740.t0 VSS nfet_03v3 ad=1.325p pd=5.53u as=1.325p ps=5.53u w=5u l=0.28u
X352 RFIN a_7040_32046# cap_mim_2f0_m4m5_noshield c_width=5u c_length=5u
X353 a_1749_16889.t4 PB.t1 VDD VDD pfet_03v3 ad=2.12p pd=8.53u as=2.12p ps=8.53u w=8u l=2u
X354 RFIN a_7040_32046# cap_mim_2f0_m4m5_noshield c_width=5u c_length=5u
X355 VDD PB.t6 a_7040_29924.t2 VDD pfet_03v3 ad=2.12p pd=8.53u as=2.12p ps=8.53u w=8u l=2u
X356 a_7845_15740.t2 OUTN cap_mim_2f0_m4m5_noshield c_width=5u c_length=5u
X357 VDD PB.t18 a_7040_29924.t1 VDD pfet_03v3 ad=2.12p pd=8.53u as=2.12p ps=8.53u w=8u l=2u
X358 RFIN a_7040_32046# cap_mim_2f0_m4m5_noshield c_width=5u c_length=5u
X359 a_1825_15740# OUTP cap_mim_2f0_m4m5_noshield c_width=5u c_length=5u
X360 a_7845_15740.t0 a_7040_32046# VSS VSS nfet_03v3 ad=1.325p pd=5.53u as=1.325p ps=5.53u w=5u l=0.28u
X361 a_7845_15740.t2 OUTN cap_mim_2f0_m4m5_noshield c_width=5u c_length=5u
X362 a_1825_15740# OUTP cap_mim_2f0_m4m5_noshield c_width=5u c_length=5u
X363 a_1825_15740# OUTP cap_mim_2f0_m4m5_noshield c_width=5u c_length=5u
X364 VSS a_7040_32046# a_7845_15740.t0 VSS nfet_03v3 ad=1.325p pd=5.53u as=1.325p ps=5.53u w=5u l=0.28u
X365 a_1825_15740# OUTP cap_mim_2f0_m4m5_noshield c_width=5u c_length=5u
X366 a_1825_15740# OUTP cap_mim_2f0_m4m5_noshield c_width=5u c_length=5u
X367 a_7845_15740.t2 OUTN cap_mim_2f0_m4m5_noshield c_width=5u c_length=5u
X368 a_7845_15740.t0 a_7040_32046# VSS VSS nfet_03v3 ad=1.325p pd=5.53u as=1.325p ps=5.53u w=5u l=0.28u
X369 a_7845_15740.t2 OUTN cap_mim_2f0_m4m5_noshield c_width=5u c_length=5u
X370 VSS a_7040_32046# a_7845_15740.t0 VSS nfet_03v3 ad=1.325p pd=5.53u as=1.325p ps=5.53u w=5u l=0.28u
X371 RFIN a_7040_32046# cap_mim_2f0_m4m5_noshield c_width=5u c_length=5u
X372 a_1825_15740# OUTP cap_mim_2f0_m4m5_noshield c_width=5u c_length=5u
X373 VSS a_7040_32046# a_7845_15740.t0 VSS nfet_03v3 ad=1.325p pd=5.53u as=1.325p ps=5.53u w=5u l=0.28u
X374 RFIN a_7040_32046# cap_mim_2f0_m4m5_noshield c_width=5u c_length=5u
X375 a_7845_15740.t2 OUTN cap_mim_2f0_m4m5_noshield c_width=5u c_length=5u
X376 VDD PB.t30 a_1749_16889.t0 VDD pfet_03v3 ad=2.12p pd=8.53u as=2.12p ps=8.53u w=8u l=2u
X377 a_7845_15740.t2 OUTN cap_mim_2f0_m4m5_noshield c_width=5u c_length=5u
X378 a_1825_15740# OUTP cap_mim_2f0_m4m5_noshield c_width=5u c_length=5u
X379 RFIN a_7040_32046# cap_mim_2f0_m4m5_noshield c_width=5u c_length=5u
X380 a_7845_15740.t0 a_7040_32046# VSS VSS nfet_03v3 ad=1.325p pd=5.53u as=1.325p ps=5.53u w=5u l=0.28u
X381 a_1825_15740# OUTP cap_mim_2f0_m4m5_noshield c_width=5u c_length=5u
X382 a_1749_16889.t8 VSS cap_mim_2f0_m4m5_noshield c_width=50u c_length=50u
X383 a_7845_15740.t0 a_7040_32046# VSS VSS nfet_03v3 ad=1.325p pd=5.53u as=1.325p ps=5.53u w=5u l=0.28u
X384 VDD PB.t26 a_1749_16889.t0 VDD pfet_03v3 ad=2.12p pd=8.53u as=2.12p ps=8.53u w=8u l=2u
X385 a_7845_15740.t2 OUTN cap_mim_2f0_m4m5_noshield c_width=5u c_length=5u
C0 RFIN a_5700_15680# 0.05282f
C1 VDD a_28064_31611# 3.30247f
C2 RFIN a_1825_15740# 8.83148f
C3 a_7040_32046# VDD 1.59128f
C4 VDD a_7584_15680# 0.01888f
C5 VDD PB 54.5428f
C6 VDD a_15436_15680# 0.02209f
C7 a_28064_29680# a_28064_31611# 0.01104f
C8 RFIN a_7040_32046# 30.3981f
C9 VDD a_1564_15680# 0.01888f
C10 a_16340_31611# a_16340_29680# 0.01104f
C11 a_13016_15680# VDD 0.01888f
C12 RFIN PB 0.22428f
C13 VDD OUTP 2.365f
C14 a_17244_15680# VDD 0.01567f
C15 a_1825_15740# a_7460_30646# 0.1582f
C16 RFIN a_1564_15680# 0.07404f
C17 a_1825_15740# a_5700_15680# 0.01265f
C18 VDD a_17816_15680# 0.01567f
C19 VDD a_28064_29680# 3.33985f
C20 a_7040_32046# a_7460_30646# 0.82797f
C21 a_16340_31611# PB 0.0436f
C22 VDD a_14864_15680# 0.02209f
C23 RFIN VDD 3.1629f
C24 VDD a_7584_17051# 0.01798f
C25 PB a_7460_30646# 0.09203f
C26 a_15436_15680# a_7460_30646# 0.06804f
C27 a_7040_32046# a_1825_15740# 0.24338f
C28 PB a_16340_29680# 0.02815f
C29 a_16340_31611# VDD 3.30247f
C30 a_1825_15740# PB 0.73021f
C31 VDD a_13016_17051# 0.01798f
C32 VDD a_7460_30646# 1.48132f
C33 VDD a_5700_15680# 0.01888f
C34 a_7040_32046# PB 0.17524f
C35 a_1825_15740# OUTP 29.7225f
C36 OUTN OUTP 0.16446f
C37 a_7460_30646# a_14864_15680# 0.06298f
C38 VDD a_16340_29680# 3.33985f
C39 VDD a_1825_15740# 4.75288f
C40 VDD OUTN 0.58887f
R0 PB PB.n42 52.6265
R1 PB.n21 PB.t0 36.0256
R2 PB.n31 PB.t21 36.0256
R3 PB.n0 PB.t22 34.3534
R4 PB.n10 PB.t43 34.3534
R5 PB.n30 PB.n29 21.4256
R6 PB.n29 PB.n28 21.4256
R7 PB.n28 PB.n27 21.4256
R8 PB.n27 PB.n26 21.4256
R9 PB.n26 PB.n25 21.4256
R10 PB.n25 PB.n24 21.4256
R11 PB.n24 PB.n23 21.4256
R12 PB.n23 PB.n22 21.4256
R13 PB.n22 PB.n21 21.4256
R14 PB.n40 PB.n39 21.4256
R15 PB.n39 PB.n38 21.4256
R16 PB.n38 PB.n37 21.4256
R17 PB.n37 PB.n36 21.4256
R18 PB.n36 PB.n35 21.4256
R19 PB.n35 PB.n34 21.4256
R20 PB.n34 PB.n33 21.4256
R21 PB.n33 PB.n32 21.4256
R22 PB.n32 PB.n31 21.4256
R23 PB.n9 PB.n8 19.7534
R24 PB.n8 PB.n7 19.7534
R25 PB.n7 PB.n6 19.7534
R26 PB.n6 PB.n5 19.7534
R27 PB.n5 PB.n4 19.7534
R28 PB.n4 PB.n3 19.7534
R29 PB.n3 PB.n2 19.7534
R30 PB.n2 PB.n1 19.7534
R31 PB.n1 PB.n0 19.7534
R32 PB.n19 PB.n18 19.7534
R33 PB.n18 PB.n17 19.7534
R34 PB.n17 PB.n16 19.7534
R35 PB.n16 PB.n15 19.7534
R36 PB.n15 PB.n14 19.7534
R37 PB.n14 PB.n13 19.7534
R38 PB.n13 PB.n12 19.7534
R39 PB.n12 PB.n11 19.7534
R40 PB.n11 PB.n10 19.7534
R41 PB.n9 PB.t32 14.6005
R42 PB.n8 PB.t31 14.6005
R43 PB.n7 PB.t30 14.6005
R44 PB.n6 PB.t29 14.6005
R45 PB.n5 PB.t28 14.6005
R46 PB.n4 PB.t27 14.6005
R47 PB.n3 PB.t26 14.6005
R48 PB.n2 PB.t25 14.6005
R49 PB.n1 PB.t24 14.6005
R50 PB.n0 PB.t23 14.6005
R51 PB.n19 PB.t33 14.6005
R52 PB.n18 PB.t34 14.6005
R53 PB.n17 PB.t35 14.6005
R54 PB.n16 PB.t36 14.6005
R55 PB.n15 PB.t37 14.6005
R56 PB.n14 PB.t38 14.6005
R57 PB.n13 PB.t39 14.6005
R58 PB.n12 PB.t40 14.6005
R59 PB.n11 PB.t41 14.6005
R60 PB.n10 PB.t42 14.6005
R61 PB.n30 PB.t10 14.6005
R62 PB.n29 PB.t9 14.6005
R63 PB.n28 PB.t8 14.6005
R64 PB.n27 PB.t7 14.6005
R65 PB.n26 PB.t6 14.6005
R66 PB.n25 PB.t5 14.6005
R67 PB.n24 PB.t4 14.6005
R68 PB.n23 PB.t3 14.6005
R69 PB.n22 PB.t2 14.6005
R70 PB.n21 PB.t1 14.6005
R71 PB.n40 PB.t11 14.6005
R72 PB.n39 PB.t12 14.6005
R73 PB.n38 PB.t13 14.6005
R74 PB.n37 PB.t14 14.6005
R75 PB.n36 PB.t15 14.6005
R76 PB.n35 PB.t16 14.6005
R77 PB.n34 PB.t17 14.6005
R78 PB.n33 PB.t18 14.6005
R79 PB.n32 PB.t19 14.6005
R80 PB.n31 PB.t20 14.6005
R81 PB.n42 PB.n20 13.9955
R82 PB.n42 PB.n41 11.0795
R83 PB.n41 PB.n30 10.7131
R84 PB.n41 PB.n40 10.7131
R85 PB.n20 PB.n9 9.87697
R86 PB.n20 PB.n19 9.87697
R87 a_1749_16889.n1 a_1749_16889.t9 96.1964
R88 a_1749_16889.n12 a_1749_16889.t32 96.1964
R89 a_1749_16889.n1 a_1749_16889.t10 84.6023
R90 a_1749_16889.n2 a_1749_16889.t11 84.6023
R91 a_1749_16889.n3 a_1749_16889.t12 84.6023
R92 a_1749_16889.n4 a_1749_16889.t13 84.6023
R93 a_1749_16889.n5 a_1749_16889.t14 84.6023
R94 a_1749_16889.n6 a_1749_16889.t15 84.6023
R95 a_1749_16889.n7 a_1749_16889.t16 84.6023
R96 a_1749_16889.n8 a_1749_16889.t17 84.6023
R97 a_1749_16889.n9 a_1749_16889.t18 84.6023
R98 a_1749_16889.n10 a_1749_16889.t19 84.6023
R99 a_1749_16889.n11 a_1749_16889.t20 84.6023
R100 a_1749_16889.n22 a_1749_16889.t21 84.6023
R101 a_1749_16889.n21 a_1749_16889.t22 84.6023
R102 a_1749_16889.n20 a_1749_16889.t23 84.6023
R103 a_1749_16889.n19 a_1749_16889.t24 84.6023
R104 a_1749_16889.n18 a_1749_16889.t25 84.6023
R105 a_1749_16889.n17 a_1749_16889.t26 84.6023
R106 a_1749_16889.n16 a_1749_16889.t27 84.6023
R107 a_1749_16889.n15 a_1749_16889.t28 84.6023
R108 a_1749_16889.n14 a_1749_16889.t29 84.6023
R109 a_1749_16889.n13 a_1749_16889.t30 84.6023
R110 a_1749_16889.n12 a_1749_16889.t31 84.6023
R111 a_1749_16889.n0 a_1749_16889.t8 13.6039
R112 a_1749_16889.n0 a_1749_16889.n23 13.4161
R113 a_1749_16889.n13 a_1749_16889.n12 11.5946
R114 a_1749_16889.n14 a_1749_16889.n13 11.5946
R115 a_1749_16889.n15 a_1749_16889.n14 11.5946
R116 a_1749_16889.n16 a_1749_16889.n15 11.5946
R117 a_1749_16889.n17 a_1749_16889.n16 11.5946
R118 a_1749_16889.n18 a_1749_16889.n17 11.5946
R119 a_1749_16889.n19 a_1749_16889.n18 11.5946
R120 a_1749_16889.n20 a_1749_16889.n19 11.5946
R121 a_1749_16889.n21 a_1749_16889.n20 11.5946
R122 a_1749_16889.n22 a_1749_16889.n21 11.5946
R123 a_1749_16889.n11 a_1749_16889.n10 11.5946
R124 a_1749_16889.n10 a_1749_16889.n9 11.5946
R125 a_1749_16889.n9 a_1749_16889.n8 11.5946
R126 a_1749_16889.n8 a_1749_16889.n7 11.5946
R127 a_1749_16889.n7 a_1749_16889.n6 11.5946
R128 a_1749_16889.n6 a_1749_16889.n5 11.5946
R129 a_1749_16889.n5 a_1749_16889.n4 11.5946
R130 a_1749_16889.n4 a_1749_16889.n3 11.5946
R131 a_1749_16889.n3 a_1749_16889.n2 11.5946
R132 a_1749_16889.n2 a_1749_16889.n1 11.5946
R133 a_1749_16889.t0 a_1749_16889.t5 10.3258
R134 a_1749_16889.n23 a_1749_16889.n22 5.79756
R135 a_1749_16889.n23 a_1749_16889.n11 5.79756
R136 a_1749_16889.t5 a_1749_16889.n0 4.64873
R137 a_1749_16889.t1 a_1749_16889.t0 4.5005
R138 a_1749_16889.n0 a_1749_16889.t6 3.86512
R139 a_1749_16889.t4 a_1749_16889.t3 3.39328
R140 a_1749_16889.t3 a_1749_16889.t2 1.62693
R141 a_1749_16889.t2 a_1749_16889.t1 1.45095
R142 a_7845_15740.t0 a_7845_15740.t2 17.6533
R143 a_7845_15740.t1 a_7845_15740.t0 3.83201
R144 a_7040_29924.t5 a_7040_29924.t8 14.9739
R145 a_7040_29924.t7 a_7040_29924.t4 7.2014
R146 a_7040_29924.t1 a_7040_29924.t0 4.5005
R147 a_7040_29924.t3 a_7040_29924.t2 3.79179
R148 a_7040_29924.t2 a_7040_29924.t1 2.38952
R149 a_7040_29924.t0 a_7040_29924.t7 1.64893
R150 a_7040_29924.t4 a_7040_29924.t5 1.2794
C41 OUTP VSS 24.2011f
C42 OUTN VSS 19.679f
C43 PB VSS 19.1278f
C44 RFIN VSS 45.0955f
C45 VDD VSS 0.34034p
C46 a_17816_15680# VSS 0.72809f
C47 a_17244_15680# VSS 0.73108f
C48 a_15436_15680# VSS 0.9592f
C49 a_14864_15680# VSS 0.96008f
C50 a_13016_15680# VSS 0.89013f
C51 a_7584_15680# VSS 0.89324f
C52 a_13016_17051# VSS 0.86856f
C53 a_7584_17051# VSS 0.88394f
C54 a_5700_15680# VSS 0.81731f
C55 a_1564_15680# VSS 0.81731f
C56 a_28064_29680# VSS 0.21076f
C57 a_16340_29680# VSS 0.21076f
C58 a_28064_31611# VSS 0.19737f
C59 a_16340_31611# VSS 0.19737f
C60 a_7460_30646# VSS 6.99045f ; **FLOATING
C61 a_7040_32046# VSS 60.2975f ; **FLOATING
C62 a_1825_15740# VSS 50.2658f ; **FLOATING
C63 a_7040_29924.t1 VSS 0.24199f ; **FLOATING
C64 a_7040_29924.t3 VSS 0.04551f ; **FLOATING
C65 a_7040_29924.t2 VSS 0.19648f ; **FLOATING
C66 a_7040_29924.t8 VSS 27.8567f ; **FLOATING
C67 a_7040_29924.t5 VSS 0.30689f ; **FLOATING
C68 a_7040_29924.t4 VSS 0.28777f ; **FLOATING
C69 a_7040_29924.t7 VSS 0.56373f ; **FLOATING
C70 a_7040_29924.t0 VSS 0.59852f ; **FLOATING
C71 a_7845_15740.t2 VSS 44.4221f ; **FLOATING
C72 a_7845_15740.t0 VSS 22.581f ; **FLOATING
C73 a_7845_15740.t1 VSS 0.03874f ; **FLOATING
C74 a_1749_16889.n0 VSS 1.45892f ; **FLOATING
C75 a_1749_16889.t6 VSS 0.04098f ; **FLOATING
C76 a_1749_16889.t4 VSS 0.06822f ; **FLOATING
C77 a_1749_16889.t2 VSS 0.30661f ; **FLOATING
C78 a_1749_16889.t3 VSS 0.28354f ; **FLOATING
C79 a_1749_16889.t1 VSS 0.20579f ; **FLOATING
C80 a_1749_16889.t20 VSS 0.01132f ; **FLOATING
C81 a_1749_16889.t19 VSS 0.01132f ; **FLOATING
C82 a_1749_16889.t18 VSS 0.01132f ; **FLOATING
C83 a_1749_16889.t17 VSS 0.01132f ; **FLOATING
C84 a_1749_16889.t16 VSS 0.01132f ; **FLOATING
C85 a_1749_16889.t15 VSS 0.01132f ; **FLOATING
C86 a_1749_16889.t14 VSS 0.01132f ; **FLOATING
C87 a_1749_16889.t13 VSS 0.01132f ; **FLOATING
C88 a_1749_16889.t12 VSS 0.01132f ; **FLOATING
C89 a_1749_16889.t11 VSS 0.01132f ; **FLOATING
C90 a_1749_16889.t10 VSS 0.01132f ; **FLOATING
C91 a_1749_16889.t9 VSS 0.01218f ; **FLOATING
C92 a_1749_16889.n1 VSS 0.01422f ; **FLOATING
C93 a_1749_16889.t21 VSS 0.01132f ; **FLOATING
C94 a_1749_16889.t22 VSS 0.01132f ; **FLOATING
C95 a_1749_16889.t23 VSS 0.01132f ; **FLOATING
C96 a_1749_16889.t24 VSS 0.01132f ; **FLOATING
C97 a_1749_16889.t25 VSS 0.01132f ; **FLOATING
C98 a_1749_16889.t26 VSS 0.01132f ; **FLOATING
C99 a_1749_16889.t27 VSS 0.01132f ; **FLOATING
C100 a_1749_16889.t28 VSS 0.01132f ; **FLOATING
C101 a_1749_16889.t29 VSS 0.01132f ; **FLOATING
C102 a_1749_16889.t30 VSS 0.01132f ; **FLOATING
C103 a_1749_16889.t31 VSS 0.01132f ; **FLOATING
C104 a_1749_16889.t32 VSS 0.01218f ; **FLOATING
C105 a_1749_16889.n12 VSS 0.01422f ; **FLOATING
C106 a_1749_16889.n23 VSS 0.26816f ; **FLOATING
C107 a_1749_16889.t8 VSS 40.4047f ; **FLOATING
C108 a_1749_16889.t5 VSS 0.52744f ; **FLOATING
C109 a_1749_16889.t0 VSS 1.97984f ; **FLOATING
C110 PB.t32 VSS 0.9787f ; **FLOATING
C111 PB.t31 VSS 0.9787f ; **FLOATING
C112 PB.t30 VSS 0.9787f ; **FLOATING
C113 PB.t29 VSS 0.9787f ; **FLOATING
C114 PB.t28 VSS 0.9787f ; **FLOATING
C115 PB.t27 VSS 0.9787f ; **FLOATING
C116 PB.t26 VSS 0.9787f ; **FLOATING
C117 PB.t25 VSS 0.9787f ; **FLOATING
C118 PB.t24 VSS 0.9787f ; **FLOATING
C119 PB.t23 VSS 0.9787f ; **FLOATING
C120 PB.t22 VSS 1.27286f ; **FLOATING
C121 PB.n0 VSS 0.73553f ; **FLOATING
C122 PB.n1 VSS 0.51811f ; **FLOATING
C123 PB.n2 VSS 0.51811f ; **FLOATING
C124 PB.n3 VSS 0.51811f ; **FLOATING
C125 PB.n4 VSS 0.51811f ; **FLOATING
C126 PB.n5 VSS 0.51811f ; **FLOATING
C127 PB.n6 VSS 0.51811f ; **FLOATING
C128 PB.n7 VSS 0.51811f ; **FLOATING
C129 PB.n8 VSS 0.51811f ; **FLOATING
C130 PB.n9 VSS 0.48093f ; **FLOATING
C131 PB.t33 VSS 0.9787f ; **FLOATING
C132 PB.t34 VSS 0.9787f ; **FLOATING
C133 PB.t35 VSS 0.9787f ; **FLOATING
C134 PB.t36 VSS 0.9787f ; **FLOATING
C135 PB.t37 VSS 0.9787f ; **FLOATING
C136 PB.t38 VSS 0.9787f ; **FLOATING
C137 PB.t39 VSS 0.9787f ; **FLOATING
C138 PB.t40 VSS 0.9787f ; **FLOATING
C139 PB.t41 VSS 0.9787f ; **FLOATING
C140 PB.t42 VSS 0.9787f ; **FLOATING
C141 PB.t43 VSS 1.27286f ; **FLOATING
C142 PB.n10 VSS 0.73553f ; **FLOATING
C143 PB.n11 VSS 0.51811f ; **FLOATING
C144 PB.n12 VSS 0.51811f ; **FLOATING
C145 PB.n13 VSS 0.51811f ; **FLOATING
C146 PB.n14 VSS 0.51811f ; **FLOATING
C147 PB.n15 VSS 0.51811f ; **FLOATING
C148 PB.n16 VSS 0.51811f ; **FLOATING
C149 PB.n17 VSS 0.51811f ; **FLOATING
C150 PB.n18 VSS 0.51811f ; **FLOATING
C151 PB.n19 VSS 0.48093f ; **FLOATING
C152 PB.n20 VSS 3.15033f ; **FLOATING
C153 PB.t10 VSS 0.9787f ; **FLOATING
C154 PB.t9 VSS 0.9787f ; **FLOATING
C155 PB.t8 VSS 0.9787f ; **FLOATING
C156 PB.t7 VSS 0.9787f ; **FLOATING
C157 PB.t6 VSS 0.9787f ; **FLOATING
C158 PB.t5 VSS 0.9787f ; **FLOATING
C159 PB.t4 VSS 0.9787f ; **FLOATING
C160 PB.t3 VSS 0.9787f ; **FLOATING
C161 PB.t2 VSS 0.9787f ; **FLOATING
C162 PB.t1 VSS 0.9787f ; **FLOATING
C163 PB.t0 VSS 1.26956f ; **FLOATING
C164 PB.n21 VSS 0.69379f ; **FLOATING
C165 PB.n22 VSS 0.49559f ; **FLOATING
C166 PB.n23 VSS 0.49559f ; **FLOATING
C167 PB.n24 VSS 0.49559f ; **FLOATING
C168 PB.n25 VSS 0.49559f ; **FLOATING
C169 PB.n26 VSS 0.49559f ; **FLOATING
C170 PB.n27 VSS 0.49559f ; **FLOATING
C171 PB.n28 VSS 0.49559f ; **FLOATING
C172 PB.n29 VSS 0.49559f ; **FLOATING
C173 PB.n30 VSS 0.46048f ; **FLOATING
C174 PB.t11 VSS 0.9787f ; **FLOATING
C175 PB.t12 VSS 0.9787f ; **FLOATING
C176 PB.t13 VSS 0.9787f ; **FLOATING
C177 PB.t14 VSS 0.9787f ; **FLOATING
C178 PB.t15 VSS 0.9787f ; **FLOATING
C179 PB.t16 VSS 0.9787f ; **FLOATING
C180 PB.t17 VSS 0.9787f ; **FLOATING
C181 PB.t18 VSS 0.9787f ; **FLOATING
C182 PB.t19 VSS 0.9787f ; **FLOATING
C183 PB.t20 VSS 0.9787f ; **FLOATING
C184 PB.t21 VSS 1.26956f ; **FLOATING
C185 PB.n31 VSS 0.69379f ; **FLOATING
C186 PB.n32 VSS 0.49559f ; **FLOATING
C187 PB.n33 VSS 0.49559f ; **FLOATING
C188 PB.n34 VSS 0.49559f ; **FLOATING
C189 PB.n35 VSS 0.49559f ; **FLOATING
C190 PB.n36 VSS 0.49559f ; **FLOATING
C191 PB.n37 VSS 0.49559f ; **FLOATING
C192 PB.n38 VSS 0.49559f ; **FLOATING
C193 PB.n39 VSS 0.49559f ; **FLOATING
C194 PB.n40 VSS 0.46048f ; **FLOATING
C195 PB.n41 VSS 3.06539f ; **FLOATING
C196 PB.n42 VSS 2.34825f ; **FLOATING
.ends

.subckt lna_nc RFIN PB OUTP OUTN VDD VSS
XPEX VSS VDD RFIN PB OUTP OUTN lna_nc_flat
.ends
.end
