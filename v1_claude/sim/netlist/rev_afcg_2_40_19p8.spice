** sch_path: /home/noritsuna/GPS/xschem/tb_afc.sch
**.subckt tb_afc
VDD vdd 0 3.3
VD0 d0 0 0
VD1 d1 0 0
VD2 d2 0 0
VD3 d3 0 0
VD4 d4 0 0
VD5 d5 0 0
VD6 d6 0 0
VD7 d7 0 0
XDAC d0 d1 d2 d3 d4 d5 d6 d7 out vdd 0 afc_dac
RLOAD out 0 100k
**** begin user architecture code
 .include /home/noritsuna/pdk/gf180mcuD/libs.tech/ngspice/design.ngspice
.lib /home/noritsuna/pdk/gf180mcuD/libs.tech/ngspice/sm141064.ngspice typical
.lib /home/noritsuna/pdk/gf180mcuD/libs.tech/ngspice/sm141064.ngspice res_typical
.lib /home/noritsuna/pdk/gf180mcuD/libs.tech/ngspice/sm141064.ngspice mimcap_typical

.control
set num_threads=1
alter VD0 dc = 0
alter VD1 dc = 0
alter VD2 dc = 0
alter VD3 dc = 0
alter VD4 dc = 0
alter VD5 dc = 0
alter VD6 dc = 0
alter VD7 dc = 0
op
echo DAC 0 $&v(out)
alter VD0 dc = 3.3
alter VD1 dc = 0
alter VD2 dc = 0
alter VD3 dc = 0
alter VD4 dc = 0
alter VD5 dc = 0
alter VD6 dc = 0
alter VD7 dc = 0
op
echo DAC 1 $&v(out)
alter VD0 dc = 0
alter VD1 dc = 3.3
alter VD2 dc = 0
alter VD3 dc = 0
alter VD4 dc = 0
alter VD5 dc = 0
alter VD6 dc = 0
alter VD7 dc = 0
op
echo DAC 2 $&v(out)
alter VD0 dc = 3.3
alter VD1 dc = 3.3
alter VD2 dc = 0
alter VD3 dc = 0
alter VD4 dc = 0
alter VD5 dc = 0
alter VD6 dc = 0
alter VD7 dc = 0
op
echo DAC 3 $&v(out)
alter VD0 dc = 0
alter VD1 dc = 0
alter VD2 dc = 3.3
alter VD3 dc = 0
alter VD4 dc = 0
alter VD5 dc = 0
alter VD6 dc = 0
alter VD7 dc = 0
op
echo DAC 4 $&v(out)
alter VD0 dc = 3.3
alter VD1 dc = 0
alter VD2 dc = 3.3
alter VD3 dc = 0
alter VD4 dc = 0
alter VD5 dc = 0
alter VD6 dc = 0
alter VD7 dc = 0
op
echo DAC 5 $&v(out)
alter VD0 dc = 0
alter VD1 dc = 3.3
alter VD2 dc = 3.3
alter VD3 dc = 0
alter VD4 dc = 0
alter VD5 dc = 0
alter VD6 dc = 0
alter VD7 dc = 0
op
echo DAC 6 $&v(out)
alter VD0 dc = 3.3
alter VD1 dc = 3.3
alter VD2 dc = 3.3
alter VD3 dc = 0
alter VD4 dc = 0
alter VD5 dc = 0
alter VD6 dc = 0
alter VD7 dc = 0
op
echo DAC 7 $&v(out)
alter VD0 dc = 0
alter VD1 dc = 0
alter VD2 dc = 0
alter VD3 dc = 3.3
alter VD4 dc = 0
alter VD5 dc = 0
alter VD6 dc = 0
alter VD7 dc = 0
op
echo DAC 8 $&v(out)
alter VD0 dc = 3.3
alter VD1 dc = 0
alter VD2 dc = 0
alter VD3 dc = 3.3
alter VD4 dc = 0
alter VD5 dc = 0
alter VD6 dc = 0
alter VD7 dc = 0
op
echo DAC 9 $&v(out)
alter VD0 dc = 0
alter VD1 dc = 3.3
alter VD2 dc = 0
alter VD3 dc = 3.3
alter VD4 dc = 0
alter VD5 dc = 0
alter VD6 dc = 0
alter VD7 dc = 0
op
echo DAC 10 $&v(out)
alter VD0 dc = 3.3
alter VD1 dc = 3.3
alter VD2 dc = 0
alter VD3 dc = 3.3
alter VD4 dc = 0
alter VD5 dc = 0
alter VD6 dc = 0
alter VD7 dc = 0
op
echo DAC 11 $&v(out)
alter VD0 dc = 0
alter VD1 dc = 0
alter VD2 dc = 3.3
alter VD3 dc = 3.3
alter VD4 dc = 0
alter VD5 dc = 0
alter VD6 dc = 0
alter VD7 dc = 0
op
echo DAC 12 $&v(out)
alter VD0 dc = 3.3
alter VD1 dc = 0
alter VD2 dc = 3.3
alter VD3 dc = 3.3
alter VD4 dc = 0
alter VD5 dc = 0
alter VD6 dc = 0
alter VD7 dc = 0
op
echo DAC 13 $&v(out)
alter VD0 dc = 0
alter VD1 dc = 3.3
alter VD2 dc = 3.3
alter VD3 dc = 3.3
alter VD4 dc = 0
alter VD5 dc = 0
alter VD6 dc = 0
alter VD7 dc = 0
op
echo DAC 14 $&v(out)
alter VD0 dc = 3.3
alter VD1 dc = 3.3
alter VD2 dc = 3.3
alter VD3 dc = 3.3
alter VD4 dc = 0
alter VD5 dc = 0
alter VD6 dc = 0
alter VD7 dc = 0
op
echo DAC 15 $&v(out)
alter VD0 dc = 0
alter VD1 dc = 0
alter VD2 dc = 0
alter VD3 dc = 0
alter VD4 dc = 3.3
alter VD5 dc = 0
alter VD6 dc = 0
alter VD7 dc = 0
op
echo DAC 16 $&v(out)
alter VD0 dc = 3.3
alter VD1 dc = 0
alter VD2 dc = 0
alter VD3 dc = 0
alter VD4 dc = 3.3
alter VD5 dc = 0
alter VD6 dc = 0
alter VD7 dc = 0
op
echo DAC 17 $&v(out)
alter VD0 dc = 0
alter VD1 dc = 3.3
alter VD2 dc = 0
alter VD3 dc = 0
alter VD4 dc = 3.3
alter VD5 dc = 0
alter VD6 dc = 0
alter VD7 dc = 0
op
echo DAC 18 $&v(out)
alter VD0 dc = 3.3
alter VD1 dc = 3.3
alter VD2 dc = 0
alter VD3 dc = 0
alter VD4 dc = 3.3
alter VD5 dc = 0
alter VD6 dc = 0
alter VD7 dc = 0
op
echo DAC 19 $&v(out)
alter VD0 dc = 0
alter VD1 dc = 0
alter VD2 dc = 3.3
alter VD3 dc = 0
alter VD4 dc = 3.3
alter VD5 dc = 0
alter VD6 dc = 0
alter VD7 dc = 0
op
echo DAC 20 $&v(out)
alter VD0 dc = 3.3
alter VD1 dc = 0
alter VD2 dc = 3.3
alter VD3 dc = 0
alter VD4 dc = 3.3
alter VD5 dc = 0
alter VD6 dc = 0
alter VD7 dc = 0
op
echo DAC 21 $&v(out)
alter VD0 dc = 0
alter VD1 dc = 3.3
alter VD2 dc = 3.3
alter VD3 dc = 0
alter VD4 dc = 3.3
alter VD5 dc = 0
alter VD6 dc = 0
alter VD7 dc = 0
op
echo DAC 22 $&v(out)
alter VD0 dc = 3.3
alter VD1 dc = 3.3
alter VD2 dc = 3.3
alter VD3 dc = 0
alter VD4 dc = 3.3
alter VD5 dc = 0
alter VD6 dc = 0
alter VD7 dc = 0
op
echo DAC 23 $&v(out)
alter VD0 dc = 0
alter VD1 dc = 0
alter VD2 dc = 0
alter VD3 dc = 3.3
alter VD4 dc = 3.3
alter VD5 dc = 0
alter VD6 dc = 0
alter VD7 dc = 0
op
echo DAC 24 $&v(out)
alter VD0 dc = 3.3
alter VD1 dc = 0
alter VD2 dc = 0
alter VD3 dc = 3.3
alter VD4 dc = 3.3
alter VD5 dc = 0
alter VD6 dc = 0
alter VD7 dc = 0
op
echo DAC 25 $&v(out)
alter VD0 dc = 0
alter VD1 dc = 3.3
alter VD2 dc = 0
alter VD3 dc = 3.3
alter VD4 dc = 3.3
alter VD5 dc = 0
alter VD6 dc = 0
alter VD7 dc = 0
op
echo DAC 26 $&v(out)
alter VD0 dc = 3.3
alter VD1 dc = 3.3
alter VD2 dc = 0
alter VD3 dc = 3.3
alter VD4 dc = 3.3
alter VD5 dc = 0
alter VD6 dc = 0
alter VD7 dc = 0
op
echo DAC 27 $&v(out)
alter VD0 dc = 0
alter VD1 dc = 0
alter VD2 dc = 3.3
alter VD3 dc = 3.3
alter VD4 dc = 3.3
alter VD5 dc = 0
alter VD6 dc = 0
alter VD7 dc = 0
op
echo DAC 28 $&v(out)
alter VD0 dc = 3.3
alter VD1 dc = 0
alter VD2 dc = 3.3
alter VD3 dc = 3.3
alter VD4 dc = 3.3
alter VD5 dc = 0
alter VD6 dc = 0
alter VD7 dc = 0
op
echo DAC 29 $&v(out)
alter VD0 dc = 0
alter VD1 dc = 3.3
alter VD2 dc = 3.3
alter VD3 dc = 3.3
alter VD4 dc = 3.3
alter VD5 dc = 0
alter VD6 dc = 0
alter VD7 dc = 0
op
echo DAC 30 $&v(out)
alter VD0 dc = 3.3
alter VD1 dc = 3.3
alter VD2 dc = 3.3
alter VD3 dc = 3.3
alter VD4 dc = 3.3
alter VD5 dc = 0
alter VD6 dc = 0
alter VD7 dc = 0
op
echo DAC 31 $&v(out)
alter VD0 dc = 0
alter VD1 dc = 0
alter VD2 dc = 0
alter VD3 dc = 0
alter VD4 dc = 0
alter VD5 dc = 3.3
alter VD6 dc = 0
alter VD7 dc = 0
op
echo DAC 32 $&v(out)
alter VD0 dc = 3.3
alter VD1 dc = 0
alter VD2 dc = 0
alter VD3 dc = 0
alter VD4 dc = 0
alter VD5 dc = 3.3
alter VD6 dc = 0
alter VD7 dc = 0
op
echo DAC 33 $&v(out)
alter VD0 dc = 0
alter VD1 dc = 3.3
alter VD2 dc = 0
alter VD3 dc = 0
alter VD4 dc = 0
alter VD5 dc = 3.3
alter VD6 dc = 0
alter VD7 dc = 0
op
echo DAC 34 $&v(out)
alter VD0 dc = 3.3
alter VD1 dc = 3.3
alter VD2 dc = 0
alter VD3 dc = 0
alter VD4 dc = 0
alter VD5 dc = 3.3
alter VD6 dc = 0
alter VD7 dc = 0
op
echo DAC 35 $&v(out)
alter VD0 dc = 0
alter VD1 dc = 0
alter VD2 dc = 3.3
alter VD3 dc = 0
alter VD4 dc = 0
alter VD5 dc = 3.3
alter VD6 dc = 0
alter VD7 dc = 0
op
echo DAC 36 $&v(out)
alter VD0 dc = 3.3
alter VD1 dc = 0
alter VD2 dc = 3.3
alter VD3 dc = 0
alter VD4 dc = 0
alter VD5 dc = 3.3
alter VD6 dc = 0
alter VD7 dc = 0
op
echo DAC 37 $&v(out)
alter VD0 dc = 0
alter VD1 dc = 3.3
alter VD2 dc = 3.3
alter VD3 dc = 0
alter VD4 dc = 0
alter VD5 dc = 3.3
alter VD6 dc = 0
alter VD7 dc = 0
op
echo DAC 38 $&v(out)
alter VD0 dc = 3.3
alter VD1 dc = 3.3
alter VD2 dc = 3.3
alter VD3 dc = 0
alter VD4 dc = 0
alter VD5 dc = 3.3
alter VD6 dc = 0
alter VD7 dc = 0
op
echo DAC 39 $&v(out)
alter VD0 dc = 0
alter VD1 dc = 0
alter VD2 dc = 0
alter VD3 dc = 3.3
alter VD4 dc = 0
alter VD5 dc = 3.3
alter VD6 dc = 0
alter VD7 dc = 0
op
echo DAC 40 $&v(out)
alter VD0 dc = 3.3
alter VD1 dc = 0
alter VD2 dc = 0
alter VD3 dc = 3.3
alter VD4 dc = 0
alter VD5 dc = 3.3
alter VD6 dc = 0
alter VD7 dc = 0
op
echo DAC 41 $&v(out)
alter VD0 dc = 0
alter VD1 dc = 3.3
alter VD2 dc = 0
alter VD3 dc = 3.3
alter VD4 dc = 0
alter VD5 dc = 3.3
alter VD6 dc = 0
alter VD7 dc = 0
op
echo DAC 42 $&v(out)
alter VD0 dc = 3.3
alter VD1 dc = 3.3
alter VD2 dc = 0
alter VD3 dc = 3.3
alter VD4 dc = 0
alter VD5 dc = 3.3
alter VD6 dc = 0
alter VD7 dc = 0
op
echo DAC 43 $&v(out)
alter VD0 dc = 0
alter VD1 dc = 0
alter VD2 dc = 3.3
alter VD3 dc = 3.3
alter VD4 dc = 0
alter VD5 dc = 3.3
alter VD6 dc = 0
alter VD7 dc = 0
op
echo DAC 44 $&v(out)
alter VD0 dc = 3.3
alter VD1 dc = 0
alter VD2 dc = 3.3
alter VD3 dc = 3.3
alter VD4 dc = 0
alter VD5 dc = 3.3
alter VD6 dc = 0
alter VD7 dc = 0
op
echo DAC 45 $&v(out)
alter VD0 dc = 0
alter VD1 dc = 3.3
alter VD2 dc = 3.3
alter VD3 dc = 3.3
alter VD4 dc = 0
alter VD5 dc = 3.3
alter VD6 dc = 0
alter VD7 dc = 0
op
echo DAC 46 $&v(out)
alter VD0 dc = 3.3
alter VD1 dc = 3.3
alter VD2 dc = 3.3
alter VD3 dc = 3.3
alter VD4 dc = 0
alter VD5 dc = 3.3
alter VD6 dc = 0
alter VD7 dc = 0
op
echo DAC 47 $&v(out)
alter VD0 dc = 0
alter VD1 dc = 0
alter VD2 dc = 0
alter VD3 dc = 0
alter VD4 dc = 3.3
alter VD5 dc = 3.3
alter VD6 dc = 0
alter VD7 dc = 0
op
echo DAC 48 $&v(out)
alter VD0 dc = 3.3
alter VD1 dc = 0
alter VD2 dc = 0
alter VD3 dc = 0
alter VD4 dc = 3.3
alter VD5 dc = 3.3
alter VD6 dc = 0
alter VD7 dc = 0
op
echo DAC 49 $&v(out)
alter VD0 dc = 0
alter VD1 dc = 3.3
alter VD2 dc = 0
alter VD3 dc = 0
alter VD4 dc = 3.3
alter VD5 dc = 3.3
alter VD6 dc = 0
alter VD7 dc = 0
op
echo DAC 50 $&v(out)
alter VD0 dc = 3.3
alter VD1 dc = 3.3
alter VD2 dc = 0
alter VD3 dc = 0
alter VD4 dc = 3.3
alter VD5 dc = 3.3
alter VD6 dc = 0
alter VD7 dc = 0
op
echo DAC 51 $&v(out)
alter VD0 dc = 0
alter VD1 dc = 0
alter VD2 dc = 3.3
alter VD3 dc = 0
alter VD4 dc = 3.3
alter VD5 dc = 3.3
alter VD6 dc = 0
alter VD7 dc = 0
op
echo DAC 52 $&v(out)
alter VD0 dc = 3.3
alter VD1 dc = 0
alter VD2 dc = 3.3
alter VD3 dc = 0
alter VD4 dc = 3.3
alter VD5 dc = 3.3
alter VD6 dc = 0
alter VD7 dc = 0
op
echo DAC 53 $&v(out)
alter VD0 dc = 0
alter VD1 dc = 3.3
alter VD2 dc = 3.3
alter VD3 dc = 0
alter VD4 dc = 3.3
alter VD5 dc = 3.3
alter VD6 dc = 0
alter VD7 dc = 0
op
echo DAC 54 $&v(out)
alter VD0 dc = 3.3
alter VD1 dc = 3.3
alter VD2 dc = 3.3
alter VD3 dc = 0
alter VD4 dc = 3.3
alter VD5 dc = 3.3
alter VD6 dc = 0
alter VD7 dc = 0
op
echo DAC 55 $&v(out)
alter VD0 dc = 0
alter VD1 dc = 0
alter VD2 dc = 0
alter VD3 dc = 3.3
alter VD4 dc = 3.3
alter VD5 dc = 3.3
alter VD6 dc = 0
alter VD7 dc = 0
op
echo DAC 56 $&v(out)
alter VD0 dc = 3.3
alter VD1 dc = 0
alter VD2 dc = 0
alter VD3 dc = 3.3
alter VD4 dc = 3.3
alter VD5 dc = 3.3
alter VD6 dc = 0
alter VD7 dc = 0
op
echo DAC 57 $&v(out)
alter VD0 dc = 0
alter VD1 dc = 3.3
alter VD2 dc = 0
alter VD3 dc = 3.3
alter VD4 dc = 3.3
alter VD5 dc = 3.3
alter VD6 dc = 0
alter VD7 dc = 0
op
echo DAC 58 $&v(out)
alter VD0 dc = 3.3
alter VD1 dc = 3.3
alter VD2 dc = 0
alter VD3 dc = 3.3
alter VD4 dc = 3.3
alter VD5 dc = 3.3
alter VD6 dc = 0
alter VD7 dc = 0
op
echo DAC 59 $&v(out)
alter VD0 dc = 0
alter VD1 dc = 0
alter VD2 dc = 3.3
alter VD3 dc = 3.3
alter VD4 dc = 3.3
alter VD5 dc = 3.3
alter VD6 dc = 0
alter VD7 dc = 0
op
echo DAC 60 $&v(out)
alter VD0 dc = 3.3
alter VD1 dc = 0
alter VD2 dc = 3.3
alter VD3 dc = 3.3
alter VD4 dc = 3.3
alter VD5 dc = 3.3
alter VD6 dc = 0
alter VD7 dc = 0
op
echo DAC 61 $&v(out)
alter VD0 dc = 0
alter VD1 dc = 3.3
alter VD2 dc = 3.3
alter VD3 dc = 3.3
alter VD4 dc = 3.3
alter VD5 dc = 3.3
alter VD6 dc = 0
alter VD7 dc = 0
op
echo DAC 62 $&v(out)
alter VD0 dc = 3.3
alter VD1 dc = 3.3
alter VD2 dc = 3.3
alter VD3 dc = 3.3
alter VD4 dc = 3.3
alter VD5 dc = 3.3
alter VD6 dc = 0
alter VD7 dc = 0
op
echo DAC 63 $&v(out)
alter VD0 dc = 0
alter VD1 dc = 0
alter VD2 dc = 0
alter VD3 dc = 0
alter VD4 dc = 0
alter VD5 dc = 0
alter VD6 dc = 3.3
alter VD7 dc = 0
op
echo DAC 64 $&v(out)
alter VD0 dc = 3.3
alter VD1 dc = 0
alter VD2 dc = 0
alter VD3 dc = 0
alter VD4 dc = 0
alter VD5 dc = 0
alter VD6 dc = 3.3
alter VD7 dc = 0
op
echo DAC 65 $&v(out)
alter VD0 dc = 0
alter VD1 dc = 3.3
alter VD2 dc = 0
alter VD3 dc = 0
alter VD4 dc = 0
alter VD5 dc = 0
alter VD6 dc = 3.3
alter VD7 dc = 0
op
echo DAC 66 $&v(out)
alter VD0 dc = 3.3
alter VD1 dc = 3.3
alter VD2 dc = 0
alter VD3 dc = 0
alter VD4 dc = 0
alter VD5 dc = 0
alter VD6 dc = 3.3
alter VD7 dc = 0
op
echo DAC 67 $&v(out)
alter VD0 dc = 0
alter VD1 dc = 0
alter VD2 dc = 3.3
alter VD3 dc = 0
alter VD4 dc = 0
alter VD5 dc = 0
alter VD6 dc = 3.3
alter VD7 dc = 0
op
echo DAC 68 $&v(out)
alter VD0 dc = 3.3
alter VD1 dc = 0
alter VD2 dc = 3.3
alter VD3 dc = 0
alter VD4 dc = 0
alter VD5 dc = 0
alter VD6 dc = 3.3
alter VD7 dc = 0
op
echo DAC 69 $&v(out)
alter VD0 dc = 0
alter VD1 dc = 3.3
alter VD2 dc = 3.3
alter VD3 dc = 0
alter VD4 dc = 0
alter VD5 dc = 0
alter VD6 dc = 3.3
alter VD7 dc = 0
op
echo DAC 70 $&v(out)
alter VD0 dc = 3.3
alter VD1 dc = 3.3
alter VD2 dc = 3.3
alter VD3 dc = 0
alter VD4 dc = 0
alter VD5 dc = 0
alter VD6 dc = 3.3
alter VD7 dc = 0
op
echo DAC 71 $&v(out)
alter VD0 dc = 0
alter VD1 dc = 0
alter VD2 dc = 0
alter VD3 dc = 3.3
alter VD4 dc = 0
alter VD5 dc = 0
alter VD6 dc = 3.3
alter VD7 dc = 0
op
echo DAC 72 $&v(out)
alter VD0 dc = 3.3
alter VD1 dc = 0
alter VD2 dc = 0
alter VD3 dc = 3.3
alter VD4 dc = 0
alter VD5 dc = 0
alter VD6 dc = 3.3
alter VD7 dc = 0
op
echo DAC 73 $&v(out)
alter VD0 dc = 0
alter VD1 dc = 3.3
alter VD2 dc = 0
alter VD3 dc = 3.3
alter VD4 dc = 0
alter VD5 dc = 0
alter VD6 dc = 3.3
alter VD7 dc = 0
op
echo DAC 74 $&v(out)
alter VD0 dc = 3.3
alter VD1 dc = 3.3
alter VD2 dc = 0
alter VD3 dc = 3.3
alter VD4 dc = 0
alter VD5 dc = 0
alter VD6 dc = 3.3
alter VD7 dc = 0
op
echo DAC 75 $&v(out)
alter VD0 dc = 0
alter VD1 dc = 0
alter VD2 dc = 3.3
alter VD3 dc = 3.3
alter VD4 dc = 0
alter VD5 dc = 0
alter VD6 dc = 3.3
alter VD7 dc = 0
op
echo DAC 76 $&v(out)
alter VD0 dc = 3.3
alter VD1 dc = 0
alter VD2 dc = 3.3
alter VD3 dc = 3.3
alter VD4 dc = 0
alter VD5 dc = 0
alter VD6 dc = 3.3
alter VD7 dc = 0
op
echo DAC 77 $&v(out)
alter VD0 dc = 0
alter VD1 dc = 3.3
alter VD2 dc = 3.3
alter VD3 dc = 3.3
alter VD4 dc = 0
alter VD5 dc = 0
alter VD6 dc = 3.3
alter VD7 dc = 0
op
echo DAC 78 $&v(out)
alter VD0 dc = 3.3
alter VD1 dc = 3.3
alter VD2 dc = 3.3
alter VD3 dc = 3.3
alter VD4 dc = 0
alter VD5 dc = 0
alter VD6 dc = 3.3
alter VD7 dc = 0
op
echo DAC 79 $&v(out)
alter VD0 dc = 0
alter VD1 dc = 0
alter VD2 dc = 0
alter VD3 dc = 0
alter VD4 dc = 3.3
alter VD5 dc = 0
alter VD6 dc = 3.3
alter VD7 dc = 0
op
echo DAC 80 $&v(out)
alter VD0 dc = 3.3
alter VD1 dc = 0
alter VD2 dc = 0
alter VD3 dc = 0
alter VD4 dc = 3.3
alter VD5 dc = 0
alter VD6 dc = 3.3
alter VD7 dc = 0
op
echo DAC 81 $&v(out)
alter VD0 dc = 0
alter VD1 dc = 3.3
alter VD2 dc = 0
alter VD3 dc = 0
alter VD4 dc = 3.3
alter VD5 dc = 0
alter VD6 dc = 3.3
alter VD7 dc = 0
op
echo DAC 82 $&v(out)
alter VD0 dc = 3.3
alter VD1 dc = 3.3
alter VD2 dc = 0
alter VD3 dc = 0
alter VD4 dc = 3.3
alter VD5 dc = 0
alter VD6 dc = 3.3
alter VD7 dc = 0
op
echo DAC 83 $&v(out)
alter VD0 dc = 0
alter VD1 dc = 0
alter VD2 dc = 3.3
alter VD3 dc = 0
alter VD4 dc = 3.3
alter VD5 dc = 0
alter VD6 dc = 3.3
alter VD7 dc = 0
op
echo DAC 84 $&v(out)
alter VD0 dc = 3.3
alter VD1 dc = 0
alter VD2 dc = 3.3
alter VD3 dc = 0
alter VD4 dc = 3.3
alter VD5 dc = 0
alter VD6 dc = 3.3
alter VD7 dc = 0
op
echo DAC 85 $&v(out)
alter VD0 dc = 0
alter VD1 dc = 3.3
alter VD2 dc = 3.3
alter VD3 dc = 0
alter VD4 dc = 3.3
alter VD5 dc = 0
alter VD6 dc = 3.3
alter VD7 dc = 0
op
echo DAC 86 $&v(out)
alter VD0 dc = 3.3
alter VD1 dc = 3.3
alter VD2 dc = 3.3
alter VD3 dc = 0
alter VD4 dc = 3.3
alter VD5 dc = 0
alter VD6 dc = 3.3
alter VD7 dc = 0
op
echo DAC 87 $&v(out)
alter VD0 dc = 0
alter VD1 dc = 0
alter VD2 dc = 0
alter VD3 dc = 3.3
alter VD4 dc = 3.3
alter VD5 dc = 0
alter VD6 dc = 3.3
alter VD7 dc = 0
op
echo DAC 88 $&v(out)
alter VD0 dc = 3.3
alter VD1 dc = 0
alter VD2 dc = 0
alter VD3 dc = 3.3
alter VD4 dc = 3.3
alter VD5 dc = 0
alter VD6 dc = 3.3
alter VD7 dc = 0
op
echo DAC 89 $&v(out)
alter VD0 dc = 0
alter VD1 dc = 3.3
alter VD2 dc = 0
alter VD3 dc = 3.3
alter VD4 dc = 3.3
alter VD5 dc = 0
alter VD6 dc = 3.3
alter VD7 dc = 0
op
echo DAC 90 $&v(out)
alter VD0 dc = 3.3
alter VD1 dc = 3.3
alter VD2 dc = 0
alter VD3 dc = 3.3
alter VD4 dc = 3.3
alter VD5 dc = 0
alter VD6 dc = 3.3
alter VD7 dc = 0
op
echo DAC 91 $&v(out)
alter VD0 dc = 0
alter VD1 dc = 0
alter VD2 dc = 3.3
alter VD3 dc = 3.3
alter VD4 dc = 3.3
alter VD5 dc = 0
alter VD6 dc = 3.3
alter VD7 dc = 0
op
echo DAC 92 $&v(out)
alter VD0 dc = 3.3
alter VD1 dc = 0
alter VD2 dc = 3.3
alter VD3 dc = 3.3
alter VD4 dc = 3.3
alter VD5 dc = 0
alter VD6 dc = 3.3
alter VD7 dc = 0
op
echo DAC 93 $&v(out)
alter VD0 dc = 0
alter VD1 dc = 3.3
alter VD2 dc = 3.3
alter VD3 dc = 3.3
alter VD4 dc = 3.3
alter VD5 dc = 0
alter VD6 dc = 3.3
alter VD7 dc = 0
op
echo DAC 94 $&v(out)
alter VD0 dc = 3.3
alter VD1 dc = 3.3
alter VD2 dc = 3.3
alter VD3 dc = 3.3
alter VD4 dc = 3.3
alter VD5 dc = 0
alter VD6 dc = 3.3
alter VD7 dc = 0
op
echo DAC 95 $&v(out)
alter VD0 dc = 0
alter VD1 dc = 0
alter VD2 dc = 0
alter VD3 dc = 0
alter VD4 dc = 0
alter VD5 dc = 3.3
alter VD6 dc = 3.3
alter VD7 dc = 0
op
echo DAC 96 $&v(out)
alter VD0 dc = 3.3
alter VD1 dc = 0
alter VD2 dc = 0
alter VD3 dc = 0
alter VD4 dc = 0
alter VD5 dc = 3.3
alter VD6 dc = 3.3
alter VD7 dc = 0
op
echo DAC 97 $&v(out)
alter VD0 dc = 0
alter VD1 dc = 3.3
alter VD2 dc = 0
alter VD3 dc = 0
alter VD4 dc = 0
alter VD5 dc = 3.3
alter VD6 dc = 3.3
alter VD7 dc = 0
op
echo DAC 98 $&v(out)
alter VD0 dc = 3.3
alter VD1 dc = 3.3
alter VD2 dc = 0
alter VD3 dc = 0
alter VD4 dc = 0
alter VD5 dc = 3.3
alter VD6 dc = 3.3
alter VD7 dc = 0
op
echo DAC 99 $&v(out)
alter VD0 dc = 0
alter VD1 dc = 0
alter VD2 dc = 3.3
alter VD3 dc = 0
alter VD4 dc = 0
alter VD5 dc = 3.3
alter VD6 dc = 3.3
alter VD7 dc = 0
op
echo DAC 100 $&v(out)
alter VD0 dc = 3.3
alter VD1 dc = 0
alter VD2 dc = 3.3
alter VD3 dc = 0
alter VD4 dc = 0
alter VD5 dc = 3.3
alter VD6 dc = 3.3
alter VD7 dc = 0
op
echo DAC 101 $&v(out)
alter VD0 dc = 0
alter VD1 dc = 3.3
alter VD2 dc = 3.3
alter VD3 dc = 0
alter VD4 dc = 0
alter VD5 dc = 3.3
alter VD6 dc = 3.3
alter VD7 dc = 0
op
echo DAC 102 $&v(out)
alter VD0 dc = 3.3
alter VD1 dc = 3.3
alter VD2 dc = 3.3
alter VD3 dc = 0
alter VD4 dc = 0
alter VD5 dc = 3.3
alter VD6 dc = 3.3
alter VD7 dc = 0
op
echo DAC 103 $&v(out)
alter VD0 dc = 0
alter VD1 dc = 0
alter VD2 dc = 0
alter VD3 dc = 3.3
alter VD4 dc = 0
alter VD5 dc = 3.3
alter VD6 dc = 3.3
alter VD7 dc = 0
op
echo DAC 104 $&v(out)
alter VD0 dc = 3.3
alter VD1 dc = 0
alter VD2 dc = 0
alter VD3 dc = 3.3
alter VD4 dc = 0
alter VD5 dc = 3.3
alter VD6 dc = 3.3
alter VD7 dc = 0
op
echo DAC 105 $&v(out)
alter VD0 dc = 0
alter VD1 dc = 3.3
alter VD2 dc = 0
alter VD3 dc = 3.3
alter VD4 dc = 0
alter VD5 dc = 3.3
alter VD6 dc = 3.3
alter VD7 dc = 0
op
echo DAC 106 $&v(out)
alter VD0 dc = 3.3
alter VD1 dc = 3.3
alter VD2 dc = 0
alter VD3 dc = 3.3
alter VD4 dc = 0
alter VD5 dc = 3.3
alter VD6 dc = 3.3
alter VD7 dc = 0
op
echo DAC 107 $&v(out)
alter VD0 dc = 0
alter VD1 dc = 0
alter VD2 dc = 3.3
alter VD3 dc = 3.3
alter VD4 dc = 0
alter VD5 dc = 3.3
alter VD6 dc = 3.3
alter VD7 dc = 0
op
echo DAC 108 $&v(out)
alter VD0 dc = 3.3
alter VD1 dc = 0
alter VD2 dc = 3.3
alter VD3 dc = 3.3
alter VD4 dc = 0
alter VD5 dc = 3.3
alter VD6 dc = 3.3
alter VD7 dc = 0
op
echo DAC 109 $&v(out)
alter VD0 dc = 0
alter VD1 dc = 3.3
alter VD2 dc = 3.3
alter VD3 dc = 3.3
alter VD4 dc = 0
alter VD5 dc = 3.3
alter VD6 dc = 3.3
alter VD7 dc = 0
op
echo DAC 110 $&v(out)
alter VD0 dc = 3.3
alter VD1 dc = 3.3
alter VD2 dc = 3.3
alter VD3 dc = 3.3
alter VD4 dc = 0
alter VD5 dc = 3.3
alter VD6 dc = 3.3
alter VD7 dc = 0
op
echo DAC 111 $&v(out)
alter VD0 dc = 0
alter VD1 dc = 0
alter VD2 dc = 0
alter VD3 dc = 0
alter VD4 dc = 3.3
alter VD5 dc = 3.3
alter VD6 dc = 3.3
alter VD7 dc = 0
op
echo DAC 112 $&v(out)
alter VD0 dc = 3.3
alter VD1 dc = 0
alter VD2 dc = 0
alter VD3 dc = 0
alter VD4 dc = 3.3
alter VD5 dc = 3.3
alter VD6 dc = 3.3
alter VD7 dc = 0
op
echo DAC 113 $&v(out)
alter VD0 dc = 0
alter VD1 dc = 3.3
alter VD2 dc = 0
alter VD3 dc = 0
alter VD4 dc = 3.3
alter VD5 dc = 3.3
alter VD6 dc = 3.3
alter VD7 dc = 0
op
echo DAC 114 $&v(out)
alter VD0 dc = 3.3
alter VD1 dc = 3.3
alter VD2 dc = 0
alter VD3 dc = 0
alter VD4 dc = 3.3
alter VD5 dc = 3.3
alter VD6 dc = 3.3
alter VD7 dc = 0
op
echo DAC 115 $&v(out)
alter VD0 dc = 0
alter VD1 dc = 0
alter VD2 dc = 3.3
alter VD3 dc = 0
alter VD4 dc = 3.3
alter VD5 dc = 3.3
alter VD6 dc = 3.3
alter VD7 dc = 0
op
echo DAC 116 $&v(out)
alter VD0 dc = 3.3
alter VD1 dc = 0
alter VD2 dc = 3.3
alter VD3 dc = 0
alter VD4 dc = 3.3
alter VD5 dc = 3.3
alter VD6 dc = 3.3
alter VD7 dc = 0
op
echo DAC 117 $&v(out)
alter VD0 dc = 0
alter VD1 dc = 3.3
alter VD2 dc = 3.3
alter VD3 dc = 0
alter VD4 dc = 3.3
alter VD5 dc = 3.3
alter VD6 dc = 3.3
alter VD7 dc = 0
op
echo DAC 118 $&v(out)
alter VD0 dc = 3.3
alter VD1 dc = 3.3
alter VD2 dc = 3.3
alter VD3 dc = 0
alter VD4 dc = 3.3
alter VD5 dc = 3.3
alter VD6 dc = 3.3
alter VD7 dc = 0
op
echo DAC 119 $&v(out)
alter VD0 dc = 0
alter VD1 dc = 0
alter VD2 dc = 0
alter VD3 dc = 3.3
alter VD4 dc = 3.3
alter VD5 dc = 3.3
alter VD6 dc = 3.3
alter VD7 dc = 0
op
echo DAC 120 $&v(out)
alter VD0 dc = 3.3
alter VD1 dc = 0
alter VD2 dc = 0
alter VD3 dc = 3.3
alter VD4 dc = 3.3
alter VD5 dc = 3.3
alter VD6 dc = 3.3
alter VD7 dc = 0
op
echo DAC 121 $&v(out)
alter VD0 dc = 0
alter VD1 dc = 3.3
alter VD2 dc = 0
alter VD3 dc = 3.3
alter VD4 dc = 3.3
alter VD5 dc = 3.3
alter VD6 dc = 3.3
alter VD7 dc = 0
op
echo DAC 122 $&v(out)
alter VD0 dc = 3.3
alter VD1 dc = 3.3
alter VD2 dc = 0
alter VD3 dc = 3.3
alter VD4 dc = 3.3
alter VD5 dc = 3.3
alter VD6 dc = 3.3
alter VD7 dc = 0
op
echo DAC 123 $&v(out)
alter VD0 dc = 0
alter VD1 dc = 0
alter VD2 dc = 3.3
alter VD3 dc = 3.3
alter VD4 dc = 3.3
alter VD5 dc = 3.3
alter VD6 dc = 3.3
alter VD7 dc = 0
op
echo DAC 124 $&v(out)
alter VD0 dc = 3.3
alter VD1 dc = 0
alter VD2 dc = 3.3
alter VD3 dc = 3.3
alter VD4 dc = 3.3
alter VD5 dc = 3.3
alter VD6 dc = 3.3
alter VD7 dc = 0
op
echo DAC 125 $&v(out)
alter VD0 dc = 0
alter VD1 dc = 3.3
alter VD2 dc = 3.3
alter VD3 dc = 3.3
alter VD4 dc = 3.3
alter VD5 dc = 3.3
alter VD6 dc = 3.3
alter VD7 dc = 0
op
echo DAC 126 $&v(out)
alter VD0 dc = 3.3
alter VD1 dc = 3.3
alter VD2 dc = 3.3
alter VD3 dc = 3.3
alter VD4 dc = 3.3
alter VD5 dc = 3.3
alter VD6 dc = 3.3
alter VD7 dc = 0
op
echo DAC 127 $&v(out)
alter VD0 dc = 0
alter VD1 dc = 0
alter VD2 dc = 0
alter VD3 dc = 0
alter VD4 dc = 0
alter VD5 dc = 0
alter VD6 dc = 0
alter VD7 dc = 3.3
op
echo DAC 128 $&v(out)
alter VD0 dc = 3.3
alter VD1 dc = 0
alter VD2 dc = 0
alter VD3 dc = 0
alter VD4 dc = 0
alter VD5 dc = 0
alter VD6 dc = 0
alter VD7 dc = 3.3
op
echo DAC 129 $&v(out)
alter VD0 dc = 0
alter VD1 dc = 3.3
alter VD2 dc = 0
alter VD3 dc = 0
alter VD4 dc = 0
alter VD5 dc = 0
alter VD6 dc = 0
alter VD7 dc = 3.3
op
echo DAC 130 $&v(out)
alter VD0 dc = 3.3
alter VD1 dc = 3.3
alter VD2 dc = 0
alter VD3 dc = 0
alter VD4 dc = 0
alter VD5 dc = 0
alter VD6 dc = 0
alter VD7 dc = 3.3
op
echo DAC 131 $&v(out)
alter VD0 dc = 0
alter VD1 dc = 0
alter VD2 dc = 3.3
alter VD3 dc = 0
alter VD4 dc = 0
alter VD5 dc = 0
alter VD6 dc = 0
alter VD7 dc = 3.3
op
echo DAC 132 $&v(out)
alter VD0 dc = 3.3
alter VD1 dc = 0
alter VD2 dc = 3.3
alter VD3 dc = 0
alter VD4 dc = 0
alter VD5 dc = 0
alter VD6 dc = 0
alter VD7 dc = 3.3
op
echo DAC 133 $&v(out)
alter VD0 dc = 0
alter VD1 dc = 3.3
alter VD2 dc = 3.3
alter VD3 dc = 0
alter VD4 dc = 0
alter VD5 dc = 0
alter VD6 dc = 0
alter VD7 dc = 3.3
op
echo DAC 134 $&v(out)
alter VD0 dc = 3.3
alter VD1 dc = 3.3
alter VD2 dc = 3.3
alter VD3 dc = 0
alter VD4 dc = 0
alter VD5 dc = 0
alter VD6 dc = 0
alter VD7 dc = 3.3
op
echo DAC 135 $&v(out)
alter VD0 dc = 0
alter VD1 dc = 0
alter VD2 dc = 0
alter VD3 dc = 3.3
alter VD4 dc = 0
alter VD5 dc = 0
alter VD6 dc = 0
alter VD7 dc = 3.3
op
echo DAC 136 $&v(out)
alter VD0 dc = 3.3
alter VD1 dc = 0
alter VD2 dc = 0
alter VD3 dc = 3.3
alter VD4 dc = 0
alter VD5 dc = 0
alter VD6 dc = 0
alter VD7 dc = 3.3
op
echo DAC 137 $&v(out)
alter VD0 dc = 0
alter VD1 dc = 3.3
alter VD2 dc = 0
alter VD3 dc = 3.3
alter VD4 dc = 0
alter VD5 dc = 0
alter VD6 dc = 0
alter VD7 dc = 3.3
op
echo DAC 138 $&v(out)
alter VD0 dc = 3.3
alter VD1 dc = 3.3
alter VD2 dc = 0
alter VD3 dc = 3.3
alter VD4 dc = 0
alter VD5 dc = 0
alter VD6 dc = 0
alter VD7 dc = 3.3
op
echo DAC 139 $&v(out)
alter VD0 dc = 0
alter VD1 dc = 0
alter VD2 dc = 3.3
alter VD3 dc = 3.3
alter VD4 dc = 0
alter VD5 dc = 0
alter VD6 dc = 0
alter VD7 dc = 3.3
op
echo DAC 140 $&v(out)
alter VD0 dc = 3.3
alter VD1 dc = 0
alter VD2 dc = 3.3
alter VD3 dc = 3.3
alter VD4 dc = 0
alter VD5 dc = 0
alter VD6 dc = 0
alter VD7 dc = 3.3
op
echo DAC 141 $&v(out)
alter VD0 dc = 0
alter VD1 dc = 3.3
alter VD2 dc = 3.3
alter VD3 dc = 3.3
alter VD4 dc = 0
alter VD5 dc = 0
alter VD6 dc = 0
alter VD7 dc = 3.3
op
echo DAC 142 $&v(out)
alter VD0 dc = 3.3
alter VD1 dc = 3.3
alter VD2 dc = 3.3
alter VD3 dc = 3.3
alter VD4 dc = 0
alter VD5 dc = 0
alter VD6 dc = 0
alter VD7 dc = 3.3
op
echo DAC 143 $&v(out)
alter VD0 dc = 0
alter VD1 dc = 0
alter VD2 dc = 0
alter VD3 dc = 0
alter VD4 dc = 3.3
alter VD5 dc = 0
alter VD6 dc = 0
alter VD7 dc = 3.3
op
echo DAC 144 $&v(out)
alter VD0 dc = 3.3
alter VD1 dc = 0
alter VD2 dc = 0
alter VD3 dc = 0
alter VD4 dc = 3.3
alter VD5 dc = 0
alter VD6 dc = 0
alter VD7 dc = 3.3
op
echo DAC 145 $&v(out)
alter VD0 dc = 0
alter VD1 dc = 3.3
alter VD2 dc = 0
alter VD3 dc = 0
alter VD4 dc = 3.3
alter VD5 dc = 0
alter VD6 dc = 0
alter VD7 dc = 3.3
op
echo DAC 146 $&v(out)
alter VD0 dc = 3.3
alter VD1 dc = 3.3
alter VD2 dc = 0
alter VD3 dc = 0
alter VD4 dc = 3.3
alter VD5 dc = 0
alter VD6 dc = 0
alter VD7 dc = 3.3
op
echo DAC 147 $&v(out)
alter VD0 dc = 0
alter VD1 dc = 0
alter VD2 dc = 3.3
alter VD3 dc = 0
alter VD4 dc = 3.3
alter VD5 dc = 0
alter VD6 dc = 0
alter VD7 dc = 3.3
op
echo DAC 148 $&v(out)
alter VD0 dc = 3.3
alter VD1 dc = 0
alter VD2 dc = 3.3
alter VD3 dc = 0
alter VD4 dc = 3.3
alter VD5 dc = 0
alter VD6 dc = 0
alter VD7 dc = 3.3
op
echo DAC 149 $&v(out)
alter VD0 dc = 0
alter VD1 dc = 3.3
alter VD2 dc = 3.3
alter VD3 dc = 0
alter VD4 dc = 3.3
alter VD5 dc = 0
alter VD6 dc = 0
alter VD7 dc = 3.3
op
echo DAC 150 $&v(out)
alter VD0 dc = 3.3
alter VD1 dc = 3.3
alter VD2 dc = 3.3
alter VD3 dc = 0
alter VD4 dc = 3.3
alter VD5 dc = 0
alter VD6 dc = 0
alter VD7 dc = 3.3
op
echo DAC 151 $&v(out)
alter VD0 dc = 0
alter VD1 dc = 0
alter VD2 dc = 0
alter VD3 dc = 3.3
alter VD4 dc = 3.3
alter VD5 dc = 0
alter VD6 dc = 0
alter VD7 dc = 3.3
op
echo DAC 152 $&v(out)
alter VD0 dc = 3.3
alter VD1 dc = 0
alter VD2 dc = 0
alter VD3 dc = 3.3
alter VD4 dc = 3.3
alter VD5 dc = 0
alter VD6 dc = 0
alter VD7 dc = 3.3
op
echo DAC 153 $&v(out)
alter VD0 dc = 0
alter VD1 dc = 3.3
alter VD2 dc = 0
alter VD3 dc = 3.3
alter VD4 dc = 3.3
alter VD5 dc = 0
alter VD6 dc = 0
alter VD7 dc = 3.3
op
echo DAC 154 $&v(out)
alter VD0 dc = 3.3
alter VD1 dc = 3.3
alter VD2 dc = 0
alter VD3 dc = 3.3
alter VD4 dc = 3.3
alter VD5 dc = 0
alter VD6 dc = 0
alter VD7 dc = 3.3
op
echo DAC 155 $&v(out)
alter VD0 dc = 0
alter VD1 dc = 0
alter VD2 dc = 3.3
alter VD3 dc = 3.3
alter VD4 dc = 3.3
alter VD5 dc = 0
alter VD6 dc = 0
alter VD7 dc = 3.3
op
echo DAC 156 $&v(out)
alter VD0 dc = 3.3
alter VD1 dc = 0
alter VD2 dc = 3.3
alter VD3 dc = 3.3
alter VD4 dc = 3.3
alter VD5 dc = 0
alter VD6 dc = 0
alter VD7 dc = 3.3
op
echo DAC 157 $&v(out)
alter VD0 dc = 0
alter VD1 dc = 3.3
alter VD2 dc = 3.3
alter VD3 dc = 3.3
alter VD4 dc = 3.3
alter VD5 dc = 0
alter VD6 dc = 0
alter VD7 dc = 3.3
op
echo DAC 158 $&v(out)
alter VD0 dc = 3.3
alter VD1 dc = 3.3
alter VD2 dc = 3.3
alter VD3 dc = 3.3
alter VD4 dc = 3.3
alter VD5 dc = 0
alter VD6 dc = 0
alter VD7 dc = 3.3
op
echo DAC 159 $&v(out)
alter VD0 dc = 0
alter VD1 dc = 0
alter VD2 dc = 0
alter VD3 dc = 0
alter VD4 dc = 0
alter VD5 dc = 3.3
alter VD6 dc = 0
alter VD7 dc = 3.3
op
echo DAC 160 $&v(out)
alter VD0 dc = 3.3
alter VD1 dc = 0
alter VD2 dc = 0
alter VD3 dc = 0
alter VD4 dc = 0
alter VD5 dc = 3.3
alter VD6 dc = 0
alter VD7 dc = 3.3
op
echo DAC 161 $&v(out)
alter VD0 dc = 0
alter VD1 dc = 3.3
alter VD2 dc = 0
alter VD3 dc = 0
alter VD4 dc = 0
alter VD5 dc = 3.3
alter VD6 dc = 0
alter VD7 dc = 3.3
op
echo DAC 162 $&v(out)
alter VD0 dc = 3.3
alter VD1 dc = 3.3
alter VD2 dc = 0
alter VD3 dc = 0
alter VD4 dc = 0
alter VD5 dc = 3.3
alter VD6 dc = 0
alter VD7 dc = 3.3
op
echo DAC 163 $&v(out)
alter VD0 dc = 0
alter VD1 dc = 0
alter VD2 dc = 3.3
alter VD3 dc = 0
alter VD4 dc = 0
alter VD5 dc = 3.3
alter VD6 dc = 0
alter VD7 dc = 3.3
op
echo DAC 164 $&v(out)
alter VD0 dc = 3.3
alter VD1 dc = 0
alter VD2 dc = 3.3
alter VD3 dc = 0
alter VD4 dc = 0
alter VD5 dc = 3.3
alter VD6 dc = 0
alter VD7 dc = 3.3
op
echo DAC 165 $&v(out)
alter VD0 dc = 0
alter VD1 dc = 3.3
alter VD2 dc = 3.3
alter VD3 dc = 0
alter VD4 dc = 0
alter VD5 dc = 3.3
alter VD6 dc = 0
alter VD7 dc = 3.3
op
echo DAC 166 $&v(out)
alter VD0 dc = 3.3
alter VD1 dc = 3.3
alter VD2 dc = 3.3
alter VD3 dc = 0
alter VD4 dc = 0
alter VD5 dc = 3.3
alter VD6 dc = 0
alter VD7 dc = 3.3
op
echo DAC 167 $&v(out)
alter VD0 dc = 0
alter VD1 dc = 0
alter VD2 dc = 0
alter VD3 dc = 3.3
alter VD4 dc = 0
alter VD5 dc = 3.3
alter VD6 dc = 0
alter VD7 dc = 3.3
op
echo DAC 168 $&v(out)
alter VD0 dc = 3.3
alter VD1 dc = 0
alter VD2 dc = 0
alter VD3 dc = 3.3
alter VD4 dc = 0
alter VD5 dc = 3.3
alter VD6 dc = 0
alter VD7 dc = 3.3
op
echo DAC 169 $&v(out)
alter VD0 dc = 0
alter VD1 dc = 3.3
alter VD2 dc = 0
alter VD3 dc = 3.3
alter VD4 dc = 0
alter VD5 dc = 3.3
alter VD6 dc = 0
alter VD7 dc = 3.3
op
echo DAC 170 $&v(out)
alter VD0 dc = 3.3
alter VD1 dc = 3.3
alter VD2 dc = 0
alter VD3 dc = 3.3
alter VD4 dc = 0
alter VD5 dc = 3.3
alter VD6 dc = 0
alter VD7 dc = 3.3
op
echo DAC 171 $&v(out)
alter VD0 dc = 0
alter VD1 dc = 0
alter VD2 dc = 3.3
alter VD3 dc = 3.3
alter VD4 dc = 0
alter VD5 dc = 3.3
alter VD6 dc = 0
alter VD7 dc = 3.3
op
echo DAC 172 $&v(out)
alter VD0 dc = 3.3
alter VD1 dc = 0
alter VD2 dc = 3.3
alter VD3 dc = 3.3
alter VD4 dc = 0
alter VD5 dc = 3.3
alter VD6 dc = 0
alter VD7 dc = 3.3
op
echo DAC 173 $&v(out)
alter VD0 dc = 0
alter VD1 dc = 3.3
alter VD2 dc = 3.3
alter VD3 dc = 3.3
alter VD4 dc = 0
alter VD5 dc = 3.3
alter VD6 dc = 0
alter VD7 dc = 3.3
op
echo DAC 174 $&v(out)
alter VD0 dc = 3.3
alter VD1 dc = 3.3
alter VD2 dc = 3.3
alter VD3 dc = 3.3
alter VD4 dc = 0
alter VD5 dc = 3.3
alter VD6 dc = 0
alter VD7 dc = 3.3
op
echo DAC 175 $&v(out)
alter VD0 dc = 0
alter VD1 dc = 0
alter VD2 dc = 0
alter VD3 dc = 0
alter VD4 dc = 3.3
alter VD5 dc = 3.3
alter VD6 dc = 0
alter VD7 dc = 3.3
op
echo DAC 176 $&v(out)
alter VD0 dc = 3.3
alter VD1 dc = 0
alter VD2 dc = 0
alter VD3 dc = 0
alter VD4 dc = 3.3
alter VD5 dc = 3.3
alter VD6 dc = 0
alter VD7 dc = 3.3
op
echo DAC 177 $&v(out)
alter VD0 dc = 0
alter VD1 dc = 3.3
alter VD2 dc = 0
alter VD3 dc = 0
alter VD4 dc = 3.3
alter VD5 dc = 3.3
alter VD6 dc = 0
alter VD7 dc = 3.3
op
echo DAC 178 $&v(out)
alter VD0 dc = 3.3
alter VD1 dc = 3.3
alter VD2 dc = 0
alter VD3 dc = 0
alter VD4 dc = 3.3
alter VD5 dc = 3.3
alter VD6 dc = 0
alter VD7 dc = 3.3
op
echo DAC 179 $&v(out)
alter VD0 dc = 0
alter VD1 dc = 0
alter VD2 dc = 3.3
alter VD3 dc = 0
alter VD4 dc = 3.3
alter VD5 dc = 3.3
alter VD6 dc = 0
alter VD7 dc = 3.3
op
echo DAC 180 $&v(out)
alter VD0 dc = 3.3
alter VD1 dc = 0
alter VD2 dc = 3.3
alter VD3 dc = 0
alter VD4 dc = 3.3
alter VD5 dc = 3.3
alter VD6 dc = 0
alter VD7 dc = 3.3
op
echo DAC 181 $&v(out)
alter VD0 dc = 0
alter VD1 dc = 3.3
alter VD2 dc = 3.3
alter VD3 dc = 0
alter VD4 dc = 3.3
alter VD5 dc = 3.3
alter VD6 dc = 0
alter VD7 dc = 3.3
op
echo DAC 182 $&v(out)
alter VD0 dc = 3.3
alter VD1 dc = 3.3
alter VD2 dc = 3.3
alter VD3 dc = 0
alter VD4 dc = 3.3
alter VD5 dc = 3.3
alter VD6 dc = 0
alter VD7 dc = 3.3
op
echo DAC 183 $&v(out)
alter VD0 dc = 0
alter VD1 dc = 0
alter VD2 dc = 0
alter VD3 dc = 3.3
alter VD4 dc = 3.3
alter VD5 dc = 3.3
alter VD6 dc = 0
alter VD7 dc = 3.3
op
echo DAC 184 $&v(out)
alter VD0 dc = 3.3
alter VD1 dc = 0
alter VD2 dc = 0
alter VD3 dc = 3.3
alter VD4 dc = 3.3
alter VD5 dc = 3.3
alter VD6 dc = 0
alter VD7 dc = 3.3
op
echo DAC 185 $&v(out)
alter VD0 dc = 0
alter VD1 dc = 3.3
alter VD2 dc = 0
alter VD3 dc = 3.3
alter VD4 dc = 3.3
alter VD5 dc = 3.3
alter VD6 dc = 0
alter VD7 dc = 3.3
op
echo DAC 186 $&v(out)
alter VD0 dc = 3.3
alter VD1 dc = 3.3
alter VD2 dc = 0
alter VD3 dc = 3.3
alter VD4 dc = 3.3
alter VD5 dc = 3.3
alter VD6 dc = 0
alter VD7 dc = 3.3
op
echo DAC 187 $&v(out)
alter VD0 dc = 0
alter VD1 dc = 0
alter VD2 dc = 3.3
alter VD3 dc = 3.3
alter VD4 dc = 3.3
alter VD5 dc = 3.3
alter VD6 dc = 0
alter VD7 dc = 3.3
op
echo DAC 188 $&v(out)
alter VD0 dc = 3.3
alter VD1 dc = 0
alter VD2 dc = 3.3
alter VD3 dc = 3.3
alter VD4 dc = 3.3
alter VD5 dc = 3.3
alter VD6 dc = 0
alter VD7 dc = 3.3
op
echo DAC 189 $&v(out)
alter VD0 dc = 0
alter VD1 dc = 3.3
alter VD2 dc = 3.3
alter VD3 dc = 3.3
alter VD4 dc = 3.3
alter VD5 dc = 3.3
alter VD6 dc = 0
alter VD7 dc = 3.3
op
echo DAC 190 $&v(out)
alter VD0 dc = 3.3
alter VD1 dc = 3.3
alter VD2 dc = 3.3
alter VD3 dc = 3.3
alter VD4 dc = 3.3
alter VD5 dc = 3.3
alter VD6 dc = 0
alter VD7 dc = 3.3
op
echo DAC 191 $&v(out)
alter VD0 dc = 0
alter VD1 dc = 0
alter VD2 dc = 0
alter VD3 dc = 0
alter VD4 dc = 0
alter VD5 dc = 0
alter VD6 dc = 3.3
alter VD7 dc = 3.3
op
echo DAC 192 $&v(out)
alter VD0 dc = 3.3
alter VD1 dc = 0
alter VD2 dc = 0
alter VD3 dc = 0
alter VD4 dc = 0
alter VD5 dc = 0
alter VD6 dc = 3.3
alter VD7 dc = 3.3
op
echo DAC 193 $&v(out)
alter VD0 dc = 0
alter VD1 dc = 3.3
alter VD2 dc = 0
alter VD3 dc = 0
alter VD4 dc = 0
alter VD5 dc = 0
alter VD6 dc = 3.3
alter VD7 dc = 3.3
op
echo DAC 194 $&v(out)
alter VD0 dc = 3.3
alter VD1 dc = 3.3
alter VD2 dc = 0
alter VD3 dc = 0
alter VD4 dc = 0
alter VD5 dc = 0
alter VD6 dc = 3.3
alter VD7 dc = 3.3
op
echo DAC 195 $&v(out)
alter VD0 dc = 0
alter VD1 dc = 0
alter VD2 dc = 3.3
alter VD3 dc = 0
alter VD4 dc = 0
alter VD5 dc = 0
alter VD6 dc = 3.3
alter VD7 dc = 3.3
op
echo DAC 196 $&v(out)
alter VD0 dc = 3.3
alter VD1 dc = 0
alter VD2 dc = 3.3
alter VD3 dc = 0
alter VD4 dc = 0
alter VD5 dc = 0
alter VD6 dc = 3.3
alter VD7 dc = 3.3
op
echo DAC 197 $&v(out)
alter VD0 dc = 0
alter VD1 dc = 3.3
alter VD2 dc = 3.3
alter VD3 dc = 0
alter VD4 dc = 0
alter VD5 dc = 0
alter VD6 dc = 3.3
alter VD7 dc = 3.3
op
echo DAC 198 $&v(out)
alter VD0 dc = 3.3
alter VD1 dc = 3.3
alter VD2 dc = 3.3
alter VD3 dc = 0
alter VD4 dc = 0
alter VD5 dc = 0
alter VD6 dc = 3.3
alter VD7 dc = 3.3
op
echo DAC 199 $&v(out)
alter VD0 dc = 0
alter VD1 dc = 0
alter VD2 dc = 0
alter VD3 dc = 3.3
alter VD4 dc = 0
alter VD5 dc = 0
alter VD6 dc = 3.3
alter VD7 dc = 3.3
op
echo DAC 200 $&v(out)
alter VD0 dc = 3.3
alter VD1 dc = 0
alter VD2 dc = 0
alter VD3 dc = 3.3
alter VD4 dc = 0
alter VD5 dc = 0
alter VD6 dc = 3.3
alter VD7 dc = 3.3
op
echo DAC 201 $&v(out)
alter VD0 dc = 0
alter VD1 dc = 3.3
alter VD2 dc = 0
alter VD3 dc = 3.3
alter VD4 dc = 0
alter VD5 dc = 0
alter VD6 dc = 3.3
alter VD7 dc = 3.3
op
echo DAC 202 $&v(out)
alter VD0 dc = 3.3
alter VD1 dc = 3.3
alter VD2 dc = 0
alter VD3 dc = 3.3
alter VD4 dc = 0
alter VD5 dc = 0
alter VD6 dc = 3.3
alter VD7 dc = 3.3
op
echo DAC 203 $&v(out)
alter VD0 dc = 0
alter VD1 dc = 0
alter VD2 dc = 3.3
alter VD3 dc = 3.3
alter VD4 dc = 0
alter VD5 dc = 0
alter VD6 dc = 3.3
alter VD7 dc = 3.3
op
echo DAC 204 $&v(out)
alter VD0 dc = 3.3
alter VD1 dc = 0
alter VD2 dc = 3.3
alter VD3 dc = 3.3
alter VD4 dc = 0
alter VD5 dc = 0
alter VD6 dc = 3.3
alter VD7 dc = 3.3
op
echo DAC 205 $&v(out)
alter VD0 dc = 0
alter VD1 dc = 3.3
alter VD2 dc = 3.3
alter VD3 dc = 3.3
alter VD4 dc = 0
alter VD5 dc = 0
alter VD6 dc = 3.3
alter VD7 dc = 3.3
op
echo DAC 206 $&v(out)
alter VD0 dc = 3.3
alter VD1 dc = 3.3
alter VD2 dc = 3.3
alter VD3 dc = 3.3
alter VD4 dc = 0
alter VD5 dc = 0
alter VD6 dc = 3.3
alter VD7 dc = 3.3
op
echo DAC 207 $&v(out)
alter VD0 dc = 0
alter VD1 dc = 0
alter VD2 dc = 0
alter VD3 dc = 0
alter VD4 dc = 3.3
alter VD5 dc = 0
alter VD6 dc = 3.3
alter VD7 dc = 3.3
op
echo DAC 208 $&v(out)
alter VD0 dc = 3.3
alter VD1 dc = 0
alter VD2 dc = 0
alter VD3 dc = 0
alter VD4 dc = 3.3
alter VD5 dc = 0
alter VD6 dc = 3.3
alter VD7 dc = 3.3
op
echo DAC 209 $&v(out)
alter VD0 dc = 0
alter VD1 dc = 3.3
alter VD2 dc = 0
alter VD3 dc = 0
alter VD4 dc = 3.3
alter VD5 dc = 0
alter VD6 dc = 3.3
alter VD7 dc = 3.3
op
echo DAC 210 $&v(out)
alter VD0 dc = 3.3
alter VD1 dc = 3.3
alter VD2 dc = 0
alter VD3 dc = 0
alter VD4 dc = 3.3
alter VD5 dc = 0
alter VD6 dc = 3.3
alter VD7 dc = 3.3
op
echo DAC 211 $&v(out)
alter VD0 dc = 0
alter VD1 dc = 0
alter VD2 dc = 3.3
alter VD3 dc = 0
alter VD4 dc = 3.3
alter VD5 dc = 0
alter VD6 dc = 3.3
alter VD7 dc = 3.3
op
echo DAC 212 $&v(out)
alter VD0 dc = 3.3
alter VD1 dc = 0
alter VD2 dc = 3.3
alter VD3 dc = 0
alter VD4 dc = 3.3
alter VD5 dc = 0
alter VD6 dc = 3.3
alter VD7 dc = 3.3
op
echo DAC 213 $&v(out)
alter VD0 dc = 0
alter VD1 dc = 3.3
alter VD2 dc = 3.3
alter VD3 dc = 0
alter VD4 dc = 3.3
alter VD5 dc = 0
alter VD6 dc = 3.3
alter VD7 dc = 3.3
op
echo DAC 214 $&v(out)
alter VD0 dc = 3.3
alter VD1 dc = 3.3
alter VD2 dc = 3.3
alter VD3 dc = 0
alter VD4 dc = 3.3
alter VD5 dc = 0
alter VD6 dc = 3.3
alter VD7 dc = 3.3
op
echo DAC 215 $&v(out)
alter VD0 dc = 0
alter VD1 dc = 0
alter VD2 dc = 0
alter VD3 dc = 3.3
alter VD4 dc = 3.3
alter VD5 dc = 0
alter VD6 dc = 3.3
alter VD7 dc = 3.3
op
echo DAC 216 $&v(out)
alter VD0 dc = 3.3
alter VD1 dc = 0
alter VD2 dc = 0
alter VD3 dc = 3.3
alter VD4 dc = 3.3
alter VD5 dc = 0
alter VD6 dc = 3.3
alter VD7 dc = 3.3
op
echo DAC 217 $&v(out)
alter VD0 dc = 0
alter VD1 dc = 3.3
alter VD2 dc = 0
alter VD3 dc = 3.3
alter VD4 dc = 3.3
alter VD5 dc = 0
alter VD6 dc = 3.3
alter VD7 dc = 3.3
op
echo DAC 218 $&v(out)
alter VD0 dc = 3.3
alter VD1 dc = 3.3
alter VD2 dc = 0
alter VD3 dc = 3.3
alter VD4 dc = 3.3
alter VD5 dc = 0
alter VD6 dc = 3.3
alter VD7 dc = 3.3
op
echo DAC 219 $&v(out)
alter VD0 dc = 0
alter VD1 dc = 0
alter VD2 dc = 3.3
alter VD3 dc = 3.3
alter VD4 dc = 3.3
alter VD5 dc = 0
alter VD6 dc = 3.3
alter VD7 dc = 3.3
op
echo DAC 220 $&v(out)
alter VD0 dc = 3.3
alter VD1 dc = 0
alter VD2 dc = 3.3
alter VD3 dc = 3.3
alter VD4 dc = 3.3
alter VD5 dc = 0
alter VD6 dc = 3.3
alter VD7 dc = 3.3
op
echo DAC 221 $&v(out)
alter VD0 dc = 0
alter VD1 dc = 3.3
alter VD2 dc = 3.3
alter VD3 dc = 3.3
alter VD4 dc = 3.3
alter VD5 dc = 0
alter VD6 dc = 3.3
alter VD7 dc = 3.3
op
echo DAC 222 $&v(out)
alter VD0 dc = 3.3
alter VD1 dc = 3.3
alter VD2 dc = 3.3
alter VD3 dc = 3.3
alter VD4 dc = 3.3
alter VD5 dc = 0
alter VD6 dc = 3.3
alter VD7 dc = 3.3
op
echo DAC 223 $&v(out)
alter VD0 dc = 0
alter VD1 dc = 0
alter VD2 dc = 0
alter VD3 dc = 0
alter VD4 dc = 0
alter VD5 dc = 3.3
alter VD6 dc = 3.3
alter VD7 dc = 3.3
op
echo DAC 224 $&v(out)
alter VD0 dc = 3.3
alter VD1 dc = 0
alter VD2 dc = 0
alter VD3 dc = 0
alter VD4 dc = 0
alter VD5 dc = 3.3
alter VD6 dc = 3.3
alter VD7 dc = 3.3
op
echo DAC 225 $&v(out)
alter VD0 dc = 0
alter VD1 dc = 3.3
alter VD2 dc = 0
alter VD3 dc = 0
alter VD4 dc = 0
alter VD5 dc = 3.3
alter VD6 dc = 3.3
alter VD7 dc = 3.3
op
echo DAC 226 $&v(out)
alter VD0 dc = 3.3
alter VD1 dc = 3.3
alter VD2 dc = 0
alter VD3 dc = 0
alter VD4 dc = 0
alter VD5 dc = 3.3
alter VD6 dc = 3.3
alter VD7 dc = 3.3
op
echo DAC 227 $&v(out)
alter VD0 dc = 0
alter VD1 dc = 0
alter VD2 dc = 3.3
alter VD3 dc = 0
alter VD4 dc = 0
alter VD5 dc = 3.3
alter VD6 dc = 3.3
alter VD7 dc = 3.3
op
echo DAC 228 $&v(out)
alter VD0 dc = 3.3
alter VD1 dc = 0
alter VD2 dc = 3.3
alter VD3 dc = 0
alter VD4 dc = 0
alter VD5 dc = 3.3
alter VD6 dc = 3.3
alter VD7 dc = 3.3
op
echo DAC 229 $&v(out)
alter VD0 dc = 0
alter VD1 dc = 3.3
alter VD2 dc = 3.3
alter VD3 dc = 0
alter VD4 dc = 0
alter VD5 dc = 3.3
alter VD6 dc = 3.3
alter VD7 dc = 3.3
op
echo DAC 230 $&v(out)
alter VD0 dc = 3.3
alter VD1 dc = 3.3
alter VD2 dc = 3.3
alter VD3 dc = 0
alter VD4 dc = 0
alter VD5 dc = 3.3
alter VD6 dc = 3.3
alter VD7 dc = 3.3
op
echo DAC 231 $&v(out)
alter VD0 dc = 0
alter VD1 dc = 0
alter VD2 dc = 0
alter VD3 dc = 3.3
alter VD4 dc = 0
alter VD5 dc = 3.3
alter VD6 dc = 3.3
alter VD7 dc = 3.3
op
echo DAC 232 $&v(out)
alter VD0 dc = 3.3
alter VD1 dc = 0
alter VD2 dc = 0
alter VD3 dc = 3.3
alter VD4 dc = 0
alter VD5 dc = 3.3
alter VD6 dc = 3.3
alter VD7 dc = 3.3
op
echo DAC 233 $&v(out)
alter VD0 dc = 0
alter VD1 dc = 3.3
alter VD2 dc = 0
alter VD3 dc = 3.3
alter VD4 dc = 0
alter VD5 dc = 3.3
alter VD6 dc = 3.3
alter VD7 dc = 3.3
op
echo DAC 234 $&v(out)
alter VD0 dc = 3.3
alter VD1 dc = 3.3
alter VD2 dc = 0
alter VD3 dc = 3.3
alter VD4 dc = 0
alter VD5 dc = 3.3
alter VD6 dc = 3.3
alter VD7 dc = 3.3
op
echo DAC 235 $&v(out)
alter VD0 dc = 0
alter VD1 dc = 0
alter VD2 dc = 3.3
alter VD3 dc = 3.3
alter VD4 dc = 0
alter VD5 dc = 3.3
alter VD6 dc = 3.3
alter VD7 dc = 3.3
op
echo DAC 236 $&v(out)
alter VD0 dc = 3.3
alter VD1 dc = 0
alter VD2 dc = 3.3
alter VD3 dc = 3.3
alter VD4 dc = 0
alter VD5 dc = 3.3
alter VD6 dc = 3.3
alter VD7 dc = 3.3
op
echo DAC 237 $&v(out)
alter VD0 dc = 0
alter VD1 dc = 3.3
alter VD2 dc = 3.3
alter VD3 dc = 3.3
alter VD4 dc = 0
alter VD5 dc = 3.3
alter VD6 dc = 3.3
alter VD7 dc = 3.3
op
echo DAC 238 $&v(out)
alter VD0 dc = 3.3
alter VD1 dc = 3.3
alter VD2 dc = 3.3
alter VD3 dc = 3.3
alter VD4 dc = 0
alter VD5 dc = 3.3
alter VD6 dc = 3.3
alter VD7 dc = 3.3
op
echo DAC 239 $&v(out)
alter VD0 dc = 0
alter VD1 dc = 0
alter VD2 dc = 0
alter VD3 dc = 0
alter VD4 dc = 3.3
alter VD5 dc = 3.3
alter VD6 dc = 3.3
alter VD7 dc = 3.3
op
echo DAC 240 $&v(out)
alter VD0 dc = 3.3
alter VD1 dc = 0
alter VD2 dc = 0
alter VD3 dc = 0
alter VD4 dc = 3.3
alter VD5 dc = 3.3
alter VD6 dc = 3.3
alter VD7 dc = 3.3
op
echo DAC 241 $&v(out)
alter VD0 dc = 0
alter VD1 dc = 3.3
alter VD2 dc = 0
alter VD3 dc = 0
alter VD4 dc = 3.3
alter VD5 dc = 3.3
alter VD6 dc = 3.3
alter VD7 dc = 3.3
op
echo DAC 242 $&v(out)
alter VD0 dc = 3.3
alter VD1 dc = 3.3
alter VD2 dc = 0
alter VD3 dc = 0
alter VD4 dc = 3.3
alter VD5 dc = 3.3
alter VD6 dc = 3.3
alter VD7 dc = 3.3
op
echo DAC 243 $&v(out)
alter VD0 dc = 0
alter VD1 dc = 0
alter VD2 dc = 3.3
alter VD3 dc = 0
alter VD4 dc = 3.3
alter VD5 dc = 3.3
alter VD6 dc = 3.3
alter VD7 dc = 3.3
op
echo DAC 244 $&v(out)
alter VD0 dc = 3.3
alter VD1 dc = 0
alter VD2 dc = 3.3
alter VD3 dc = 0
alter VD4 dc = 3.3
alter VD5 dc = 3.3
alter VD6 dc = 3.3
alter VD7 dc = 3.3
op
echo DAC 245 $&v(out)
alter VD0 dc = 0
alter VD1 dc = 3.3
alter VD2 dc = 3.3
alter VD3 dc = 0
alter VD4 dc = 3.3
alter VD5 dc = 3.3
alter VD6 dc = 3.3
alter VD7 dc = 3.3
op
echo DAC 246 $&v(out)
alter VD0 dc = 3.3
alter VD1 dc = 3.3
alter VD2 dc = 3.3
alter VD3 dc = 0
alter VD4 dc = 3.3
alter VD5 dc = 3.3
alter VD6 dc = 3.3
alter VD7 dc = 3.3
op
echo DAC 247 $&v(out)
alter VD0 dc = 0
alter VD1 dc = 0
alter VD2 dc = 0
alter VD3 dc = 3.3
alter VD4 dc = 3.3
alter VD5 dc = 3.3
alter VD6 dc = 3.3
alter VD7 dc = 3.3
op
echo DAC 248 $&v(out)
alter VD0 dc = 3.3
alter VD1 dc = 0
alter VD2 dc = 0
alter VD3 dc = 3.3
alter VD4 dc = 3.3
alter VD5 dc = 3.3
alter VD6 dc = 3.3
alter VD7 dc = 3.3
op
echo DAC 249 $&v(out)
alter VD0 dc = 0
alter VD1 dc = 3.3
alter VD2 dc = 0
alter VD3 dc = 3.3
alter VD4 dc = 3.3
alter VD5 dc = 3.3
alter VD6 dc = 3.3
alter VD7 dc = 3.3
op
echo DAC 250 $&v(out)
alter VD0 dc = 3.3
alter VD1 dc = 3.3
alter VD2 dc = 0
alter VD3 dc = 3.3
alter VD4 dc = 3.3
alter VD5 dc = 3.3
alter VD6 dc = 3.3
alter VD7 dc = 3.3
op
echo DAC 251 $&v(out)
alter VD0 dc = 0
alter VD1 dc = 0
alter VD2 dc = 3.3
alter VD3 dc = 3.3
alter VD4 dc = 3.3
alter VD5 dc = 3.3
alter VD6 dc = 3.3
alter VD7 dc = 3.3
op
echo DAC 252 $&v(out)
alter VD0 dc = 3.3
alter VD1 dc = 0
alter VD2 dc = 3.3
alter VD3 dc = 3.3
alter VD4 dc = 3.3
alter VD5 dc = 3.3
alter VD6 dc = 3.3
alter VD7 dc = 3.3
op
echo DAC 253 $&v(out)
alter VD0 dc = 0
alter VD1 dc = 3.3
alter VD2 dc = 3.3
alter VD3 dc = 3.3
alter VD4 dc = 3.3
alter VD5 dc = 3.3
alter VD6 dc = 3.3
alter VD7 dc = 3.3
op
echo DAC 254 $&v(out)
alter VD0 dc = 3.3
alter VD1 dc = 3.3
alter VD2 dc = 3.3
alter VD3 dc = 3.3
alter VD4 dc = 3.3
alter VD5 dc = 3.3
alter VD6 dc = 3.3
alter VD7 dc = 3.3
op
echo DAC 255 $&v(out)
.endc

**** end user architecture code
**.ends

* expanding   symbol:  afc_dac.sym # of pins=11
** sym_path: /home/noritsuna/GPS/xschem/afc_dac.sym
** sch_path: /home/noritsuna/GPS/xschem/afc_dac.sch
.subckt afc_dac D0 D1 D2 D3 D4 D5 D6 D7 OUT VDD VSS
*.ipin D0
*.ipin D1
*.ipin D2
*.ipin D3
*.ipin D4
*.ipin D5
*.ipin D6
*.ipin D7
*.opin OUT
*.iopin VDD
*.iopin VSS
XRT VSS n0 VSS ppolyf_u_1k r_width=2u r_length=40u
XA0 D0 db0 VDD VSS inv_dig
XB0 db0 dr0 VDD VSS inv_dac
XR2_0 n0 dr0 VSS ppolyf_u_1k r_width=2u r_length=40u
XR1_0 n1 n0 VSS ppolyf_u_1k r_width=2u r_length=19.8u
XA1 D1 db1 VDD VSS inv_dig
XB1 db1 dr1 VDD VSS inv_dac
XR2_1 n1 dr1 VSS ppolyf_u_1k r_width=2u r_length=40u
XR1_1 n2 n1 VSS ppolyf_u_1k r_width=2u r_length=19.8u
XA2 D2 db2 VDD VSS inv_dig
XB2 db2 dr2 VDD VSS inv_dac
XR2_2 n2 dr2 VSS ppolyf_u_1k r_width=2u r_length=40u
XR1_2 n3 n2 VSS ppolyf_u_1k r_width=2u r_length=19.8u
XA3 D3 db3 VDD VSS inv_dig
XB3 db3 dr3 VDD VSS inv_dac
XR2_3 n3 dr3 VSS ppolyf_u_1k r_width=2u r_length=40u
XR1_3 n4 n3 VSS ppolyf_u_1k r_width=2u r_length=19.8u
XA4 D4 db4 VDD VSS inv_dig
XB4 db4 dr4 VDD VSS inv_dac
XR2_4 n4 dr4 VSS ppolyf_u_1k r_width=2u r_length=40u
XR1_4 n5 n4 VSS ppolyf_u_1k r_width=2u r_length=19.8u
XA5 D5 db5 VDD VSS inv_dig
XB5 db5 dr5 VDD VSS inv_dac
XR2_5 n5 dr5 VSS ppolyf_u_1k r_width=2u r_length=40u
XR1_5 n6 n5 VSS ppolyf_u_1k r_width=2u r_length=19.8u
XA6 D6 db6 VDD VSS inv_dig
XB6 db6 dr6 VDD VSS inv_dac
XR2_6 n6 dr6 VSS ppolyf_u_1k r_width=2u r_length=40u
XR1_6 OUT n6 VSS ppolyf_u_1k r_width=2u r_length=19.8u
XA7 D7 db7 VDD VSS inv_dig
XB7 db7 dr7 VDD VSS inv_dac
XR2_7 OUT dr7 VSS ppolyf_u_1k r_width=2u r_length=40u
.ends

* expanding   symbol:  inv_dig.sym # of pins=4
** sym_path: /home/noritsuna/GPS/xschem/inv_dig.sym
** sch_path: /home/noritsuna/GPS/xschem/inv_dig.sch
.subckt inv_dig A Y VDD VSS
*.ipin A
*.opin Y
*.iopin VDD
*.iopin VSS
XMN Y A VSS VSS nfet_03v3 L=0.28u W=1u nf=1 ad='int((nf+1)/2) * W/nf * 0.18u' as='int((nf+2)/2) * W/nf * 0.18u' pd='2*int((nf+1)/2) * (W/nf + 0.18u)'
+ ps='2*int((nf+2)/2) * (W/nf + 0.18u)' nrd='0.18u / W' nrs='0.18u / W' sa=0 sb=0 sd=0 m=1 par=1
XMP Y A VDD VDD pfet_03v3 L=0.28u W=2u nf=1 ad='int((nf+1)/2) * W/nf * 0.18u' as='int((nf+2)/2) * W/nf * 0.18u' pd='2*int((nf+1)/2) * (W/nf + 0.18u)'
+ ps='2*int((nf+2)/2) * (W/nf + 0.18u)' nrd='0.18u / W' nrs='0.18u / W' sa=0 sb=0 sd=0 m=1 par=1
.ends

* expanding   symbol:  inv_dac.sym # of pins=4
** sym_path: /home/noritsuna/GPS/xschem/inv_dac.sym
** sch_path: /home/noritsuna/GPS/xschem/inv_dac.sch
.subckt inv_dac A Y VDD VSS
*.ipin A
*.opin Y
*.iopin VDD
*.iopin VSS
XMN Y A VSS VSS nfet_03v3 L=0.28u W=8u nf=2 ad='int((nf+1)/2) * W/nf * 0.18u' as='int((nf+2)/2) * W/nf * 0.18u' pd='2*int((nf+1)/2) * (W/nf + 0.18u)'
+ ps='2*int((nf+2)/2) * (W/nf + 0.18u)' nrd='0.18u / W' nrs='0.18u / W' sa=0 sb=0 sd=0 m=1 par=1
XMP Y A VDD VDD pfet_03v3 L=0.28u W=24u nf=4 ad='int((nf+1)/2) * W/nf * 0.18u' as='int((nf+2)/2) * W/nf * 0.18u' pd='2*int((nf+1)/2) * (W/nf + 0.18u)'
+ ps='2*int((nf+2)/2) * (W/nf + 0.18u)' nrd='0.18u / W' nrs='0.18u / W' sa=0 sb=0 sd=0 m=1 par=1
.ends

.end
