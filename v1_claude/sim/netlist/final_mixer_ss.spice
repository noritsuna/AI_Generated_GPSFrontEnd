** sch_path: /home/noritsuna/GPS/xschem/tb_mixer.sch
**.subckt tb_mixer
VDD vdd 0 3.135
XB nb pb vdd 0 bias_gen
VL1P l1p 0 pulse(0 2.85 0.000p 60p 60p 576.404p 1272.809p)
VL1N l1n 0 pulse(0 2.85 636.404p 60p 60p 576.404p 1272.809p)
VL2P l2p 0 pulse(0 2.85 159.101p 60p 60p 576.404p 1272.809p)
VL2N l2n 0 pulse(0 2.85 795.505p 60p 60p 576.404p 1272.809p)
VL3P l3p 0 pulse(0 2.85 318.202p 60p 60p 576.404p 1272.809p)
VL3N l3n 0 pulse(0 2.85 954.607p 60p 60p 576.404p 1272.809p)
VL4P l4p 0 pulse(0 2.85 477.303p 60p 60p 576.404p 1272.809p)
VL4N l4n 0 pulse(0 2.85 1113.708p 60p 60p 576.404p 1272.809p)
VRFP sp 0 sin(0 ARF 1575.42e6 0 0 0)
VRFN sn 0 sin(0 ARF 1575.42e6 0 0 180)
RSP sp rfp_s 50
RSN sn rfn_s 50
CCP rfp_s rfp 10p
CCN rfn_s rfn 10p
XM rfp rfn l1p l1n l2p l2n l3p l3n l4p l4n nb ifip ifin ifqp ifqn vdd 0 mixer_iq
**** begin user architecture code
 .include /home/noritsuna/pdk/gf180mcuD/libs.tech/ngspice/design.ngspice
.lib /home/noritsuna/pdk/gf180mcuD/libs.tech/ngspice/sm141064.ngspice ss
.lib /home/noritsuna/pdk/gf180mcuD/libs.tech/ngspice/sm141064.ngspice res_ss
.lib /home/noritsuna/pdk/gf180mcuD/libs.tech/ngspice/sm141064.ngspice mimcap_ss

.param arf=1m
.temp 85
.option method=gear
.control
set num_threads=1
save v(xm.ti) v(xm.xpi) v(xm.mpai) v(ifip) v(ifin) v(xm.gl1p) v(xm.gl3p) i(VDD) @m.xm.xmti.m0[vds] @m.xm.xmti.m0[vdsat] @m.xm.xmti.m0[id] @m.xm.xmti.m0[vgs] @m.xm.xmg1i.m0[vds] @m.xm.xmg1i.m0[vdsat] @m.xm.xmg1i.m0[id] @m.xm.xmg1i.m0[vgs] @m.xm.xmg2i.m0[vds] @m.xm.xmg2i.m0[vdsat] @m.xm.xmg2i.m0[id] @m.xm.xmg2i.m0[vgs] @m.xm.xmtq.m0[vds] @m.xm.xmtq.m0[vdsat] @m.xm.xmtq.m0[id] @m.xm.xmtq.m0[vgs] @m.xm.xmg1q.m0[vds] @m.xm.xmg1q.m0[vdsat] @m.xm.xmg1q.m0[id] @m.xm.xmg1q.m0[vgs] @m.xm.xmg2q.m0[vds] @m.xm.xmg2q.m0[vdsat] @m.xm.xmg2q.m0[id] @m.xm.xmg2q.m0[vgs] @m.xm.xmlapi.m0[vds] @m.xm.xmlapi.m0[vdsat] @m.xm.xmlapi.m0[id] @m.xm.xmlapi.m0[vgs] @m.xm.xmu1pi.m0[vds] @m.xm.xmu1pi.m0[vdsat] @m.xm.xmu1pi.m0[id] @m.xm.xmu1pi.m0[vgs]
tran 5p 300n 0 5p
let mar = @m.xm.xmti.m0[vds] - @m.xm.xmti.m0[vdsat]
meas tran ma avg mar from=250n to=300n
meas tran mi min mar from=250n to=300n
meas tran ia avg @m.xm.xmti.m0[id] from=250n to=300n
meas tran va avg @m.xm.xmti.m0[vds] from=250n to=300n
meas tran sa avg @m.xm.xmti.m0[vdsat] from=250n to=300n
echo DEV xmti $&ma $&mi $&ia $&va $&sa
let mar = @m.xm.xmg1i.m0[vds] - @m.xm.xmg1i.m0[vdsat]
meas tran ma avg mar from=250n to=300n
meas tran mi min mar from=250n to=300n
meas tran ia avg @m.xm.xmg1i.m0[id] from=250n to=300n
meas tran va avg @m.xm.xmg1i.m0[vds] from=250n to=300n
meas tran sa avg @m.xm.xmg1i.m0[vdsat] from=250n to=300n
echo DEV xmg1i $&ma $&mi $&ia $&va $&sa
let mar = @m.xm.xmg2i.m0[vds] - @m.xm.xmg2i.m0[vdsat]
meas tran ma avg mar from=250n to=300n
meas tran mi min mar from=250n to=300n
meas tran ia avg @m.xm.xmg2i.m0[id] from=250n to=300n
meas tran va avg @m.xm.xmg2i.m0[vds] from=250n to=300n
meas tran sa avg @m.xm.xmg2i.m0[vdsat] from=250n to=300n
echo DEV xmg2i $&ma $&mi $&ia $&va $&sa
let mar = @m.xm.xmtq.m0[vds] - @m.xm.xmtq.m0[vdsat]
meas tran ma avg mar from=250n to=300n
meas tran mi min mar from=250n to=300n
meas tran ia avg @m.xm.xmtq.m0[id] from=250n to=300n
meas tran va avg @m.xm.xmtq.m0[vds] from=250n to=300n
meas tran sa avg @m.xm.xmtq.m0[vdsat] from=250n to=300n
echo DEV xmtq $&ma $&mi $&ia $&va $&sa
let mar = @m.xm.xmg1q.m0[vds] - @m.xm.xmg1q.m0[vdsat]
meas tran ma avg mar from=250n to=300n
meas tran mi min mar from=250n to=300n
meas tran ia avg @m.xm.xmg1q.m0[id] from=250n to=300n
meas tran va avg @m.xm.xmg1q.m0[vds] from=250n to=300n
meas tran sa avg @m.xm.xmg1q.m0[vdsat] from=250n to=300n
echo DEV xmg1q $&ma $&mi $&ia $&va $&sa
let mar = @m.xm.xmg2q.m0[vds] - @m.xm.xmg2q.m0[vdsat]
meas tran ma avg mar from=250n to=300n
meas tran mi min mar from=250n to=300n
meas tran ia avg @m.xm.xmg2q.m0[id] from=250n to=300n
meas tran va avg @m.xm.xmg2q.m0[vds] from=250n to=300n
meas tran sa avg @m.xm.xmg2q.m0[vdsat] from=250n to=300n
echo DEV xmg2q $&ma $&mi $&ia $&va $&sa
let mar = @m.xm.xmlapi.m0[vds] - @m.xm.xmlapi.m0[vdsat]
meas tran ma avg mar from=250n to=300n
meas tran mi min mar from=250n to=300n
meas tran ia avg @m.xm.xmlapi.m0[id] from=250n to=300n
meas tran va avg @m.xm.xmlapi.m0[vds] from=250n to=300n
meas tran sa avg @m.xm.xmlapi.m0[vdsat] from=250n to=300n
echo DEV xmlapi $&ma $&mi $&ia $&va $&sa
let mar = @m.xm.xmu1pi.m0[vds] - @m.xm.xmu1pi.m0[vdsat]
meas tran ma avg mar from=250n to=300n
meas tran mi min mar from=250n to=300n
meas tran ia avg @m.xm.xmu1pi.m0[id] from=250n to=300n
meas tran va avg @m.xm.xmu1pi.m0[vds] from=250n to=300n
meas tran sa avg @m.xm.xmu1pi.m0[vdsat] from=250n to=300n
echo DEV xmu1pi $&ma $&mi $&ia $&va $&sa
meas tran a avg v(xm.ti) from=250n to=300n
meas tran lo min v(xm.ti) from=250n to=300n
meas tran hi max v(xm.ti) from=250n to=300n
echo NODE xm.ti $&a $&lo $&hi
meas tran a avg v(xm.xpi) from=250n to=300n
meas tran lo min v(xm.xpi) from=250n to=300n
meas tran hi max v(xm.xpi) from=250n to=300n
echo NODE xm.xpi $&a $&lo $&hi
meas tran a avg v(xm.mpai) from=250n to=300n
meas tran lo min v(xm.mpai) from=250n to=300n
meas tran hi max v(xm.mpai) from=250n to=300n
echo NODE xm.mpai $&a $&lo $&hi
meas tran a avg v(ifip) from=250n to=300n
meas tran lo min v(ifip) from=250n to=300n
meas tran hi max v(ifip) from=250n to=300n
echo NODE ifip $&a $&lo $&hi
meas tran a avg v(xm.gl1p) from=250n to=300n
meas tran lo min v(xm.gl1p) from=250n to=300n
meas tran hi max v(xm.gl1p) from=250n to=300n
echo NODE xm.gl1p $&a $&lo $&hi
meas tran a avg v(xm.gl3p) from=250n to=300n
meas tran lo min v(xm.gl3p) from=250n to=300n
meas tran hi max v(xm.gl3p) from=250n to=300n
echo NODE xm.gl3p $&a $&lo $&hi
.endc

**** end user architecture code
**.ends

* expanding   symbol:  bias_gen.sym # of pins=4
** sym_path: /home/noritsuna/GPS/xschem/bias_gen.sym
** sch_path: /home/noritsuna/GPS/xschem/bias_gen.sch
.subckt bias_gen NB PB VDD VSS
*.opin NB
*.opin PB
*.iopin VDD
*.iopin VSS
XMN1 nbc nbc VSS VSS nfet_03v3 L=2u W=4u nf=1 ad='int((nf+1)/2) * W/nf * 0.18u' as='int((nf+2)/2) * W/nf * 0.18u' pd='2*int((nf+1)/2) * (W/nf + 0.18u)'
+ ps='2*int((nf+2)/2) * (W/nf + 0.18u)' nrd='0.18u / W' nrs='0.18u / W' sa=0 sb=0 sd=0 m=1 par=1
XMN2 pbc nbc nr VSS nfet_03v3 L=2u W=16u nf=2 ad='int((nf+1)/2) * W/nf * 0.18u' as='int((nf+2)/2) * W/nf * 0.18u' pd='2*int((nf+1)/2) * (W/nf + 0.18u)'
+ ps='2*int((nf+2)/2) * (W/nf + 0.18u)' nrd='0.18u / W' nrs='0.18u / W' sa=0 sb=0 sd=0 m=1 par=1
XRB VSS nr VSS ppolyf_u_1k r_width=1u r_length=4.6u
XMP1 nbc pbc VDD VDD pfet_03v3 L=2u W=8u nf=1 ad='int((nf+1)/2) * W/nf * 0.18u' as='int((nf+2)/2) * W/nf * 0.18u' pd='2*int((nf+1)/2) * (W/nf + 0.18u)'
+ ps='2*int((nf+2)/2) * (W/nf + 0.18u)' nrd='0.18u / W' nrs='0.18u / W' sa=0 sb=0 sd=0 m=1 par=1
XMP2 pbc pbc VDD VDD pfet_03v3 L=2u W=8u nf=1 ad='int((nf+1)/2) * W/nf * 0.18u' as='int((nf+2)/2) * W/nf * 0.18u' pd='2*int((nf+1)/2) * (W/nf + 0.18u)'
+ ps='2*int((nf+2)/2) * (W/nf + 0.18u)' nrd='0.18u / W' nrs='0.18u / W' sa=0 sb=0 sd=0 m=1 par=1
XMSP st VSS VDD VDD pfet_03v3 L=20u W=1u nf=1 ad='int((nf+1)/2) * W/nf * 0.18u' as='int((nf+2)/2) * W/nf * 0.18u' pd='2*int((nf+1)/2) * (W/nf + 0.18u)'
+ ps='2*int((nf+2)/2) * (W/nf + 0.18u)' nrd='0.18u / W' nrs='0.18u / W' sa=0 sb=0 sd=0 m=1 par=1
XMSN st nbc VSS VSS nfet_03v3 L=1u W=2u nf=1 ad='int((nf+1)/2) * W/nf * 0.18u' as='int((nf+2)/2) * W/nf * 0.18u' pd='2*int((nf+1)/2) * (W/nf + 0.18u)'
+ ps='2*int((nf+2)/2) * (W/nf + 0.18u)' nrd='0.18u / W' nrs='0.18u / W' sa=0 sb=0 sd=0 m=1 par=1
XMSU pbc st VSS VSS nfet_03v3 L=1u W=1u nf=1 ad='int((nf+1)/2) * W/nf * 0.18u' as='int((nf+2)/2) * W/nf * 0.18u' pd='2*int((nf+1)/2) * (W/nf + 0.18u)'
+ ps='2*int((nf+2)/2) * (W/nf + 0.18u)' nrd='0.18u / W' nrs='0.18u / W' sa=0 sb=0 sd=0 m=1 par=1
XMP3 NB pbc VDD VDD pfet_03v3 L=2u W=8u nf=1 ad='int((nf+1)/2) * W/nf * 0.18u' as='int((nf+2)/2) * W/nf * 0.18u' pd='2*int((nf+1)/2) * (W/nf + 0.18u)'
+ ps='2*int((nf+2)/2) * (W/nf + 0.18u)' nrd='0.18u / W' nrs='0.18u / W' sa=0 sb=0 sd=0 m=1 par=1
XMN3 NB NB VSS VSS nfet_03v3 L=2u W=16u nf=2 ad='int((nf+1)/2) * W/nf * 0.18u' as='int((nf+2)/2) * W/nf * 0.18u' pd='2*int((nf+1)/2) * (W/nf + 0.18u)'
+ ps='2*int((nf+2)/2) * (W/nf + 0.18u)' nrd='0.18u / W' nrs='0.18u / W' sa=0 sb=0 sd=0 m=1 par=1
XMN4 PB nbc VSS VSS nfet_03v3 L=2u W=4u nf=1 ad='int((nf+1)/2) * W/nf * 0.18u' as='int((nf+2)/2) * W/nf * 0.18u' pd='2*int((nf+1)/2) * (W/nf + 0.18u)'
+ ps='2*int((nf+2)/2) * (W/nf + 0.18u)' nrd='0.18u / W' nrs='0.18u / W' sa=0 sb=0 sd=0 m=1 par=1
XMP4 PB PB VDD VDD pfet_03v3 L=2u W=32u nf=4 ad='int((nf+1)/2) * W/nf * 0.18u' as='int((nf+2)/2) * W/nf * 0.18u' pd='2*int((nf+1)/2) * (W/nf + 0.18u)'
+ ps='2*int((nf+2)/2) * (W/nf + 0.18u)' nrd='0.18u / W' nrs='0.18u / W' sa=0 sb=0 sd=0 m=1 par=1
XCNB NB VSS cap_mim_2f0_m4m5_noshield c_width=20e-6 c_length=20e-6
XCPB VDD PB cap_mim_2f0_m4m5_noshield c_width=20e-6 c_length=20e-6
.ends

* expanding   symbol:  mixer_iq.sym # of pins=17
** sym_path: /home/noritsuna/GPS/xschem/mixer_iq.sym
** sch_path: /home/noritsuna/GPS/xschem/mixer_iq.sch
.subckt mixer_iq RFP RFN L1P L1N L2P L2N L3P L3N L4P L4N NB IFIP IFIN IFQP IFQN VDD VSS
*.ipin RFP
*.ipin RFN
*.ipin L1P
*.ipin L1N
*.ipin L2P
*.ipin L2N
*.ipin L3P
*.ipin L3N
*.ipin L4P
*.ipin L4N
*.ipin NB
*.opin IFIP
*.opin IFIN
*.opin IFQP
*.opin IFQN
*.iopin VDD
*.iopin VSS
XRT1 vbrf RFP VSS ppolyf_u_1k r_width=1u r_length=5u
XRT2 vbrf RFN VSS ppolyf_u_1k r_width=1u r_length=5u
XRBA vbrf VDD VSS ppolyf_u_1k r_width=1u r_length=20u
XRBB VSS vbrf VSS ppolyf_u_1k r_width=1u r_length=13u
XCBRF vbrf VSS cap_mim_2f0_m4m5_noshield c_width=70e-6 c_length=70e-6
XRLUA vlou VDD VSS ppolyf_u_1k r_width=1u r_length=47u
XRLUB VSS vlou VSS ppolyf_u_1k r_width=1u r_length=56u
XCLOU vlou VSS cap_mim_2f0_m4m5_noshield c_width=50e-6 c_length=50e-6
XRLLA vlol VDD VSS ppolyf_u_1k r_width=1u r_length=65u
XRLLB VSS vlol VSS ppolyf_u_1k r_width=1u r_length=37u
XCLOL vlol VSS cap_mim_2f0_m4m5_noshield c_width=50e-6 c_length=50e-6
XCACL1P L1P gl1p cap_mim_2f0_m4m5_noshield c_width=31.6e-6 c_length=31.6e-6
XRACL1P vlou gl1p VSS ppolyf_u_1k r_width=1u r_length=20u
XCACL1N L1N gl1n cap_mim_2f0_m4m5_noshield c_width=31.6e-6 c_length=31.6e-6
XRACL1N vlou gl1n VSS ppolyf_u_1k r_width=1u r_length=20u
XCACL2P L2P gl2p cap_mim_2f0_m4m5_noshield c_width=31.6e-6 c_length=31.6e-6
XRACL2P vlou gl2p VSS ppolyf_u_1k r_width=1u r_length=20u
XCACL2N L2N gl2n cap_mim_2f0_m4m5_noshield c_width=31.6e-6 c_length=31.6e-6
XRACL2N vlou gl2n VSS ppolyf_u_1k r_width=1u r_length=20u
XCACL3P L3P gl3p cap_mim_2f0_m4m5_noshield c_width=31.6e-6 c_length=31.6e-6
XRACL3P vlol gl3p VSS ppolyf_u_1k r_width=1u r_length=20u
XCACL3N L3N gl3n cap_mim_2f0_m4m5_noshield c_width=31.6e-6 c_length=31.6e-6
XRACL3N vlol gl3n VSS ppolyf_u_1k r_width=1u r_length=20u
XCACL4P L4P gl4p cap_mim_2f0_m4m5_noshield c_width=31.6e-6 c_length=31.6e-6
XRACL4P vlol gl4p VSS ppolyf_u_1k r_width=1u r_length=20u
XCACL4N L4N gl4n cap_mim_2f0_m4m5_noshield c_width=31.6e-6 c_length=31.6e-6
XRACL4N vlol gl4n VSS ppolyf_u_1k r_width=1u r_length=20u
XMCTL1P VSS gl1p VSS VSS nfet_03v3 L=2u W=4.96u nf=1 ad='int((nf+1)/2) * W/nf * 0.18u' as='int((nf+2)/2) * W/nf * 0.18u' pd='2*int((nf+1)/2) * (W/nf + 0.18u)'
+ ps='2*int((nf+2)/2) * (W/nf + 0.18u)' nrd='0.18u / W' nrs='0.18u / W' sa=0 sb=0 sd=0 m=1 par=1
XMCTL1N VSS gl1n VSS VSS nfet_03v3 L=2u W=6.08u nf=1 ad='int((nf+1)/2) * W/nf * 0.18u' as='int((nf+2)/2) * W/nf * 0.18u' pd='2*int((nf+1)/2) * (W/nf + 0.18u)'
+ ps='2*int((nf+2)/2) * (W/nf + 0.18u)' nrd='0.18u / W' nrs='0.18u / W' sa=0 sb=0 sd=0 m=1 par=1
XMCTL2P VSS gl2p VSS VSS nfet_03v3 L=2u W=3.97u nf=1 ad='int((nf+1)/2) * W/nf * 0.18u' as='int((nf+2)/2) * W/nf * 0.18u' pd='2*int((nf+1)/2) * (W/nf + 0.18u)'
+ ps='2*int((nf+2)/2) * (W/nf + 0.18u)' nrd='0.18u / W' nrs='0.18u / W' sa=0 sb=0 sd=0 m=1 par=1
XMCTL2N VSS gl2n VSS VSS nfet_03v3 L=2u W=4.25u nf=1 ad='int((nf+1)/2) * W/nf * 0.18u' as='int((nf+2)/2) * W/nf * 0.18u' pd='2*int((nf+1)/2) * (W/nf + 0.18u)'
+ ps='2*int((nf+2)/2) * (W/nf + 0.18u)' nrd='0.18u / W' nrs='0.18u / W' sa=0 sb=0 sd=0 m=1 par=1
XMCTL3P VSS gl3p VSS VSS nfet_03v3 L=2u W=0.83u nf=1 ad='int((nf+1)/2) * W/nf * 0.18u' as='int((nf+2)/2) * W/nf * 0.18u' pd='2*int((nf+1)/2) * (W/nf + 0.18u)'
+ ps='2*int((nf+2)/2) * (W/nf + 0.18u)' nrd='0.18u / W' nrs='0.18u / W' sa=0 sb=0 sd=0 m=1 par=1
XMCTL3N VSS gl3n VSS VSS nfet_03v3 L=2u W=0.8u nf=1 ad='int((nf+1)/2) * W/nf * 0.18u' as='int((nf+2)/2) * W/nf * 0.18u' pd='2*int((nf+1)/2) * (W/nf + 0.18u)'
+ ps='2*int((nf+2)/2) * (W/nf + 0.18u)' nrd='0.18u / W' nrs='0.18u / W' sa=0 sb=0 sd=0 m=1 par=1
XMCTL4P VSS gl4p VSS VSS nfet_03v3 L=2u W=1.3u nf=1 ad='int((nf+1)/2) * W/nf * 0.18u' as='int((nf+2)/2) * W/nf * 0.18u' pd='2*int((nf+1)/2) * (W/nf + 0.18u)'
+ ps='2*int((nf+2)/2) * (W/nf + 0.18u)' nrd='0.18u / W' nrs='0.18u / W' sa=0 sb=0 sd=0 m=1 par=1
XMCTL4N VSS gl4n VSS VSS nfet_03v3 L=2u W=1.65u nf=1 ad='int((nf+1)/2) * W/nf * 0.18u' as='int((nf+2)/2) * W/nf * 0.18u' pd='2*int((nf+1)/2) * (W/nf + 0.18u)'
+ ps='2*int((nf+2)/2) * (W/nf + 0.18u)' nrd='0.18u / W' nrs='0.18u / W' sa=0 sb=0 sd=0 m=1 par=1
XMTI tI NB VSS VSS nfet_03v3 L=2u W=40u nf=4 ad='int((nf+1)/2) * W/nf * 0.18u' as='int((nf+2)/2) * W/nf * 0.18u' pd='2*int((nf+1)/2) * (W/nf + 0.18u)'
+ ps='2*int((nf+2)/2) * (W/nf + 0.18u)' nrd='0.18u / W' nrs='0.18u / W' sa=0 sb=0 sd=0 m=16 par=16
XMG1I xpI RFP tI VSS nfet_03v3 L=0.28u W=80u nf=16 ad='int((nf+1)/2) * W/nf * 0.18u' as='int((nf+2)/2) * W/nf * 0.18u' pd='2*int((nf+1)/2) * (W/nf + 0.18u)'
+ ps='2*int((nf+2)/2) * (W/nf + 0.18u)' nrd='0.18u / W' nrs='0.18u / W' sa=0 sb=0 sd=0 m=1 par=1
XMG2I xnI RFN tI VSS nfet_03v3 L=0.28u W=80u nf=16 ad='int((nf+1)/2) * W/nf * 0.18u' as='int((nf+2)/2) * W/nf * 0.18u' pd='2*int((nf+1)/2) * (W/nf + 0.18u)'
+ ps='2*int((nf+2)/2) * (W/nf + 0.18u)' nrd='0.18u / W' nrs='0.18u / W' sa=0 sb=0 sd=0 m=1 par=1
XMLApI mpaI gl3n xpI VSS nfet_03v3 L=0.28u W=40u nf=8 ad='int((nf+1)/2) * W/nf * 0.18u' as='int((nf+2)/2) * W/nf * 0.18u' pd='2*int((nf+1)/2) * (W/nf + 0.18u)'
+ ps='2*int((nf+2)/2) * (W/nf + 0.18u)' nrd='0.18u / W' nrs='0.18u / W' sa=0 sb=0 sd=0 m=1 par=1
XMLBpI mpbI gl3p xpI VSS nfet_03v3 L=0.28u W=40u nf=8 ad='int((nf+1)/2) * W/nf * 0.18u' as='int((nf+2)/2) * W/nf * 0.18u' pd='2*int((nf+1)/2) * (W/nf + 0.18u)'
+ ps='2*int((nf+2)/2) * (W/nf + 0.18u)' nrd='0.18u / W' nrs='0.18u / W' sa=0 sb=0 sd=0 m=1 par=1
XMU1pI IFIP gl1p mpaI VSS nfet_03v3 L=0.28u W=20u nf=4 ad='int((nf+1)/2) * W/nf * 0.18u' as='int((nf+2)/2) * W/nf * 0.18u' pd='2*int((nf+1)/2) * (W/nf + 0.18u)'
+ ps='2*int((nf+2)/2) * (W/nf + 0.18u)' nrd='0.18u / W' nrs='0.18u / W' sa=0 sb=0 sd=0 m=1 par=1
XMU2pI IFIN gl1n mpaI VSS nfet_03v3 L=0.28u W=20u nf=4 ad='int((nf+1)/2) * W/nf * 0.18u' as='int((nf+2)/2) * W/nf * 0.18u' pd='2*int((nf+1)/2) * (W/nf + 0.18u)'
+ ps='2*int((nf+2)/2) * (W/nf + 0.18u)' nrd='0.18u / W' nrs='0.18u / W' sa=0 sb=0 sd=0 m=1 par=1
XMU3pI IFIN gl1p mpbI VSS nfet_03v3 L=0.28u W=20u nf=4 ad='int((nf+1)/2) * W/nf * 0.18u' as='int((nf+2)/2) * W/nf * 0.18u' pd='2*int((nf+1)/2) * (W/nf + 0.18u)'
+ ps='2*int((nf+2)/2) * (W/nf + 0.18u)' nrd='0.18u / W' nrs='0.18u / W' sa=0 sb=0 sd=0 m=1 par=1
XMU4pI IFIP gl1n mpbI VSS nfet_03v3 L=0.28u W=20u nf=4 ad='int((nf+1)/2) * W/nf * 0.18u' as='int((nf+2)/2) * W/nf * 0.18u' pd='2*int((nf+1)/2) * (W/nf + 0.18u)'
+ ps='2*int((nf+2)/2) * (W/nf + 0.18u)' nrd='0.18u / W' nrs='0.18u / W' sa=0 sb=0 sd=0 m=1 par=1
XMLAnI mnaI gl3n xnI VSS nfet_03v3 L=0.28u W=40u nf=8 ad='int((nf+1)/2) * W/nf * 0.18u' as='int((nf+2)/2) * W/nf * 0.18u' pd='2*int((nf+1)/2) * (W/nf + 0.18u)'
+ ps='2*int((nf+2)/2) * (W/nf + 0.18u)' nrd='0.18u / W' nrs='0.18u / W' sa=0 sb=0 sd=0 m=1 par=1
XMLBnI mnbI gl3p xnI VSS nfet_03v3 L=0.28u W=40u nf=8 ad='int((nf+1)/2) * W/nf * 0.18u' as='int((nf+2)/2) * W/nf * 0.18u' pd='2*int((nf+1)/2) * (W/nf + 0.18u)'
+ ps='2*int((nf+2)/2) * (W/nf + 0.18u)' nrd='0.18u / W' nrs='0.18u / W' sa=0 sb=0 sd=0 m=1 par=1
XMU1nI IFIN gl1p mnaI VSS nfet_03v3 L=0.28u W=20u nf=4 ad='int((nf+1)/2) * W/nf * 0.18u' as='int((nf+2)/2) * W/nf * 0.18u' pd='2*int((nf+1)/2) * (W/nf + 0.18u)'
+ ps='2*int((nf+2)/2) * (W/nf + 0.18u)' nrd='0.18u / W' nrs='0.18u / W' sa=0 sb=0 sd=0 m=1 par=1
XMU2nI IFIP gl1n mnaI VSS nfet_03v3 L=0.28u W=20u nf=4 ad='int((nf+1)/2) * W/nf * 0.18u' as='int((nf+2)/2) * W/nf * 0.18u' pd='2*int((nf+1)/2) * (W/nf + 0.18u)'
+ ps='2*int((nf+2)/2) * (W/nf + 0.18u)' nrd='0.18u / W' nrs='0.18u / W' sa=0 sb=0 sd=0 m=1 par=1
XMU3nI IFIP gl1p mnbI VSS nfet_03v3 L=0.28u W=20u nf=4 ad='int((nf+1)/2) * W/nf * 0.18u' as='int((nf+2)/2) * W/nf * 0.18u' pd='2*int((nf+1)/2) * (W/nf + 0.18u)'
+ ps='2*int((nf+2)/2) * (W/nf + 0.18u)' nrd='0.18u / W' nrs='0.18u / W' sa=0 sb=0 sd=0 m=1 par=1
XMU4nI IFIN gl1n mnbI VSS nfet_03v3 L=0.28u W=20u nf=4 ad='int((nf+1)/2) * W/nf * 0.18u' as='int((nf+2)/2) * W/nf * 0.18u' pd='2*int((nf+1)/2) * (W/nf + 0.18u)'
+ ps='2*int((nf+2)/2) * (W/nf + 0.18u)' nrd='0.18u / W' nrs='0.18u / W' sa=0 sb=0 sd=0 m=1 par=1
XRL1I IFIP VDD VSS ppolyf_u_1k r_width=4u r_length=5u
XRL2I IFIN VDD VSS ppolyf_u_1k r_width=4u r_length=5u
XCL1I IFIP VSS cap_mim_2f0_m4m5_noshield c_width=45e-6 c_length=45e-6
XCL2I IFIN VSS cap_mim_2f0_m4m5_noshield c_width=45e-6 c_length=45e-6
XMTQ tQ NB VSS VSS nfet_03v3 L=2u W=40u nf=4 ad='int((nf+1)/2) * W/nf * 0.18u' as='int((nf+2)/2) * W/nf * 0.18u' pd='2*int((nf+1)/2) * (W/nf + 0.18u)'
+ ps='2*int((nf+2)/2) * (W/nf + 0.18u)' nrd='0.18u / W' nrs='0.18u / W' sa=0 sb=0 sd=0 m=16 par=16
XMG1Q xpQ RFP tQ VSS nfet_03v3 L=0.28u W=80u nf=16 ad='int((nf+1)/2) * W/nf * 0.18u' as='int((nf+2)/2) * W/nf * 0.18u' pd='2*int((nf+1)/2) * (W/nf + 0.18u)'
+ ps='2*int((nf+2)/2) * (W/nf + 0.18u)' nrd='0.18u / W' nrs='0.18u / W' sa=0 sb=0 sd=0 m=1 par=1
XMG2Q xnQ RFN tQ VSS nfet_03v3 L=0.28u W=80u nf=16 ad='int((nf+1)/2) * W/nf * 0.18u' as='int((nf+2)/2) * W/nf * 0.18u' pd='2*int((nf+1)/2) * (W/nf + 0.18u)'
+ ps='2*int((nf+2)/2) * (W/nf + 0.18u)' nrd='0.18u / W' nrs='0.18u / W' sa=0 sb=0 sd=0 m=1 par=1
XMLApQ mpaQ gl4n xpQ VSS nfet_03v3 L=0.28u W=40u nf=8 ad='int((nf+1)/2) * W/nf * 0.18u' as='int((nf+2)/2) * W/nf * 0.18u' pd='2*int((nf+1)/2) * (W/nf + 0.18u)'
+ ps='2*int((nf+2)/2) * (W/nf + 0.18u)' nrd='0.18u / W' nrs='0.18u / W' sa=0 sb=0 sd=0 m=1 par=1
XMLBpQ mpbQ gl4p xpQ VSS nfet_03v3 L=0.28u W=40u nf=8 ad='int((nf+1)/2) * W/nf * 0.18u' as='int((nf+2)/2) * W/nf * 0.18u' pd='2*int((nf+1)/2) * (W/nf + 0.18u)'
+ ps='2*int((nf+2)/2) * (W/nf + 0.18u)' nrd='0.18u / W' nrs='0.18u / W' sa=0 sb=0 sd=0 m=1 par=1
XMU1pQ IFQP gl2p mpaQ VSS nfet_03v3 L=0.28u W=20u nf=4 ad='int((nf+1)/2) * W/nf * 0.18u' as='int((nf+2)/2) * W/nf * 0.18u' pd='2*int((nf+1)/2) * (W/nf + 0.18u)'
+ ps='2*int((nf+2)/2) * (W/nf + 0.18u)' nrd='0.18u / W' nrs='0.18u / W' sa=0 sb=0 sd=0 m=1 par=1
XMU2pQ IFQN gl2n mpaQ VSS nfet_03v3 L=0.28u W=20u nf=4 ad='int((nf+1)/2) * W/nf * 0.18u' as='int((nf+2)/2) * W/nf * 0.18u' pd='2*int((nf+1)/2) * (W/nf + 0.18u)'
+ ps='2*int((nf+2)/2) * (W/nf + 0.18u)' nrd='0.18u / W' nrs='0.18u / W' sa=0 sb=0 sd=0 m=1 par=1
XMU3pQ IFQN gl2p mpbQ VSS nfet_03v3 L=0.28u W=20u nf=4 ad='int((nf+1)/2) * W/nf * 0.18u' as='int((nf+2)/2) * W/nf * 0.18u' pd='2*int((nf+1)/2) * (W/nf + 0.18u)'
+ ps='2*int((nf+2)/2) * (W/nf + 0.18u)' nrd='0.18u / W' nrs='0.18u / W' sa=0 sb=0 sd=0 m=1 par=1
XMU4pQ IFQP gl2n mpbQ VSS nfet_03v3 L=0.28u W=20u nf=4 ad='int((nf+1)/2) * W/nf * 0.18u' as='int((nf+2)/2) * W/nf * 0.18u' pd='2*int((nf+1)/2) * (W/nf + 0.18u)'
+ ps='2*int((nf+2)/2) * (W/nf + 0.18u)' nrd='0.18u / W' nrs='0.18u / W' sa=0 sb=0 sd=0 m=1 par=1
XMLAnQ mnaQ gl4n xnQ VSS nfet_03v3 L=0.28u W=40u nf=8 ad='int((nf+1)/2) * W/nf * 0.18u' as='int((nf+2)/2) * W/nf * 0.18u' pd='2*int((nf+1)/2) * (W/nf + 0.18u)'
+ ps='2*int((nf+2)/2) * (W/nf + 0.18u)' nrd='0.18u / W' nrs='0.18u / W' sa=0 sb=0 sd=0 m=1 par=1
XMLBnQ mnbQ gl4p xnQ VSS nfet_03v3 L=0.28u W=40u nf=8 ad='int((nf+1)/2) * W/nf * 0.18u' as='int((nf+2)/2) * W/nf * 0.18u' pd='2*int((nf+1)/2) * (W/nf + 0.18u)'
+ ps='2*int((nf+2)/2) * (W/nf + 0.18u)' nrd='0.18u / W' nrs='0.18u / W' sa=0 sb=0 sd=0 m=1 par=1
XMU1nQ IFQN gl2p mnaQ VSS nfet_03v3 L=0.28u W=20u nf=4 ad='int((nf+1)/2) * W/nf * 0.18u' as='int((nf+2)/2) * W/nf * 0.18u' pd='2*int((nf+1)/2) * (W/nf + 0.18u)'
+ ps='2*int((nf+2)/2) * (W/nf + 0.18u)' nrd='0.18u / W' nrs='0.18u / W' sa=0 sb=0 sd=0 m=1 par=1
XMU2nQ IFQP gl2n mnaQ VSS nfet_03v3 L=0.28u W=20u nf=4 ad='int((nf+1)/2) * W/nf * 0.18u' as='int((nf+2)/2) * W/nf * 0.18u' pd='2*int((nf+1)/2) * (W/nf + 0.18u)'
+ ps='2*int((nf+2)/2) * (W/nf + 0.18u)' nrd='0.18u / W' nrs='0.18u / W' sa=0 sb=0 sd=0 m=1 par=1
XMU3nQ IFQP gl2p mnbQ VSS nfet_03v3 L=0.28u W=20u nf=4 ad='int((nf+1)/2) * W/nf * 0.18u' as='int((nf+2)/2) * W/nf * 0.18u' pd='2*int((nf+1)/2) * (W/nf + 0.18u)'
+ ps='2*int((nf+2)/2) * (W/nf + 0.18u)' nrd='0.18u / W' nrs='0.18u / W' sa=0 sb=0 sd=0 m=1 par=1
XMU4nQ IFQN gl2n mnbQ VSS nfet_03v3 L=0.28u W=20u nf=4 ad='int((nf+1)/2) * W/nf * 0.18u' as='int((nf+2)/2) * W/nf * 0.18u' pd='2*int((nf+1)/2) * (W/nf + 0.18u)'
+ ps='2*int((nf+2)/2) * (W/nf + 0.18u)' nrd='0.18u / W' nrs='0.18u / W' sa=0 sb=0 sd=0 m=1 par=1
XRL1Q IFQP VDD VSS ppolyf_u_1k r_width=4u r_length=5u
XRL2Q IFQN VDD VSS ppolyf_u_1k r_width=4u r_length=5u
XCL1Q IFQP VSS cap_mim_2f0_m4m5_noshield c_width=45e-6 c_length=45e-6
XCL2Q IFQN VSS cap_mim_2f0_m4m5_noshield c_width=45e-6 c_length=45e-6
.ends

.end
