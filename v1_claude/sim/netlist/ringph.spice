** sch_path: /home/noritsuna/GPS/xschem/tb_vco.sch
**.subckt tb_vco
VDD vdd 0 3.3
VC vctrl 0 1.5
VB0 b0 0 0
VB1 b1 0 0
XVCO vctrl b0 b1 loip loin loqp loqn vr vdd 0 vco_ring4
CLloip loip 0 60f
CLloin loin 0 60f
CLloqp loqp 0 60f
CLloqn loqn 0 60f
**** begin user architecture code
 .include /home/noritsuna/pdk/gf180mcuD/libs.tech/ngspice/design.ngspice
.lib /home/noritsuna/pdk/gf180mcuD/libs.tech/ngspice/sm141064.ngspice typical
.lib /home/noritsuna/pdk/gf180mcuD/libs.tech/ngspice/sm141064.ngspice res_typical
.lib /home/noritsuna/pdk/gf180mcuD/libs.tech/ngspice/sm141064.ngspice mimcap_typical

.option method=gear reltol=1e-4
.ic v(xvco.xpex.a_28909_57069#)=0 v(xvco.xpex.a_29925_57069#)=2
.control
set num_threads=4
alter VC dc = 2.1
tran 1p 30n 15n uic
wrdata /home/noritsuna/GPS/sim/pex_vco/ringph.txt v(xvco.xpex.a_28909_57069#) v(xvco.xpex.a_19487_65329#) v(xvco.xpex.a_22709_52000#) v(xvco.xpex.a_36325_56340#) v(xvco.xpex.a_29925_57069#) v(xvco.xpex.a_23253_52869#) v(xvco.xpex.a_19487_39989#) v(xvco.xpex.a_35309_56340#)
.endc

**** end user architecture code
**.ends

* expanding   symbol:  vco_ring4.sym # of pins=10
** sym_path: /home/noritsuna/GPS/xschem/vco_ring4.sym
** sch_path: /home/noritsuna/GPS/xschem/vco_ring4.sch

* expanding   symbol:  inv_dig.sym # of pins=4
** sym_path: /home/noritsuna/GPS/xschem/inv_dig.sym
** sch_path: /home/noritsuna/GPS/xschem/inv_dig.sch
.subckt inv_dig A Y VDD VSS
*.ipin A
*.opin Y
*.iopin VDD
*.iopin VSS
XMN Y A VSS VSS nfet_03v3 L=0.28u W=1u nf=1 ad='int((nf+1)/2) * W/nf * 0.18u' as='int((nf+2)/2) * W/nf * 0.18u' pd='2*int((nf+1)/2) * (W/nf + 0.18u)'
+ ps='2*int((nf+2)/2) * (W/nf + 0.18u)' nrd='0.18u / W' nrs='0.18u / W' sa=0 sb=0 sd=0 m=1 par=1
XMP Y A VDD VDD pfet_03v3 L=0.28u W=2u nf=1 ad='int((nf+1)/2) * W/nf * 0.18u' as='int((nf+2)/2) * W/nf * 0.18u' pd='2*int((nf+1)/2) * (W/nf + 0.18u)'
+ ps='2*int((nf+2)/2) * (W/nf + 0.18u)' nrd='0.18u / W' nrs='0.18u / W' sa=0 sb=0 sd=0 m=1 par=1
.ends

* expanding   symbol:  vco_core.sym # of pins=12
** sym_path: /home/noritsuna/GPS/xschem/vco_core.sym
** sch_path: /home/noritsuna/GPS/xschem/vco_core.sch
.subckt vco_core p1 n1 p2 n2 p3 n3 p4 n4 kh kl VR VSS
*.opin p1
*.opin n1
*.opin p2
*.opin n2
*.opin p3
*.opin n3
*.opin p4
*.opin n4
*.ipin kh
*.ipin kl
*.iopin VR
*.iopin VSS
XMNa1 n1 p4 VSS VSS nfet_03v3 L=0.4u W=8u nf=2 ad='int((nf+1)/2) * W/nf * 0.18u' as='int((nf+2)/2) * W/nf * 0.18u' pd='2*int((nf+1)/2) * (W/nf + 0.18u)'
+ ps='2*int((nf+2)/2) * (W/nf + 0.18u)' nrd='0.18u / W' nrs='0.18u / W' sa=0 sb=0 sd=0 m=1 par=1
XMNb1 p1 n4 VSS VSS nfet_03v3 L=0.4u W=8u nf=2 ad='int((nf+1)/2) * W/nf * 0.18u' as='int((nf+2)/2) * W/nf * 0.18u' pd='2*int((nf+1)/2) * (W/nf + 0.18u)'
+ ps='2*int((nf+2)/2) * (W/nf + 0.18u)' nrd='0.18u / W' nrs='0.18u / W' sa=0 sb=0 sd=0 m=1 par=1
XMPa1 n1 p4 VR VR pfet_03v3 L=0.4u W=12u nf=4 ad='int((nf+1)/2) * W/nf * 0.18u' as='int((nf+2)/2) * W/nf * 0.18u' pd='2*int((nf+1)/2) * (W/nf + 0.18u)'
+ ps='2*int((nf+2)/2) * (W/nf + 0.18u)' nrd='0.18u / W' nrs='0.18u / W' sa=0 sb=0 sd=0 m=1 par=1
XMPb1 p1 n4 VR VR pfet_03v3 L=0.4u W=12u nf=4 ad='int((nf+1)/2) * W/nf * 0.18u' as='int((nf+2)/2) * W/nf * 0.18u' pd='2*int((nf+1)/2) * (W/nf + 0.18u)'
+ ps='2*int((nf+2)/2) * (W/nf + 0.18u)' nrd='0.18u / W' nrs='0.18u / W' sa=0 sb=0 sd=0 m=1 par=1
XMNc1 n1 p1 VSS VSS nfet_03v3 L=0.4u W=1u nf=1 ad='int((nf+1)/2) * W/nf * 0.18u' as='int((nf+2)/2) * W/nf * 0.18u' pd='2*int((nf+1)/2) * (W/nf + 0.18u)'
+ ps='2*int((nf+2)/2) * (W/nf + 0.18u)' nrd='0.18u / W' nrs='0.18u / W' sa=0 sb=0 sd=0 m=1 par=1
XMNd1 p1 n1 VSS VSS nfet_03v3 L=0.4u W=1u nf=1 ad='int((nf+1)/2) * W/nf * 0.18u' as='int((nf+2)/2) * W/nf * 0.18u' pd='2*int((nf+1)/2) * (W/nf + 0.18u)'
+ ps='2*int((nf+2)/2) * (W/nf + 0.18u)' nrd='0.18u / W' nrs='0.18u / W' sa=0 sb=0 sd=0 m=1 par=1
XMPc1 n1 p1 VR VR pfet_03v3 L=0.4u W=2u nf=1 ad='int((nf+1)/2) * W/nf * 0.18u' as='int((nf+2)/2) * W/nf * 0.18u' pd='2*int((nf+1)/2) * (W/nf + 0.18u)'
+ ps='2*int((nf+2)/2) * (W/nf + 0.18u)' nrd='0.18u / W' nrs='0.18u / W' sa=0 sb=0 sd=0 m=1 par=1
XMPd1 p1 n1 VR VR pfet_03v3 L=0.4u W=2u nf=1 ad='int((nf+1)/2) * W/nf * 0.18u' as='int((nf+2)/2) * W/nf * 0.18u' pd='2*int((nf+1)/2) * (W/nf + 0.18u)'
+ ps='2*int((nf+2)/2) * (W/nf + 0.18u)' nrd='0.18u / W' nrs='0.18u / W' sa=0 sb=0 sd=0 m=1 par=1
XMNa2 n2 p1 VSS VSS nfet_03v3 L=0.4u W=8u nf=2 ad='int((nf+1)/2) * W/nf * 0.18u' as='int((nf+2)/2) * W/nf * 0.18u' pd='2*int((nf+1)/2) * (W/nf + 0.18u)'
+ ps='2*int((nf+2)/2) * (W/nf + 0.18u)' nrd='0.18u / W' nrs='0.18u / W' sa=0 sb=0 sd=0 m=1 par=1
XMNb2 p2 n1 VSS VSS nfet_03v3 L=0.4u W=8u nf=2 ad='int((nf+1)/2) * W/nf * 0.18u' as='int((nf+2)/2) * W/nf * 0.18u' pd='2*int((nf+1)/2) * (W/nf + 0.18u)'
+ ps='2*int((nf+2)/2) * (W/nf + 0.18u)' nrd='0.18u / W' nrs='0.18u / W' sa=0 sb=0 sd=0 m=1 par=1
XMPa2 n2 p1 VR VR pfet_03v3 L=0.4u W=12u nf=4 ad='int((nf+1)/2) * W/nf * 0.18u' as='int((nf+2)/2) * W/nf * 0.18u' pd='2*int((nf+1)/2) * (W/nf + 0.18u)'
+ ps='2*int((nf+2)/2) * (W/nf + 0.18u)' nrd='0.18u / W' nrs='0.18u / W' sa=0 sb=0 sd=0 m=1 par=1
XMPb2 p2 n1 VR VR pfet_03v3 L=0.4u W=12u nf=4 ad='int((nf+1)/2) * W/nf * 0.18u' as='int((nf+2)/2) * W/nf * 0.18u' pd='2*int((nf+1)/2) * (W/nf + 0.18u)'
+ ps='2*int((nf+2)/2) * (W/nf + 0.18u)' nrd='0.18u / W' nrs='0.18u / W' sa=0 sb=0 sd=0 m=1 par=1
XMNc2 n2 p2 VSS VSS nfet_03v3 L=0.4u W=1u nf=1 ad='int((nf+1)/2) * W/nf * 0.18u' as='int((nf+2)/2) * W/nf * 0.18u' pd='2*int((nf+1)/2) * (W/nf + 0.18u)'
+ ps='2*int((nf+2)/2) * (W/nf + 0.18u)' nrd='0.18u / W' nrs='0.18u / W' sa=0 sb=0 sd=0 m=1 par=1
XMNd2 p2 n2 VSS VSS nfet_03v3 L=0.4u W=1u nf=1 ad='int((nf+1)/2) * W/nf * 0.18u' as='int((nf+2)/2) * W/nf * 0.18u' pd='2*int((nf+1)/2) * (W/nf + 0.18u)'
+ ps='2*int((nf+2)/2) * (W/nf + 0.18u)' nrd='0.18u / W' nrs='0.18u / W' sa=0 sb=0 sd=0 m=1 par=1
XMPc2 n2 p2 VR VR pfet_03v3 L=0.4u W=2u nf=1 ad='int((nf+1)/2) * W/nf * 0.18u' as='int((nf+2)/2) * W/nf * 0.18u' pd='2*int((nf+1)/2) * (W/nf + 0.18u)'
+ ps='2*int((nf+2)/2) * (W/nf + 0.18u)' nrd='0.18u / W' nrs='0.18u / W' sa=0 sb=0 sd=0 m=1 par=1
XMPd2 p2 n2 VR VR pfet_03v3 L=0.4u W=2u nf=1 ad='int((nf+1)/2) * W/nf * 0.18u' as='int((nf+2)/2) * W/nf * 0.18u' pd='2*int((nf+1)/2) * (W/nf + 0.18u)'
+ ps='2*int((nf+2)/2) * (W/nf + 0.18u)' nrd='0.18u / W' nrs='0.18u / W' sa=0 sb=0 sd=0 m=1 par=1
XMNa3 n3 p2 VSS VSS nfet_03v3 L=0.4u W=8u nf=2 ad='int((nf+1)/2) * W/nf * 0.18u' as='int((nf+2)/2) * W/nf * 0.18u' pd='2*int((nf+1)/2) * (W/nf + 0.18u)'
+ ps='2*int((nf+2)/2) * (W/nf + 0.18u)' nrd='0.18u / W' nrs='0.18u / W' sa=0 sb=0 sd=0 m=1 par=1
XMNb3 p3 n2 VSS VSS nfet_03v3 L=0.4u W=8u nf=2 ad='int((nf+1)/2) * W/nf * 0.18u' as='int((nf+2)/2) * W/nf * 0.18u' pd='2*int((nf+1)/2) * (W/nf + 0.18u)'
+ ps='2*int((nf+2)/2) * (W/nf + 0.18u)' nrd='0.18u / W' nrs='0.18u / W' sa=0 sb=0 sd=0 m=1 par=1
XMPa3 n3 p2 VR VR pfet_03v3 L=0.4u W=12u nf=4 ad='int((nf+1)/2) * W/nf * 0.18u' as='int((nf+2)/2) * W/nf * 0.18u' pd='2*int((nf+1)/2) * (W/nf + 0.18u)'
+ ps='2*int((nf+2)/2) * (W/nf + 0.18u)' nrd='0.18u / W' nrs='0.18u / W' sa=0 sb=0 sd=0 m=1 par=1
XMPb3 p3 n2 VR VR pfet_03v3 L=0.4u W=12u nf=4 ad='int((nf+1)/2) * W/nf * 0.18u' as='int((nf+2)/2) * W/nf * 0.18u' pd='2*int((nf+1)/2) * (W/nf + 0.18u)'
+ ps='2*int((nf+2)/2) * (W/nf + 0.18u)' nrd='0.18u / W' nrs='0.18u / W' sa=0 sb=0 sd=0 m=1 par=1
XMNc3 n3 p3 VSS VSS nfet_03v3 L=0.4u W=1u nf=1 ad='int((nf+1)/2) * W/nf * 0.18u' as='int((nf+2)/2) * W/nf * 0.18u' pd='2*int((nf+1)/2) * (W/nf + 0.18u)'
+ ps='2*int((nf+2)/2) * (W/nf + 0.18u)' nrd='0.18u / W' nrs='0.18u / W' sa=0 sb=0 sd=0 m=1 par=1
XMNd3 p3 n3 VSS VSS nfet_03v3 L=0.4u W=1u nf=1 ad='int((nf+1)/2) * W/nf * 0.18u' as='int((nf+2)/2) * W/nf * 0.18u' pd='2*int((nf+1)/2) * (W/nf + 0.18u)'
+ ps='2*int((nf+2)/2) * (W/nf + 0.18u)' nrd='0.18u / W' nrs='0.18u / W' sa=0 sb=0 sd=0 m=1 par=1
XMPc3 n3 p3 VR VR pfet_03v3 L=0.4u W=2u nf=1 ad='int((nf+1)/2) * W/nf * 0.18u' as='int((nf+2)/2) * W/nf * 0.18u' pd='2*int((nf+1)/2) * (W/nf + 0.18u)'
+ ps='2*int((nf+2)/2) * (W/nf + 0.18u)' nrd='0.18u / W' nrs='0.18u / W' sa=0 sb=0 sd=0 m=1 par=1
XMPd3 p3 n3 VR VR pfet_03v3 L=0.4u W=2u nf=1 ad='int((nf+1)/2) * W/nf * 0.18u' as='int((nf+2)/2) * W/nf * 0.18u' pd='2*int((nf+1)/2) * (W/nf + 0.18u)'
+ ps='2*int((nf+2)/2) * (W/nf + 0.18u)' nrd='0.18u / W' nrs='0.18u / W' sa=0 sb=0 sd=0 m=1 par=1
XMNa4 p4 p3 VSS VSS nfet_03v3 L=0.4u W=8u nf=2 ad='int((nf+1)/2) * W/nf * 0.18u' as='int((nf+2)/2) * W/nf * 0.18u' pd='2*int((nf+1)/2) * (W/nf + 0.18u)'
+ ps='2*int((nf+2)/2) * (W/nf + 0.18u)' nrd='0.18u / W' nrs='0.18u / W' sa=0 sb=0 sd=0 m=1 par=1
XMNb4 n4 n3 VSS VSS nfet_03v3 L=0.4u W=8u nf=2 ad='int((nf+1)/2) * W/nf * 0.18u' as='int((nf+2)/2) * W/nf * 0.18u' pd='2*int((nf+1)/2) * (W/nf + 0.18u)'
+ ps='2*int((nf+2)/2) * (W/nf + 0.18u)' nrd='0.18u / W' nrs='0.18u / W' sa=0 sb=0 sd=0 m=1 par=1
XMPa4 p4 p3 VR VR pfet_03v3 L=0.4u W=12u nf=4 ad='int((nf+1)/2) * W/nf * 0.18u' as='int((nf+2)/2) * W/nf * 0.18u' pd='2*int((nf+1)/2) * (W/nf + 0.18u)'
+ ps='2*int((nf+2)/2) * (W/nf + 0.18u)' nrd='0.18u / W' nrs='0.18u / W' sa=0 sb=0 sd=0 m=1 par=1
XMPb4 n4 n3 VR VR pfet_03v3 L=0.4u W=12u nf=4 ad='int((nf+1)/2) * W/nf * 0.18u' as='int((nf+2)/2) * W/nf * 0.18u' pd='2*int((nf+1)/2) * (W/nf + 0.18u)'
+ ps='2*int((nf+2)/2) * (W/nf + 0.18u)' nrd='0.18u / W' nrs='0.18u / W' sa=0 sb=0 sd=0 m=1 par=1
XMNc4 p4 n4 VSS VSS nfet_03v3 L=0.4u W=1u nf=1 ad='int((nf+1)/2) * W/nf * 0.18u' as='int((nf+2)/2) * W/nf * 0.18u' pd='2*int((nf+1)/2) * (W/nf + 0.18u)'
+ ps='2*int((nf+2)/2) * (W/nf + 0.18u)' nrd='0.18u / W' nrs='0.18u / W' sa=0 sb=0 sd=0 m=1 par=1
XMNd4 n4 p4 VSS VSS nfet_03v3 L=0.4u W=1u nf=1 ad='int((nf+1)/2) * W/nf * 0.18u' as='int((nf+2)/2) * W/nf * 0.18u' pd='2*int((nf+1)/2) * (W/nf + 0.18u)'
+ ps='2*int((nf+2)/2) * (W/nf + 0.18u)' nrd='0.18u / W' nrs='0.18u / W' sa=0 sb=0 sd=0 m=1 par=1
XMPc4 p4 n4 VR VR pfet_03v3 L=0.4u W=2u nf=1 ad='int((nf+1)/2) * W/nf * 0.18u' as='int((nf+2)/2) * W/nf * 0.18u' pd='2*int((nf+1)/2) * (W/nf + 0.18u)'
+ ps='2*int((nf+2)/2) * (W/nf + 0.18u)' nrd='0.18u / W' nrs='0.18u / W' sa=0 sb=0 sd=0 m=1 par=1
XMPd4 n4 p4 VR VR pfet_03v3 L=0.4u W=2u nf=1 ad='int((nf+1)/2) * W/nf * 0.18u' as='int((nf+2)/2) * W/nf * 0.18u' pd='2*int((nf+1)/2) * (W/nf + 0.18u)'
+ ps='2*int((nf+2)/2) * (W/nf + 0.18u)' nrd='0.18u / W' nrs='0.18u / W' sa=0 sb=0 sd=0 m=1 par=1
XMK1 n1 kh VSS VSS nfet_03v3 L=0.4u W=8u nf=2 ad='int((nf+1)/2) * W/nf * 0.18u' as='int((nf+2)/2) * W/nf * 0.18u' pd='2*int((nf+1)/2) * (W/nf + 0.18u)'
+ ps='2*int((nf+2)/2) * (W/nf + 0.18u)' nrd='0.18u / W' nrs='0.18u / W' sa=0 sb=0 sd=0 m=1 par=1
XMKD1 p1 VSS VSS VSS nfet_03v3 L=0.4u W=8u nf=2 ad='int((nf+1)/2) * W/nf * 0.18u' as='int((nf+2)/2) * W/nf * 0.18u' pd='2*int((nf+1)/2) * (W/nf + 0.18u)'
+ ps='2*int((nf+2)/2) * (W/nf + 0.18u)' nrd='0.18u / W' nrs='0.18u / W' sa=0 sb=0 sd=0 m=1 par=1
XMK2 n2 kl VSS VSS nfet_03v3 L=0.4u W=8u nf=2 ad='int((nf+1)/2) * W/nf * 0.18u' as='int((nf+2)/2) * W/nf * 0.18u' pd='2*int((nf+1)/2) * (W/nf + 0.18u)'
+ ps='2*int((nf+2)/2) * (W/nf + 0.18u)' nrd='0.18u / W' nrs='0.18u / W' sa=0 sb=0 sd=0 m=1 par=1
XMKD2 p2 VSS VSS VSS nfet_03v3 L=0.4u W=8u nf=2 ad='int((nf+1)/2) * W/nf * 0.18u' as='int((nf+2)/2) * W/nf * 0.18u' pd='2*int((nf+1)/2) * (W/nf + 0.18u)'
+ ps='2*int((nf+2)/2) * (W/nf + 0.18u)' nrd='0.18u / W' nrs='0.18u / W' sa=0 sb=0 sd=0 m=1 par=1
XMK3 n3 VSS VSS VSS nfet_03v3 L=0.4u W=8u nf=2 ad='int((nf+1)/2) * W/nf * 0.18u' as='int((nf+2)/2) * W/nf * 0.18u' pd='2*int((nf+1)/2) * (W/nf + 0.18u)'
+ ps='2*int((nf+2)/2) * (W/nf + 0.18u)' nrd='0.18u / W' nrs='0.18u / W' sa=0 sb=0 sd=0 m=1 par=1
XMKD3 p3 VSS VSS VSS nfet_03v3 L=0.4u W=8u nf=2 ad='int((nf+1)/2) * W/nf * 0.18u' as='int((nf+2)/2) * W/nf * 0.18u' pd='2*int((nf+1)/2) * (W/nf + 0.18u)'
+ ps='2*int((nf+2)/2) * (W/nf + 0.18u)' nrd='0.18u / W' nrs='0.18u / W' sa=0 sb=0 sd=0 m=1 par=1
XMK4 p4 VSS VSS VSS nfet_03v3 L=0.4u W=8u nf=2 ad='int((nf+1)/2) * W/nf * 0.18u' as='int((nf+2)/2) * W/nf * 0.18u' pd='2*int((nf+1)/2) * (W/nf + 0.18u)'
+ ps='2*int((nf+2)/2) * (W/nf + 0.18u)' nrd='0.18u / W' nrs='0.18u / W' sa=0 sb=0 sd=0 m=1 par=1
XMKD4 n4 VSS VSS VSS nfet_03v3 L=0.4u W=8u nf=2 ad='int((nf+1)/2) * W/nf * 0.18u' as='int((nf+2)/2) * W/nf * 0.18u' pd='2*int((nf+1)/2) * (W/nf + 0.18u)'
+ ps='2*int((nf+2)/2) * (W/nf + 0.18u)' nrd='0.18u / W' nrs='0.18u / W' sa=0 sb=0 sd=0 m=1 par=1
.ends

* expanding   symbol:  inv_lo1.sym # of pins=4
** sym_path: /home/noritsuna/GPS/xschem/inv_lo1.sym
** sch_path: /home/noritsuna/GPS/xschem/inv_lo1.sch
.subckt inv_lo1 A Y VDD VSS
*.ipin A
*.opin Y
*.iopin VDD
*.iopin VSS
XMN Y A VSS VSS nfet_03v3 L=0.28u W=2u nf=1 ad='int((nf+1)/2) * W/nf * 0.18u' as='int((nf+2)/2) * W/nf * 0.18u' pd='2*int((nf+1)/2) * (W/nf + 0.18u)'
+ ps='2*int((nf+2)/2) * (W/nf + 0.18u)' nrd='0.18u / W' nrs='0.18u / W' sa=0 sb=0 sd=0 m=1 par=1
XMP Y A VDD VDD pfet_03v3 L=0.28u W=4u nf=1 ad='int((nf+1)/2) * W/nf * 0.18u' as='int((nf+2)/2) * W/nf * 0.18u' pd='2*int((nf+1)/2) * (W/nf + 0.18u)'
+ ps='2*int((nf+2)/2) * (W/nf + 0.18u)' nrd='0.18u / W' nrs='0.18u / W' sa=0 sb=0 sd=0 m=1 par=1
.ends

* expanding   symbol:  inv_lo2.sym # of pins=4
** sym_path: /home/noritsuna/GPS/xschem/inv_lo2.sym
** sch_path: /home/noritsuna/GPS/xschem/inv_lo2.sch
.subckt inv_lo2 A Y VDD VSS
*.ipin A
*.opin Y
*.iopin VDD
*.iopin VSS
XMN Y A VSS VSS nfet_03v3 L=0.28u W=6u nf=2 ad='int((nf+1)/2) * W/nf * 0.18u' as='int((nf+2)/2) * W/nf * 0.18u' pd='2*int((nf+1)/2) * (W/nf + 0.18u)'
+ ps='2*int((nf+2)/2) * (W/nf + 0.18u)' nrd='0.18u / W' nrs='0.18u / W' sa=0 sb=0 sd=0 m=1 par=1
XMP Y A VDD VDD pfet_03v3 L=0.28u W=12u nf=4 ad='int((nf+1)/2) * W/nf * 0.18u' as='int((nf+2)/2) * W/nf * 0.18u' pd='2*int((nf+1)/2) * (W/nf + 0.18u)'
+ ps='2*int((nf+2)/2) * (W/nf + 0.18u)' nrd='0.18u / W' nrs='0.18u / W' sa=0 sb=0 sd=0 m=1 par=1
.ends

* expanding   symbol:  aoi22.sym # of pins=7
** sym_path: /home/noritsuna/GPS/xschem/aoi22.sym
** sch_path: /home/noritsuna/GPS/xschem/aoi22.sch
.subckt aoi22 A B C D Y VDD VSS
*.ipin A
*.ipin B
*.ipin C
*.ipin D
*.opin Y
*.iopin VDD
*.iopin VSS
XMNA Y A na VSS nfet_03v3 L=0.28u W=4u nf=1 ad='int((nf+1)/2) * W/nf * 0.18u' as='int((nf+2)/2) * W/nf * 0.18u' pd='2*int((nf+1)/2) * (W/nf + 0.18u)'
+ ps='2*int((nf+2)/2) * (W/nf + 0.18u)' nrd='0.18u / W' nrs='0.18u / W' sa=0 sb=0 sd=0 m=1 par=1
XMNB na B VSS VSS nfet_03v3 L=0.28u W=4u nf=1 ad='int((nf+1)/2) * W/nf * 0.18u' as='int((nf+2)/2) * W/nf * 0.18u' pd='2*int((nf+1)/2) * (W/nf + 0.18u)'
+ ps='2*int((nf+2)/2) * (W/nf + 0.18u)' nrd='0.18u / W' nrs='0.18u / W' sa=0 sb=0 sd=0 m=1 par=1
XMNC Y C nc VSS nfet_03v3 L=0.28u W=4u nf=1 ad='int((nf+1)/2) * W/nf * 0.18u' as='int((nf+2)/2) * W/nf * 0.18u' pd='2*int((nf+1)/2) * (W/nf + 0.18u)'
+ ps='2*int((nf+2)/2) * (W/nf + 0.18u)' nrd='0.18u / W' nrs='0.18u / W' sa=0 sb=0 sd=0 m=1 par=1
XMND nc D VSS VSS nfet_03v3 L=0.28u W=4u nf=1 ad='int((nf+1)/2) * W/nf * 0.18u' as='int((nf+2)/2) * W/nf * 0.18u' pd='2*int((nf+1)/2) * (W/nf + 0.18u)'
+ ps='2*int((nf+2)/2) * (W/nf + 0.18u)' nrd='0.18u / W' nrs='0.18u / W' sa=0 sb=0 sd=0 m=1 par=1
XMPA pm A VDD VDD pfet_03v3 L=0.28u W=8u nf=1 ad='int((nf+1)/2) * W/nf * 0.18u' as='int((nf+2)/2) * W/nf * 0.18u' pd='2*int((nf+1)/2) * (W/nf + 0.18u)'
+ ps='2*int((nf+2)/2) * (W/nf + 0.18u)' nrd='0.18u / W' nrs='0.18u / W' sa=0 sb=0 sd=0 m=1 par=1
XMPB pm B VDD VDD pfet_03v3 L=0.28u W=8u nf=1 ad='int((nf+1)/2) * W/nf * 0.18u' as='int((nf+2)/2) * W/nf * 0.18u' pd='2*int((nf+1)/2) * (W/nf + 0.18u)'
+ ps='2*int((nf+2)/2) * (W/nf + 0.18u)' nrd='0.18u / W' nrs='0.18u / W' sa=0 sb=0 sd=0 m=1 par=1
XMPC Y C pm VDD pfet_03v3 L=0.28u W=8u nf=1 ad='int((nf+1)/2) * W/nf * 0.18u' as='int((nf+2)/2) * W/nf * 0.18u' pd='2*int((nf+1)/2) * (W/nf + 0.18u)'
+ ps='2*int((nf+2)/2) * (W/nf + 0.18u)' nrd='0.18u / W' nrs='0.18u / W' sa=0 sb=0 sd=0 m=1 par=1
XMPD Y D pm VDD pfet_03v3 L=0.28u W=8u nf=1 ad='int((nf+1)/2) * W/nf * 0.18u' as='int((nf+2)/2) * W/nf * 0.18u' pd='2*int((nf+1)/2) * (W/nf + 0.18u)'
+ ps='2*int((nf+2)/2) * (W/nf + 0.18u)' nrd='0.18u / W' nrs='0.18u / W' sa=0 sb=0 sd=0 m=1 par=1
.ends

* expanding   symbol:  nand2.sym # of pins=5
** sym_path: /home/noritsuna/GPS/xschem/nand2.sym
** sch_path: /home/noritsuna/GPS/xschem/nand2.sch
.subckt nand2 A B Y VDD VSS
*.ipin A
*.ipin B
*.opin Y
*.iopin VDD
*.iopin VSS
XMN1 Y A n1 VSS nfet_03v3 L=0.28u W=2u nf=1 ad='int((nf+1)/2) * W/nf * 0.18u' as='int((nf+2)/2) * W/nf * 0.18u' pd='2*int((nf+1)/2) * (W/nf + 0.18u)'
+ ps='2*int((nf+2)/2) * (W/nf + 0.18u)' nrd='0.18u / W' nrs='0.18u / W' sa=0 sb=0 sd=0 m=1 par=1
XMN2 n1 B VSS VSS nfet_03v3 L=0.28u W=2u nf=1 ad='int((nf+1)/2) * W/nf * 0.18u' as='int((nf+2)/2) * W/nf * 0.18u' pd='2*int((nf+1)/2) * (W/nf + 0.18u)'
+ ps='2*int((nf+2)/2) * (W/nf + 0.18u)' nrd='0.18u / W' nrs='0.18u / W' sa=0 sb=0 sd=0 m=1 par=1
XMP1 Y A VDD VDD pfet_03v3 L=0.28u W=2u nf=1 ad='int((nf+1)/2) * W/nf * 0.18u' as='int((nf+2)/2) * W/nf * 0.18u' pd='2*int((nf+1)/2) * (W/nf + 0.18u)'
+ ps='2*int((nf+2)/2) * (W/nf + 0.18u)' nrd='0.18u / W' nrs='0.18u / W' sa=0 sb=0 sd=0 m=1 par=1
XMP2 Y B VDD VDD pfet_03v3 L=0.28u W=2u nf=1 ad='int((nf+1)/2) * W/nf * 0.18u' as='int((nf+2)/2) * W/nf * 0.18u' pd='2*int((nf+1)/2) * (W/nf + 0.18u)'
+ ps='2*int((nf+2)/2) * (W/nf + 0.18u)' nrd='0.18u / W' nrs='0.18u / W' sa=0 sb=0 sd=0 m=1 par=1
.ends

* expanding   symbol:  nor2.sym # of pins=5
** sym_path: /home/noritsuna/GPS/xschem/nor2.sym
** sch_path: /home/noritsuna/GPS/xschem/nor2.sch
.subckt nor2 A B Y VDD VSS
*.ipin A
*.ipin B
*.opin Y
*.iopin VDD
*.iopin VSS
XMN1 Y A VSS VSS nfet_03v3 L=0.28u W=1u nf=1 ad='int((nf+1)/2) * W/nf * 0.18u' as='int((nf+2)/2) * W/nf * 0.18u' pd='2*int((nf+1)/2) * (W/nf + 0.18u)'
+ ps='2*int((nf+2)/2) * (W/nf + 0.18u)' nrd='0.18u / W' nrs='0.18u / W' sa=0 sb=0 sd=0 m=1 par=1
XMN2 Y B VSS VSS nfet_03v3 L=0.28u W=1u nf=1 ad='int((nf+1)/2) * W/nf * 0.18u' as='int((nf+2)/2) * W/nf * 0.18u' pd='2*int((nf+1)/2) * (W/nf + 0.18u)'
+ ps='2*int((nf+2)/2) * (W/nf + 0.18u)' nrd='0.18u / W' nrs='0.18u / W' sa=0 sb=0 sd=0 m=1 par=1
XMP1 n1 A VDD VDD pfet_03v3 L=0.28u W=4u nf=1 ad='int((nf+1)/2) * W/nf * 0.18u' as='int((nf+2)/2) * W/nf * 0.18u' pd='2*int((nf+1)/2) * (W/nf + 0.18u)'
+ ps='2*int((nf+2)/2) * (W/nf + 0.18u)' nrd='0.18u / W' nrs='0.18u / W' sa=0 sb=0 sd=0 m=1 par=1
XMP2 Y B n1 VDD pfet_03v3 L=0.28u W=4u nf=1 ad='int((nf+1)/2) * W/nf * 0.18u' as='int((nf+2)/2) * W/nf * 0.18u' pd='2*int((nf+1)/2) * (W/nf + 0.18u)'
+ ps='2*int((nf+2)/2) * (W/nf + 0.18u)' nrd='0.18u / W' nrs='0.18u / W' sa=0 sb=0 sd=0 m=1 par=1
.ends
* NGSPICE file created from vco_ring4_flat.ext - technology: gf180mcuD

.subckt vco_ring4_flat VSS VDD VCTRL B0 B1 LOIP LOIN LOQP LOQN VR
X0 VSS VSS a_19487_65329# VSS nfet_03v3 ad=1.78p pd=8.89u as=1.06p ps=4.53u w=4u l=0.4u
X1 a_22707_78209.t2 a_8707_27249# VSS VSS nfet_03v3 ad=0.795p pd=3.53u as=1.335p ps=6.89u w=3u l=0.28u
X2 VR.t256 a_25765_39400# a_7027_78209.t0 VR.t255 pfet_03v3 ad=0.795p pd=3.53u as=0.795p ps=3.53u w=3u l=0.28u
X3 VR.t329 VSS cap_mim_2f0_m4m5_noshield c_width=5u c_length=5u
X4 a_3785_77340# a_3667_82549.t5 a_3640_91200# VR.t97 pfet_03v3 ad=3.56p pd=16.89u as=3.56p ps=16.89u w=8u l=0.28u
X5 a_38505_26660# a_40067_27249# VR.t27 VR.t26 pfet_03v3 ad=0.89p pd=4.89u as=0.89p ps=4.89u w=2u l=0.28u
X6 LOIN.t0 a_13305_77340# VR.t1 VR.t0 pfet_03v3 ad=0.795p pd=3.53u as=1.335p ps=6.89u w=3u l=0.28u
X7 VR.t60 a_25765_64740# a_24387_78209# VR.t59 pfet_03v3 ad=0.795p pd=3.53u as=0.795p ps=3.53u w=3u l=0.28u
X8 VSS a_28909_57069# a_19487_65329# VSS nfet_03v3 ad=1.78p pd=8.89u as=1.06p ps=4.53u w=4u l=0.4u
X9 VR.t158 a_28909_57069# a_19487_65329# VR.t157 pfet_03v3 ad=1.335p pd=6.89u as=0.795p ps=3.53u w=3u l=0.4u
X10 a_19487_65329# a_23253_52869# VR.t208 VR.t207 pfet_03v3 ad=0.89p pd=4.89u as=0.89p ps=4.89u w=2u l=0.4u
X11 VR.t260 a_25765_39400# a_7027_78209.t1 VR.t259 pfet_03v3 ad=1.335p pd=6.89u as=0.795p ps=3.53u w=3u l=0.28u
X12 a_31569_13109# B0 VSS VSS nfet_03v3 ad=0.445p pd=2.89u as=0.445p ps=2.89u w=1u l=0.28u
X13 a_32200_91200# a_22707_78209.t5 VR.t131 VR.t130 pfet_03v3 ad=3.56p pd=16.89u as=3.56p ps=16.89u w=8u l=0.28u
X14 a_13305_81680# a_5347_78209.t4 VSS VSS nfet_03v3 ad=1.78p pd=8.89u as=1.78p ps=8.89u w=4u l=0.28u
X15 VR.t327 a_19487_39989# a_35309_56340# VR.t326 pfet_03v3 ad=1.335p pd=6.89u as=0.795p ps=3.53u w=3u l=0.4u
X16 a_36325_56340# a_22709_52000# VR.t224 VR.t223 pfet_03v3 ad=0.795p pd=3.53u as=1.335p ps=6.89u w=3u l=0.4u
X17 a_19487_39989# a_23253_52869# VSS VSS nfet_03v3 ad=1.06p pd=4.53u as=1.78p ps=8.89u w=4u l=0.4u
X18 LOQN a_22825_77340# VSS VSS nfet_03v3 ad=0.795p pd=3.53u as=1.335p ps=6.89u w=3u l=0.28u
X19 a_18109_11960.t42 a_35769_13109.t12 VR.t200 VDD pfet_03v3 ad=1.325p pd=5.53u as=1.325p ps=5.53u w=5u l=0.28u
X20 VDD a_17709_13109.t83 VR.t180 VDD pfet_03v3 ad=1.325p pd=5.53u as=1.325p ps=5.53u w=5u l=0.28u
X21 a_40220_3486# a_40067_27249# VSS ppolyf_u_1k r_width=1u r_length=10u
X22 VR.t328 VSS cap_mim_2f0_m4m5_noshield c_width=5u c_length=5u
X23 VR.t64 a_25765_64740# a_24387_78209# VR.t63 pfet_03v3 ad=1.335p pd=6.89u as=0.795p ps=3.53u w=3u l=0.28u
X24 a_41900_3486# a_42740_1364# VSS ppolyf_u_1k r_width=1u r_length=10u
X25 VSS a_12809_65469# a_12885_64740# VSS nfet_03v3 ad=1.335p pd=6.89u as=0.795p ps=3.53u w=3u l=0.28u
X26 a_52505_26660# a_12809_40129# a_52360_26660# VSS nfet_03v3 ad=0.89p pd=4.89u as=0.89p ps=4.89u w=2u l=0.28u
X27 a_28909_57069# a_35309_56340# VR.t9 VR.t8 pfet_03v3 ad=0.795p pd=3.53u as=1.335p ps=6.89u w=3u l=0.4u
X28 a_18109_11960.t0 a_17709_13109.t16 VDD VDD pfet_03v3 ad=1.325p pd=5.53u as=1.325p ps=5.53u w=5u l=0.28u
X29 VR.t234 a_22709_52000# a_36325_56340# VR.t233 pfet_03v3 ad=1.335p pd=6.89u as=0.795p ps=3.53u w=3u l=0.4u
X30 VSS a_19487_39989# a_35309_56340# VSS nfet_03v3 ad=1.78p pd=8.89u as=1.06p ps=4.53u w=4u l=0.4u
X31 VR.t329 VSS cap_mim_2f0_m4m5_noshield c_width=5u c_length=5u
X32 VR.t174 a_17709_13109.t72 VDD VDD pfet_03v3 ad=1.325p pd=5.53u as=1.325p ps=5.53u w=5u l=0.28u
X33 VR.t329 VSS cap_mim_2f0_m4m5_noshield c_width=5u c_length=5u
X34 a_28909_57069# a_29925_57069# VR.t160 VR.t159 pfet_03v3 ad=0.89p pd=4.89u as=0.89p ps=4.89u w=2u l=0.4u
X35 a_32200_77340# a_12885_64740# VSS VSS nfet_03v3 ad=1.78p pd=8.89u as=1.78p ps=8.89u w=4u l=0.28u
X36 a_57400_77340# a_25765_64740# VSS VSS nfet_03v3 ad=0.89p pd=4.89u as=0.89p ps=4.89u w=2u l=0.28u
X37 a_22825_77340# a_22707_78209.t4 a_22680_77340# VSS nfet_03v3 ad=1.78p pd=8.89u as=1.78p ps=8.89u w=4u l=0.28u
X38 a_12809_65469# a_19487_65329# VSS VSS nfet_03v3 ad=0.89p pd=4.89u as=0.89p ps=4.89u w=2u l=0.28u
X39 a_18109_11960.t37 a_35769_13109.t44 VR.t185 VDD pfet_03v3 ad=1.325p pd=5.53u as=1.325p ps=5.53u w=5u l=0.28u
X40 VDD a_17709_13109.t75 VR.t125 VDD pfet_03v3 ad=1.325p pd=5.53u as=1.325p ps=5.53u w=5u l=0.28u
X41 VDD a_17709_13109.t155 VR.t222 VDD pfet_03v3 ad=1.325p pd=5.53u as=1.325p ps=5.53u w=5u l=0.28u
X42 a_35309_56340# a_36325_56340# VSS VSS nfet_03v3 ad=0.445p pd=2.89u as=0.445p ps=2.89u w=1u l=0.4u
X43 a_3785_81680# a_3667_82549.t4 VSS VSS nfet_03v3 ad=1.78p pd=8.89u as=1.78p ps=8.89u w=4u l=0.28u
X44 VSS VSS a_19487_39989# VSS nfet_03v3 ad=1.78p pd=8.89u as=1.06p ps=4.53u w=4u l=0.4u
X45 a_18109_11960.t4 a_17709_13109.t88 VDD VDD pfet_03v3 ad=1.325p pd=5.53u as=1.325p ps=5.53u w=5u l=0.28u
X46 LOQP a_32345_77340# VR.t244 VR.t243 pfet_03v3 ad=0.795p pd=3.53u as=1.335p ps=6.89u w=3u l=0.28u
X47 a_12809_40129# a_19487_39989# VR.t319 VR.t318 pfet_03v3 ad=1.78p pd=8.89u as=1.78p ps=8.89u w=4u l=0.28u
X48 a_52505_26660# a_25765_39400# VR.t262 VR.t261 pfet_03v3 ad=0.89p pd=4.89u as=0.89p ps=4.89u w=2u l=0.28u
X49 VR.t194 a_19487_65329# a_22709_52000# VR.t193 pfet_03v3 ad=0.795p pd=3.53u as=0.795p ps=3.53u w=3u l=0.4u
X50 VR.t236 a_17709_13109.t144 VDD VDD pfet_03v3 ad=1.325p pd=5.53u as=1.325p ps=5.53u w=5u l=0.28u
X51 a_35769_13109.t1 B1.t0 VSS VSS nfet_03v3 ad=0.445p pd=2.89u as=0.445p ps=2.89u w=1u l=0.28u
X52 a_18109_11960.t16 a_17709_13109.t70 VDD VDD pfet_03v3 ad=1.325p pd=5.53u as=1.325p ps=5.53u w=5u l=0.28u
X53 a_22709_52000# a_19487_39989# VR.t321 VR.t320 pfet_03v3 ad=0.89p pd=4.89u as=0.89p ps=4.89u w=2u l=0.4u
X54 VSS a_32345_77340# LOQP VSS nfet_03v3 ad=1.335p pd=6.89u as=0.795p ps=3.53u w=3u l=0.28u
X55 a_13305_77340# a_7027_78209.t5 a_13160_91200# VR.t111 pfet_03v3 ad=3.56p pd=16.89u as=3.56p ps=16.89u w=8u l=0.28u
X56 a_19487_65329# a_23253_52869# VSS VSS nfet_03v3 ad=0.445p pd=2.89u as=0.445p ps=2.89u w=1u l=0.4u
X57 a_22709_52000# a_19487_65329# VSS VSS nfet_03v3 ad=1.06p pd=4.53u as=1.78p ps=8.89u w=4u l=0.4u
X58 a_16665_27002# a_10387_27249.t2 a_16665_30860# VR.t146 pfet_03v3 ad=1.78p pd=8.89u as=1.78p ps=8.89u w=4u l=0.28u
X59 a_10387_27249.t1 a_35309_56340# VSS VSS nfet_03v3 ad=0.89p pd=4.89u as=0.89p ps=4.89u w=2u l=0.28u
X60 VR.t328 VSS cap_mim_2f0_m4m5_noshield c_width=5u c_length=5u
X61 a_18109_11960.t16 a_17709_13109.t82 VDD VDD pfet_03v3 ad=1.325p pd=5.53u as=1.325p ps=5.53u w=5u l=0.28u
X62 VDD a_17709_13109.t147 VR.t182 VDD pfet_03v3 ad=1.325p pd=5.53u as=1.325p ps=5.53u w=5u l=0.28u
X63 VR.t176 a_35769_13109.t17 a_18109_11960.t30 VDD pfet_03v3 ad=1.325p pd=5.53u as=1.325p ps=5.53u w=5u l=0.28u
X64 a_23253_52869# a_29925_57069# VR.t162 VR.t161 pfet_03v3 ad=0.795p pd=3.53u as=1.335p ps=6.89u w=3u l=0.4u
X65 VR.t329 VSS cap_mim_2f0_m4m5_noshield c_width=5u c_length=5u
X66 a_17709_13109.t11 VCTRL a_35000_1180# VSS nfet_03v3 ad=1.325p pd=5.53u as=2.225p ps=10.89u w=5u l=0.5u
X67 a_60345_27002# a_25765_39400# a_60345_30860# VR.t263 pfet_03v3 ad=1.78p pd=8.89u as=1.78p ps=8.89u w=4u l=0.28u
X68 a_29925_57069# a_28909_57069# VSS VSS nfet_03v3 ad=0.445p pd=2.89u as=0.445p ps=2.89u w=1u l=0.4u
X69 VDD a_17709_13109.t21 VR.t186 VDD pfet_03v3 ad=1.325p pd=5.53u as=1.325p ps=5.53u w=5u l=0.28u
X70 VDD a_17709_13109.t77 a_18109_11960.t16 VDD pfet_03v3 ad=1.325p pd=5.53u as=1.325p ps=5.53u w=5u l=0.28u
X71 a_7027_78209.t0 a_25765_39400# VR.t254 VR.t253 pfet_03v3 ad=0.795p pd=3.53u as=1.335p ps=6.89u w=3u l=0.28u
X72 VSS VSS a_23253_52869# VSS nfet_03v3 ad=1.78p pd=8.89u as=1.06p ps=4.53u w=4u l=0.4u
X73 a_18109_11960.t46 a_17709_13109.t142 VDD VDD pfet_03v3 ad=1.325p pd=5.53u as=1.325p ps=5.53u w=5u l=0.28u
X74 VR.t329 VSS cap_mim_2f0_m4m5_noshield c_width=5u c_length=5u
X75 a_18109_11960.t12 a_17709_13109.t24 VDD VDD pfet_03v3 ad=1.325p pd=5.53u as=1.325p ps=5.53u w=5u l=0.28u
X76 a_18109_11960.t56 a_17709_13109.t154 VDD VDD pfet_03v3 ad=1.325p pd=5.53u as=1.325p ps=5.53u w=5u l=0.28u
X77 VR.t250 a_32345_77340# LOQP VR.t249 pfet_03v3 ad=1.335p pd=6.89u as=0.795p ps=3.53u w=3u l=0.28u
X78 a_25765_64740# a_23253_52869# VSS VSS nfet_03v3 ad=0.89p pd=4.89u as=0.89p ps=4.89u w=2u l=0.28u
X79 a_36325_56340# a_35309_56340# VR.t13 VR.t12 pfet_03v3 ad=0.89p pd=4.89u as=0.89p ps=4.89u w=2u l=0.4u
X80 a_40067_27249# VSS cap_mim_2f0_m4m5_noshield c_width=5u c_length=5u
X81 VR.t114 a_35769_13109.t49 a_18109_11960.t47 VDD pfet_03v3 ad=1.325p pd=5.53u as=1.325p ps=5.53u w=5u l=0.28u
X82 VR.t122 a_17709_13109.t80 VDD VDD pfet_03v3 ad=1.325p pd=5.53u as=1.325p ps=5.53u w=5u l=0.28u
X83 a_18109_11960.t57 a_17709_13109.t42 VDD VDD pfet_03v3 ad=1.325p pd=5.53u as=1.325p ps=5.53u w=5u l=0.28u
X84 a_24387_78209# a_25765_64740# VR.t58 VR.t57 pfet_03v3 ad=0.795p pd=3.53u as=1.335p ps=6.89u w=3u l=0.28u
X85 VSS a_25765_39400# a_7027_78209.t2 VSS nfet_03v3 ad=1.335p pd=6.89u as=0.795p ps=3.53u w=3u l=0.28u
X86 a_36325_56340# a_22709_52000# VSS VSS nfet_03v3 ad=1.06p pd=4.53u as=1.78p ps=8.89u w=4u l=0.4u
X87 VR.t82 a_10387_27249.t5 a_26067_78209.t0 VR.t81 pfet_03v3 ad=0.795p pd=3.53u as=0.795p ps=3.53u w=3u l=0.28u
X88 VDD a_17709_13109.t93 VR.t303 VDD pfet_03v3 ad=1.325p pd=5.53u as=1.325p ps=5.53u w=5u l=0.28u
X89 a_25765_39400# a_22709_52000# VR.t232 VR.t231 pfet_03v3 ad=1.78p pd=8.89u as=1.78p ps=8.89u w=4u l=0.28u
X90 VR.t328 VSS cap_mim_2f0_m4m5_noshield c_width=5u c_length=5u
X91 a_35000_1180# VSS VSS ppolyf_u_1k r_width=2u r_length=4u
X92 a_19487_39989# a_23253_52869# VR.t214 VR.t213 pfet_03v3 ad=0.795p pd=3.53u as=0.795p ps=3.53u w=3u l=0.4u
X93 VDD a_17709_13109.t149 a_18109_11960.t22 VDD pfet_03v3 ad=1.325p pd=5.53u as=1.325p ps=5.53u w=5u l=0.28u
X94 a_32345_27002# a_23897_52869# VSS VSS nfet_03v3 ad=0.445p pd=2.89u as=0.445p ps=2.89u w=1u l=0.28u
X95 a_43580_3486# a_44420_1364# VSS ppolyf_u_1k r_width=1u r_length=10u
X96 VR.t329 VSS cap_mim_2f0_m4m5_noshield c_width=5u c_length=5u
X97 a_18109_11960.t19 a_17709_13109.t96 VDD VDD pfet_03v3 ad=1.325p pd=5.53u as=1.325p ps=5.53u w=5u l=0.28u
X98 a_46940_3486# a_46100_1364# VSS ppolyf_u_1k r_width=1u r_length=10u
X99 a_24505_30860# a_8825_26660# VR.t88 VR.t87 pfet_03v3 ad=1.78p pd=8.89u as=1.78p ps=8.89u w=4u l=0.28u
X100 VDD a_17709_13109.t37 VR.t98 VDD pfet_03v3 ad=1.325p pd=5.53u as=1.325p ps=5.53u w=5u l=0.28u
X101 VR.t270 a_43427_77929# a_5347_78209.t0 VR.t269 pfet_03v3 ad=0.795p pd=3.53u as=0.795p ps=3.53u w=3u l=0.28u
X102 VDD a_17709_13109.t17 VR.t121 VDD pfet_03v3 ad=1.325p pd=5.53u as=1.325p ps=5.53u w=5u l=0.28u
X103 VR.t129 a_17709_13109.t152 VDD VDD pfet_03v3 ad=1.325p pd=5.53u as=1.325p ps=5.53u w=5u l=0.28u
X104 a_18109_11960.t25 a_35769_13109.t22 VR.t171 VDD pfet_03v3 ad=1.325p pd=5.53u as=1.325p ps=5.53u w=5u l=0.28u
X105 VSS a_22825_77340# LOQN VSS nfet_03v3 ad=1.335p pd=6.89u as=0.795p ps=3.53u w=3u l=0.28u
X106 a_23253_52869# a_29925_57069# VR.t168 VR.t167 pfet_03v3 ad=0.795p pd=3.53u as=0.795p ps=3.53u w=3u l=0.4u
X107 a_18109_11960.t36 a_17709_13109.t114 VDD VDD pfet_03v3 ad=1.325p pd=5.53u as=1.325p ps=5.53u w=5u l=0.28u
X108 a_22825_77340# a_12885_64740# a_22680_91200# VR.t23 pfet_03v3 ad=3.56p pd=16.89u as=3.56p ps=16.89u w=8u l=0.28u
X109 a_41865_77340# a_38569_65469# VR.t276 VR.t275 pfet_03v3 ad=0.89p pd=4.89u as=0.89p ps=4.89u w=2u l=0.28u
X110 VDD a_17709_13109.t73 a_18109_11960.t16 VDD pfet_03v3 ad=1.325p pd=5.53u as=1.325p ps=5.53u w=5u l=0.28u
X111 LOQP a_32345_77340# VR.t248 VR.t247 pfet_03v3 ad=0.795p pd=3.53u as=0.795p ps=3.53u w=3u l=0.28u
X112 VR.t329 VSS cap_mim_2f0_m4m5_noshield c_width=5u c_length=5u
X113 VR.t172 a_35769_13109.t25 a_18109_11960.t52 VDD pfet_03v3 ad=1.325p pd=5.53u as=1.325p ps=5.53u w=5u l=0.28u
X114 VR.t116 a_17709_13109.t26 VDD VDD pfet_03v3 ad=1.325p pd=5.53u as=1.325p ps=5.53u w=5u l=0.28u
X115 VR.t125 a_17709_13109.t76 VDD VDD pfet_03v3 ad=1.325p pd=5.53u as=1.325p ps=5.53u w=5u l=0.28u
X116 VSS a_36325_56340# a_29925_57069# VSS nfet_03v3 ad=1.78p pd=8.89u as=1.06p ps=4.53u w=4u l=0.4u
X117 VR.t218 a_35769_13109.t11 a_18109_11960.t42 VDD pfet_03v3 ad=1.325p pd=5.53u as=1.325p ps=5.53u w=5u l=0.28u
X118 a_28909_57069# a_35309_56340# VSS VSS nfet_03v3 ad=1.06p pd=4.53u as=1.78p ps=8.89u w=4u l=0.4u
X119 VDD a_17709_13109.t29 VR.t199 VDD pfet_03v3 ad=1.325p pd=5.53u as=1.325p ps=5.53u w=5u l=0.28u
X120 VDD a_17709_13109.t109 VR.t120 VDD pfet_03v3 ad=1.325p pd=5.53u as=1.325p ps=5.53u w=5u l=0.28u
X121 a_40220_3486# a_41060_1364# VSS ppolyf_u_1k r_width=1u r_length=10u
X122 VDD a_17709_13109.t89 VR.t221 VDD pfet_03v3 ad=1.325p pd=5.53u as=1.325p ps=5.53u w=5u l=0.28u
X123 a_43580_3486# a_42740_1364# VSS ppolyf_u_1k r_width=1u r_length=10u
X124 a_41720_77340# a_43427_77929# VSS VSS nfet_03v3 ad=0.89p pd=4.89u as=0.89p ps=4.89u w=2u l=0.28u
X125 a_18109_11960.t32 a_35769_13109.t54 VR.t52 VDD pfet_03v3 ad=1.325p pd=5.53u as=1.325p ps=5.53u w=5u l=0.28u
X126 VDD a_17709_13109.t15 a_18109_11960.t0 VDD pfet_03v3 ad=1.325p pd=5.53u as=1.325p ps=5.53u w=5u l=0.28u
X127 LOIP.t1 a_3785_77340# VSS VSS nfet_03v3 ad=0.795p pd=3.53u as=1.335p ps=6.89u w=3u l=0.28u
X128 a_32345_77340# a_22707_78209.t3 a_32200_77340# VSS nfet_03v3 ad=1.78p pd=8.89u as=1.78p ps=8.89u w=4u l=0.28u
X129 a_22709_52000# a_19487_65329# VR.t196 VR.t195 pfet_03v3 ad=0.795p pd=3.53u as=0.795p ps=3.53u w=3u l=0.4u
X130 a_18109_11960.t40 a_35769_13109.t20 VR.t217 VDD pfet_03v3 ad=1.325p pd=5.53u as=1.325p ps=5.53u w=5u l=0.28u
X131 VDD a_17709_13109.t45 a_21997_11960# VDD pfet_03v3 ad=1.325p pd=5.53u as=1.325p ps=5.53u w=5u l=0.28u
X132 VDD a_17709_13109.t145 a_18109_11960.t34 VDD pfet_03v3 ad=1.325p pd=5.53u as=1.325p ps=5.53u w=5u l=0.28u
X133 VDD a_17709_13109.t71 VR.t174 VDD pfet_03v3 ad=1.325p pd=5.53u as=1.325p ps=5.53u w=5u l=0.28u
X134 VR.t328 VSS cap_mim_2f0_m4m5_noshield c_width=5u c_length=5u
X135 VR.t53 a_35769_13109.t57 a_18109_11960.t3 VDD pfet_03v3 ad=1.325p pd=5.53u as=1.325p ps=5.53u w=5u l=0.28u
X136 VR.t121 a_17709_13109.t18 VDD VDD pfet_03v3 ad=1.325p pd=5.53u as=1.325p ps=5.53u w=5u l=0.28u
X137 VR.t127 a_17709_13109.t98 VDD VDD pfet_03v3 ad=1.325p pd=5.53u as=1.325p ps=5.53u w=5u l=0.28u
X138 VR.t329 VSS cap_mim_2f0_m4m5_noshield c_width=5u c_length=5u
X139 VR.t182 a_17709_13109.t148 VDD VDD pfet_03v3 ad=1.325p pd=5.53u as=1.325p ps=5.53u w=5u l=0.28u
X140 VR.t119 a_35769_13109.t43 a_18109_11960.t37 VDD pfet_03v3 ad=1.325p pd=5.53u as=1.325p ps=5.53u w=5u l=0.28u
X141 a_18109_11960.t16 a_17709_13109.t74 VDD VDD pfet_03v3 ad=1.325p pd=5.53u as=1.325p ps=5.53u w=5u l=0.28u
X142 a_16665_27002# a_8707_27249# VSS VSS nfet_03v3 ad=0.445p pd=2.89u as=0.445p ps=2.89u w=1u l=0.28u
X143 VR.t115 a_35769_13109.t9 a_18109_11960.t11 VDD pfet_03v3 ad=1.325p pd=5.53u as=1.325p ps=5.53u w=5u l=0.28u
X144 VR.t329 VSS cap_mim_2f0_m4m5_noshield c_width=5u c_length=5u
X145 a_18109_11960.t38 a_17709_13109.t36 VDD VDD pfet_03v3 ad=1.325p pd=5.53u as=1.325p ps=5.53u w=5u l=0.28u
X146 VDD a_17709_13109.t101 VR.t173 VDD pfet_03v3 ad=1.325p pd=5.53u as=1.325p ps=5.53u w=5u l=0.28u
X147 a_8680_26660# a_10387_27249.t3 VSS VSS nfet_03v3 ad=0.89p pd=4.89u as=0.89p ps=4.89u w=2u l=0.28u
X148 a_22825_77340# a_26067_78209.t6 a_22680_91200# VR.t240 pfet_03v3 ad=3.56p pd=16.89u as=3.56p ps=16.89u w=8u l=0.28u
X149 VR.t186 a_17709_13109.t22 VDD VDD pfet_03v3 ad=1.325p pd=5.53u as=1.325p ps=5.53u w=5u l=0.28u
X150 VDD a_17709_13109.t87 a_18109_11960.t4 VDD pfet_03v3 ad=1.325p pd=5.53u as=1.325p ps=5.53u w=5u l=0.28u
X151 VSS VSS a_28909_57069# VSS nfet_03v3 ad=1.78p pd=8.89u as=1.06p ps=4.53u w=4u l=0.4u
X152 VR.t252 a_35769_13109.t27 a_18109_11960.t50 VDD pfet_03v3 ad=1.325p pd=5.53u as=1.325p ps=5.53u w=5u l=0.28u
X153 a_18109_11960.t31 a_35769_13109.t52 VR.t178 VDD pfet_03v3 ad=1.325p pd=5.53u as=1.325p ps=5.53u w=5u l=0.28u
X154 VR.t228 a_22709_52000# a_36325_56340# VR.t227 pfet_03v3 ad=0.795p pd=3.53u as=0.795p ps=3.53u w=3u l=0.4u
X155 VDD a_17709_13109.t13 VR.t181 VDD pfet_03v3 ad=2.225p pd=10.89u as=1.325p ps=5.53u w=5u l=0.28u
X156 VDD a_17709_13109.t117 a_21997_11960# VDD pfet_03v3 ad=1.325p pd=5.53u as=1.325p ps=5.53u w=5u l=0.28u
X157 VR.t138 a_12809_40129# a_3667_78209# VR.t137 pfet_03v3 ad=0.795p pd=3.53u as=0.795p ps=3.53u w=3u l=0.28u
X158 a_26067_27389# VSS cap_mim_2f0_m4m5_noshield c_width=5u c_length=5u
X159 VDD a_17709_13109.t43 VR.t307 VDD pfet_03v3 ad=1.325p pd=5.53u as=1.325p ps=5.53u w=5u l=0.28u
X160 a_18109_11960.t16 a_17709_13109.t78 VDD VDD pfet_03v3 ad=1.325p pd=5.53u as=1.325p ps=5.53u w=5u l=0.28u
X161 VDD a_17709_13109.t143 VR.t236 VDD pfet_03v3 ad=1.325p pd=5.53u as=1.325p ps=5.53u w=5u l=0.28u
X162 VR.t329 VSS cap_mim_2f0_m4m5_noshield c_width=5u c_length=5u
X163 VR.t221 a_17709_13109.t90 VDD VDD pfet_03v3 ad=1.325p pd=5.53u as=1.325p ps=5.53u w=5u l=0.28u
X164 a_37337_52869# a_38505_26660# VSS VSS nfet_03v3 ad=0.445p pd=2.89u as=0.445p ps=2.89u w=1u l=0.28u
X165 LOQN a_22825_77340# VR.t40 VR.t39 pfet_03v3 ad=0.795p pd=3.53u as=1.335p ps=6.89u w=3u l=0.28u
X166 a_18109_11960.t51 a_35769_13109.t30 VR.t241 VDD pfet_03v3 ad=1.325p pd=5.53u as=1.325p ps=5.53u w=5u l=0.28u
X167 VDD a_17709_13109.t31 a_18109_11960.t38 VDD pfet_03v3 ad=1.325p pd=5.53u as=1.325p ps=5.53u w=5u l=0.28u
X168 LOQN a_22825_77340# VR.t44 VR.t43 pfet_03v3 ad=0.795p pd=3.53u as=0.795p ps=3.53u w=3u l=0.28u
X169 VR.t15 a_35309_56340# a_28909_57069# VR.t14 pfet_03v3 ad=0.795p pd=3.53u as=0.795p ps=3.53u w=3u l=0.4u
X170 VDD a_17709_13109.t81 a_18109_11960.t16 VDD pfet_03v3 ad=1.325p pd=5.53u as=1.325p ps=5.53u w=5u l=0.28u
X171 a_18109_11960.t34 a_17709_13109.t146 VDD VDD pfet_03v3 ad=1.325p pd=5.53u as=1.325p ps=5.53u w=5u l=0.28u
X172 a_60345_30860# a_12809_40129# VR.t134 VR.t133 pfet_03v3 ad=1.78p pd=8.89u as=1.78p ps=8.89u w=4u l=0.28u
X173 a_18109_11960.t29 a_35769_13109.t16 VR.t176 VDD pfet_03v3 ad=1.325p pd=5.53u as=1.325p ps=5.53u w=5u l=0.28u
X174 a_22825_81680# a_12885_64740# VSS VSS nfet_03v3 ad=1.78p pd=8.89u as=1.78p ps=8.89u w=4u l=0.28u
X175 VR.t118 a_35769_13109.t41 a_18109_11960.t15 VDD pfet_03v3 ad=1.325p pd=5.53u as=1.325p ps=5.53u w=5u l=0.28u
X176 VR.t74 a_12809_65469# a_12885_64740# VR.t73 pfet_03v3 ad=0.795p pd=3.53u as=0.795p ps=3.53u w=3u l=0.28u
X177 a_18109_11960.t41 a_17709_13109.t108 VDD VDD pfet_03v3 ad=1.325p pd=5.53u as=1.325p ps=5.53u w=5u l=0.28u
X178 VR.t302 a_17709_13109.t34 VDD VDD pfet_03v3 ad=1.325p pd=5.53u as=1.325p ps=5.53u w=5u l=0.28u
X179 VSS a_13305_77340# LOIN.t2 VSS nfet_03v3 ad=1.335p pd=6.89u as=0.795p ps=3.53u w=3u l=0.28u
X180 a_18109_11960.t13 a_17709_13109.t62 VDD VDD pfet_03v3 ad=1.325p pd=5.53u as=1.325p ps=5.53u w=5u l=0.28u
X181 VR.t303 a_17709_13109.t94 VDD VDD pfet_03v3 ad=1.325p pd=5.53u as=1.325p ps=5.53u w=5u l=0.28u
X182 VR.t177 a_35769_13109.t19 a_18109_11960.t40 VDD pfet_03v3 ad=1.325p pd=5.53u as=1.325p ps=5.53u w=5u l=0.28u
X183 VR.t311 a_35769_13109.t59 a_18109_11960.t58 VDD pfet_03v3 ad=1.325p pd=5.53u as=1.325p ps=5.53u w=5u l=0.28u
X184 a_13305_77340# a_7027_78209.t3 a_13305_81680# VSS nfet_03v3 ad=1.78p pd=8.89u as=1.78p ps=8.89u w=4u l=0.28u
X185 a_5347_78209.t2 a_43427_77929# VSS VSS nfet_03v3 ad=0.795p pd=3.53u as=1.335p ps=6.89u w=3u l=0.28u
X186 a_18109_11960.t7 a_17709_13109.t20 VDD VDD pfet_03v3 ad=1.325p pd=5.53u as=1.325p ps=5.53u w=5u l=0.28u
X187 VDD a_17709_13109.t85 VR.t77 VDD pfet_03v3 ad=2.225p pd=10.89u as=1.325p ps=5.53u w=5u l=0.28u
X188 a_18109_11960.t6 a_17709_13109.t50 VDD VDD pfet_03v3 ad=1.325p pd=5.53u as=1.325p ps=5.53u w=5u l=0.28u
X189 a_18109_11960.t22 a_17709_13109.t150 VDD VDD pfet_03v3 ad=1.325p pd=5.53u as=1.325p ps=5.53u w=5u l=0.28u
X190 a_45260_3486# a_46100_1364# VSS ppolyf_u_1k r_width=1u r_length=10u
X191 VDD a_17709_13109.t115 VR.t184 VDD pfet_03v3 ad=1.325p pd=5.53u as=1.325p ps=5.53u w=5u l=0.28u
X192 a_35000_1180# VCTRL a_17709_13109.t12 VSS nfet_03v3 ad=2.225p pd=10.89u as=1.325p ps=5.53u w=5u l=0.5u
X193 a_18109_11960.t43 a_35769_13109.t62 VR.t220 VDD pfet_03v3 ad=1.325p pd=5.53u as=1.325p ps=5.53u w=5u l=0.28u
X194 VDD a_17709_13109.t23 a_18109_11960.t12 VDD pfet_03v3 ad=1.325p pd=5.53u as=1.325p ps=5.53u w=5u l=0.28u
X195 a_7027_78209.t2 a_25765_39400# VSS VSS nfet_03v3 ad=0.795p pd=3.53u as=1.335p ps=6.89u w=3u l=0.28u
X196 VSS a_22709_52000# a_36325_56340# VSS nfet_03v3 ad=1.78p pd=8.89u as=1.06p ps=4.53u w=4u l=0.4u
X197 a_3640_91200# a_5347_78209.t5 VR.t30 VR.t29 pfet_03v3 ad=3.56p pd=16.89u as=3.56p ps=16.89u w=8u l=0.28u
X198 a_35309_56340# a_19487_39989# VR.t317 VR.t316 pfet_03v3 ad=0.795p pd=3.53u as=1.335p ps=6.89u w=3u l=0.4u
X199 VR.t328 VSS cap_mim_2f0_m4m5_noshield c_width=5u c_length=5u
X200 VDD a_17709_13109.t103 a_18109_11960.t27 VDD pfet_03v3 ad=1.325p pd=5.53u as=1.325p ps=5.53u w=5u l=0.28u
X201 a_35309_56340# a_37337_52869# VSS VSS nfet_03v3 ad=1.06p pd=4.53u as=1.78p ps=8.89u w=4u l=0.4u
X202 a_18109_11960.t50 a_35769_13109.t28 VR.t251 VDD pfet_03v3 ad=1.325p pd=5.53u as=1.325p ps=5.53u w=5u l=0.28u
X203 VR.t329 VSS cap_mim_2f0_m4m5_noshield c_width=5u c_length=5u
X204 VDD a_17709_13109.t53 VR.t183 VDD pfet_03v3 ad=1.325p pd=5.53u as=1.325p ps=5.53u w=5u l=0.28u
X205 VDD a_17709_13109.t153 a_18109_11960.t56 VDD pfet_03v3 ad=1.325p pd=5.53u as=1.325p ps=5.53u w=5u l=0.28u
X206 a_18109_11960.t10 a_35769_13109.t48 VR.t114 VDD pfet_03v3 ad=1.325p pd=5.53u as=1.325p ps=5.53u w=5u l=0.28u
X207 VDD a_17709_13109.t79 VR.t122 VDD pfet_03v3 ad=1.325p pd=5.53u as=1.325p ps=5.53u w=5u l=0.28u
X208 a_18109_11960.t39 a_35769_13109.t14 VR.t201 VDD pfet_03v3 ad=1.325p pd=5.53u as=1.325p ps=5.53u w=5u l=0.28u
X209 a_17709_13109.t12 VCTRL a_35000_1180# VSS nfet_03v3 ad=1.325p pd=5.53u as=1.325p ps=5.53u w=5u l=0.5u
X210 VDD a_17709_13109.t41 a_18109_11960.t57 VDD pfet_03v3 ad=1.325p pd=5.53u as=1.325p ps=5.53u w=5u l=0.28u
X211 VR.t287 a_17709_13109.t106 VDD VDD pfet_03v3 ad=1.325p pd=5.53u as=1.325p ps=5.53u w=5u l=0.28u
X212 a_57545_77340# a_12809_65469# a_57400_77340# VSS nfet_03v3 ad=0.89p pd=4.89u as=0.89p ps=4.89u w=2u l=0.28u
X213 a_29925_57069# a_36325_56340# VR.t295 VR.t294 pfet_03v3 ad=0.795p pd=3.53u as=1.335p ps=6.89u w=3u l=0.4u
X214 a_18109_11960.t21 a_17709_13109.t134 VDD VDD pfet_03v3 ad=1.325p pd=5.53u as=1.325p ps=5.53u w=5u l=0.28u
X215 a_26067_78209.t1 a_10387_27249.t5 VR.t84 VR.t83 pfet_03v3 ad=0.795p pd=3.53u as=0.795p ps=3.53u w=3u l=0.28u
X216 VR.t237 a_35769_13109.t51 a_18109_11960.t31 VDD pfet_03v3 ad=1.325p pd=5.53u as=1.325p ps=5.53u w=5u l=0.28u
X217 VDD a_17709_13109.t27 a_18109_11960.t12 VDD pfet_03v3 ad=1.325p pd=5.53u as=1.325p ps=5.53u w=5u l=0.28u
X218 a_18109_11960.t44 a_17709_13109.t92 VDD VDD pfet_03v3 ad=1.325p pd=5.53u as=1.325p ps=5.53u w=5u l=0.28u
X219 a_8825_26660# a_8707_27249# a_8680_26660# VSS nfet_03v3 ad=0.89p pd=4.89u as=0.89p ps=4.89u w=2u l=0.28u
X220 a_3667_78209# a_12809_40129# VR.t140 VR.t139 pfet_03v3 ad=0.795p pd=3.53u as=0.795p ps=3.53u w=3u l=0.28u
X221 VR.t7 a_13305_77340# LOIN.t1 VR.t6 pfet_03v3 ad=1.335p pd=6.89u as=0.795p ps=3.53u w=3u l=0.28u
X222 VSS a_19487_65329# a_22709_52000# VSS nfet_03v3 ad=1.78p pd=8.89u as=1.06p ps=4.53u w=4u l=0.4u
X223 a_18109_11960.t48 a_35769_13109.t32 VR.t242 VDD pfet_03v3 ad=1.325p pd=5.53u as=1.325p ps=5.53u w=5u l=0.28u
X224 a_8707_27249# a_36325_56340# VSS VSS nfet_03v3 ad=0.89p pd=4.89u as=0.89p ps=4.89u w=2u l=0.28u
X225 a_35000_1180# VCTRL a_17709_13109.t11 VSS nfet_03v3 ad=1.325p pd=5.53u as=1.325p ps=5.53u w=5u l=0.5u
X226 VSS a_10387_27249.t5 a_26067_78209.t2 VSS nfet_03v3 ad=1.335p pd=6.89u as=0.795p ps=3.53u w=3u l=0.28u
X227 a_18109_11960.t33 a_17709_13109.t122 VDD VDD pfet_03v3 ad=1.325p pd=5.53u as=1.325p ps=5.53u w=5u l=0.28u
X228 a_18109_11960.t6 a_17709_13109.t48 VDD VDD pfet_03v3 ad=1.325p pd=5.53u as=1.325p ps=5.53u w=5u l=0.28u
X229 VR.t246 a_32345_77340# LOQP VR.t245 pfet_03v3 ad=0.795p pd=3.53u as=0.795p ps=3.53u w=3u l=0.28u
X230 a_32345_77340# a_24387_78209# a_32200_91200# VR.t202 pfet_03v3 ad=3.56p pd=16.89u as=3.56p ps=16.89u w=8u l=0.28u
X231 VR.t199 a_17709_13109.t30 VDD VDD pfet_03v3 ad=1.325p pd=5.53u as=1.325p ps=5.53u w=5u l=0.28u
X232 a_39800_3486# a_26067_27389# VSS ppolyf_u_1k r_width=1u r_length=10u
X233 VDD a_17709_13109.t95 a_18109_11960.t19 VDD pfet_03v3 ad=1.325p pd=5.53u as=1.325p ps=5.53u w=5u l=0.28u
X234 a_52505_26660# a_12809_40129# VR.t144 VR.t143 pfet_03v3 ad=0.89p pd=4.89u as=0.89p ps=4.89u w=2u l=0.28u
X235 a_45260_3486# a_44420_1364# VSS ppolyf_u_1k r_width=1u r_length=10u
X236 a_18109_11960.t58 a_35769_13109.t60 VR.t219 VDD pfet_03v3 ad=1.325p pd=5.53u as=1.325p ps=5.53u w=5u l=0.28u
X237 VDD a_17709_13109.t125 VR.t308 VDD pfet_03v3 ad=1.325p pd=5.53u as=1.325p ps=5.53u w=5u l=0.28u
X238 a_5347_78209.t1 a_43427_77929# VR.t272 VR.t271 pfet_03v3 ad=0.795p pd=3.53u as=0.795p ps=3.53u w=3u l=0.28u
X239 a_46940_3486# a_16665_27002# VSS ppolyf_u_1k r_width=1u r_length=10u
X240 VDD a_17709_13109.t51 a_21997_11960# VDD pfet_03v3 ad=1.325p pd=5.53u as=1.325p ps=5.53u w=5u l=0.28u
X241 VDD a_17709_13109.t151 VR.t129 VDD pfet_03v3 ad=1.325p pd=5.53u as=1.325p ps=5.53u w=5u l=0.28u
X242 a_12885_64740# a_12809_65469# VR.t68 VR.t67 pfet_03v3 ad=0.795p pd=3.53u as=0.795p ps=3.53u w=3u l=0.28u
X243 VR.t217 a_35769_13109.t21 a_18109_11960.t25 VDD pfet_03v3 ad=1.325p pd=5.53u as=1.325p ps=5.53u w=5u l=0.28u
X244 a_13160_91200# a_3667_82549.t3 VR.t315 VR.t314 pfet_03v3 ad=3.56p pd=16.89u as=3.56p ps=16.89u w=8u l=0.28u
X245 a_65385_77682# a_25765_64740# VSS VSS nfet_03v3 ad=0.445p pd=2.89u as=0.445p ps=2.89u w=1u l=0.28u
X246 a_18109_11960.t9 a_35769_13109.t46 VR.t113 VDD pfet_03v3 ad=1.325p pd=5.53u as=1.325p ps=5.53u w=5u l=0.28u
X247 VDD a_17709_13109.t113 a_18109_11960.t36 VDD pfet_03v3 ad=1.325p pd=5.53u as=1.325p ps=5.53u w=5u l=0.28u
X248 VDD a_17709_13109.t39 a_21997_11960# VDD pfet_03v3 ad=1.325p pd=5.53u as=1.325p ps=5.53u w=5u l=0.28u
X249 a_29925_57069# VSS VSS VSS nfet_03v3 ad=1.06p pd=4.53u as=1.78p ps=8.89u w=4u l=0.4u
X250 VR.t329 VSS cap_mim_2f0_m4m5_noshield c_width=5u c_length=5u
X251 VR.t328 VSS cap_mim_2f0_m4m5_noshield c_width=5u c_length=5u
X252 VDD a_17709_13109.t67 VR.t179 VDD pfet_03v3 ad=1.325p pd=5.53u as=1.325p ps=5.53u w=5u l=0.28u
X253 VDD a_17709_13109.t99 a_18109_11960.t45 VDD pfet_03v3 ad=1.325p pd=5.53u as=1.325p ps=5.53u w=5u l=0.28u
X254 a_57545_77340# a_25765_64740# VR.t55 VR.t54 pfet_03v3 ad=0.89p pd=4.89u as=0.89p ps=4.89u w=2u l=0.28u
X255 a_18109_11960.t26 a_35769_13109.t24 VR.t172 VDD pfet_03v3 ad=1.325p pd=5.53u as=1.325p ps=5.53u w=5u l=0.28u
X256 a_18109_11960.t23 a_35769_13109.t64 VR.t132 VDD pfet_03v3 ad=1.325p pd=5.53u as=1.325p ps=5.53u w=5u l=0.28u
X257 VDD a_17709_13109.t25 VR.t116 VDD pfet_03v3 ad=1.325p pd=5.53u as=1.325p ps=5.53u w=5u l=0.28u
X258 VR.t198 a_19487_65329# a_22709_52000# VR.t197 pfet_03v3 ad=1.335p pd=6.89u as=0.795p ps=3.53u w=3u l=0.4u
X259 VDD a_17709_13109.t7 a_17709_13109.t6 VDD pfet_03v3 ad=1.325p pd=5.53u as=1.325p ps=5.53u w=5u l=0.28u
X260 a_18109_11960.t55 a_17709_13109.t120 VDD VDD pfet_03v3 ad=1.325p pd=5.53u as=1.325p ps=5.53u w=5u l=0.28u
X261 VSS a_3785_77340# LOIP.t1 VSS nfet_03v3 ad=1.335p pd=6.89u as=0.795p ps=3.53u w=3u l=0.28u
X262 a_18109_11960.t11 a_35769_13109.t10 VR.t218 VDD pfet_03v3 ad=1.325p pd=5.53u as=1.325p ps=5.53u w=5u l=0.28u
X263 VR.t329 VSS cap_mim_2f0_m4m5_noshield c_width=5u c_length=5u
X264 VR.t173 a_17709_13109.t102 VDD VDD pfet_03v3 ad=1.325p pd=5.53u as=1.325p ps=5.53u w=5u l=0.28u
X265 a_49705_77682# a_38569_65469# VSS VSS nfet_03v3 ad=0.445p pd=2.89u as=0.445p ps=2.89u w=1u l=0.28u
X266 a_18109_11960.t12 a_17709_13109.t28 VDD VDD pfet_03v3 ad=1.325p pd=5.53u as=1.325p ps=5.53u w=5u l=0.28u
X267 VR.t242 a_35769_13109.t33 a_18109_11960.t49 VDD pfet_03v3 ad=1.325p pd=5.53u as=2.225p ps=10.89u w=5u l=0.28u
X268 a_18109_11960.t35 a_17709_13109.t56 VDD VDD pfet_03v3 ad=1.325p pd=5.53u as=1.325p ps=5.53u w=5u l=0.28u
X269 VDD a_17709_13109.t123 a_21997_11960# VDD pfet_03v3 ad=1.325p pd=5.53u as=1.325p ps=5.53u w=5u l=0.28u
X270 VR.t200 a_35769_13109.t13 a_18109_11960.t39 VDD pfet_03v3 ad=1.325p pd=5.53u as=1.325p ps=5.53u w=5u l=0.28u
X271 a_19487_65329# a_28909_57069# VR.t150 VR.t149 pfet_03v3 ad=0.795p pd=3.53u as=1.335p ps=6.89u w=3u l=0.4u
X272 VR.t178 a_35769_13109.t53 a_18109_11960.t32 VDD pfet_03v3 ad=1.325p pd=5.53u as=1.325p ps=5.53u w=5u l=0.28u
X273 VR.t181 a_17709_13109.t14 VDD VDD pfet_03v3 ad=1.325p pd=5.53u as=1.325p ps=5.53u w=5u l=0.28u
X274 VR.t180 a_17709_13109.t84 VDD VDD pfet_03v3 ad=1.325p pd=5.53u as=2.225p ps=10.89u w=5u l=0.28u
X275 VR.t307 a_17709_13109.t44 VDD VDD pfet_03v3 ad=1.325p pd=5.53u as=1.325p ps=5.53u w=5u l=0.28u
X276 VDD a_17709_13109.t111 a_21997_11960# VDD pfet_03v3 ad=1.325p pd=5.53u as=1.325p ps=5.53u w=5u l=0.28u
X277 a_23897_52869# a_26067_27389# VSS VSS nfet_03v3 ad=0.445p pd=2.89u as=0.445p ps=2.89u w=1u l=0.28u
X278 VR.t216 a_23253_52869# a_19487_39989# VR.t215 pfet_03v3 ad=1.335p pd=6.89u as=0.795p ps=3.53u w=3u l=0.4u
X279 VR.t86 a_10387_27249.t5 a_26067_78209.t1 VR.t85 pfet_03v3 ad=1.335p pd=6.89u as=0.795p ps=3.53u w=3u l=0.28u
X280 a_12885_64740# a_12809_65469# VSS VSS nfet_03v3 ad=0.795p pd=3.53u as=1.335p ps=6.89u w=3u l=0.28u
X281 VDD a_17709_13109.t139 VR.t112 VDD pfet_03v3 ad=1.325p pd=5.53u as=1.325p ps=5.53u w=5u l=0.28u
X282 VR.t241 a_35769_13109.t31 a_18109_11960.t48 VDD pfet_03v3 ad=1.325p pd=5.53u as=1.325p ps=5.53u w=5u l=0.28u
X283 a_18109_11960.t2 a_35769_13109.t56 VR.t53 VDD pfet_03v3 ad=1.325p pd=5.53u as=1.325p ps=5.53u w=5u l=0.28u
X284 a_18109_11960.t38 a_17709_13109.t32 VDD VDD pfet_03v3 ad=1.325p pd=5.53u as=1.325p ps=5.53u w=5u l=0.28u
X285 VDD a_17709_13109.t97 VR.t127 VDD pfet_03v3 ad=1.325p pd=5.53u as=1.325p ps=5.53u w=5u l=0.28u
X286 VDD a_17709_13109.t47 a_18109_11960.t6 VDD pfet_03v3 ad=1.325p pd=5.53u as=1.325p ps=5.53u w=5u l=0.28u
X287 VDD a_17709_13109.t2 a_17709_13109.t1 VDD pfet_03v3 ad=1.325p pd=5.53u as=1.325p ps=5.53u w=5u l=0.28u
X288 a_18109_11960.t15 a_35769_13109.t42 VR.t119 VDD pfet_03v3 ad=1.325p pd=5.53u as=1.325p ps=5.53u w=5u l=0.28u
X289 VR.t170 a_29925_57069# a_23253_52869# VR.t169 pfet_03v3 ad=1.335p pd=6.89u as=0.795p ps=3.53u w=3u l=0.4u
X290 a_18109_11960.t53 a_35769_13109.t8 VR.t115 VDD pfet_03v3 ad=1.325p pd=5.53u as=1.325p ps=5.53u w=5u l=0.28u
X291 VR.t38 a_3785_77340# LOIP.t0 VR.t37 pfet_03v3 ad=1.335p pd=6.89u as=0.795p ps=3.53u w=3u l=0.28u
X292 VDD a_17709_13109.t35 a_18109_11960.t38 VDD pfet_03v3 ad=1.325p pd=5.53u as=1.325p ps=5.53u w=5u l=0.28u
X293 a_18109_11960.t45 a_17709_13109.t100 VDD VDD pfet_03v3 ad=1.325p pd=5.53u as=1.325p ps=5.53u w=5u l=0.28u
X294 VR.t274 a_43427_77929# a_5347_78209.t1 VR.t273 pfet_03v3 ad=1.335p pd=6.89u as=0.795p ps=3.53u w=3u l=0.28u
X295 a_39800_3486# a_40640_1364# VSS ppolyf_u_1k r_width=1u r_length=10u
X296 VR.t328 VSS cap_mim_2f0_m4m5_noshield c_width=5u c_length=5u
X297 VR.t132 a_35769_13109.t65 a_18109_11960.t24 VDD pfet_03v3 ad=1.325p pd=5.53u as=2.225p ps=10.89u w=5u l=0.28u
X298 VDD a_17709_13109.t63 VR.t117 VDD pfet_03v3 ad=1.325p pd=5.53u as=1.325p ps=5.53u w=5u l=0.28u
X299 a_18109_11960.t54 a_17709_13109.t128 VDD VDD pfet_03v3 ad=1.325p pd=5.53u as=1.325p ps=5.53u w=5u l=0.28u
X300 VR.t42 a_22825_77340# LOQN VR.t41 pfet_03v3 ad=0.795p pd=3.53u as=0.795p ps=3.53u w=3u l=0.28u
X301 VSS a_38569_65469# a_3667_82549.t2 VSS nfet_03v3 ad=1.335p pd=6.89u as=0.795p ps=3.53u w=3u l=0.28u
X302 VR.t185 a_35769_13109.t45 a_18109_11960.t9 VDD pfet_03v3 ad=1.325p pd=5.53u as=1.325p ps=5.53u w=5u l=0.28u
X303 a_21997_11960# a_31569_13109# VR.t94 VDD pfet_03v3 ad=1.325p pd=5.53u as=1.325p ps=5.53u w=5u l=0.28u
X304 a_17709_13109.t6 a_17709_13109.t5 VDD VDD pfet_03v3 ad=1.325p pd=5.53u as=1.325p ps=5.53u w=5u l=0.28u
X305 a_43427_77929# a_29925_57069# VR.t164 VR.t163 pfet_03v3 ad=1.78p pd=8.89u as=1.78p ps=8.89u w=4u l=0.28u
X306 VR.t77 a_17709_13109.t86 VDD VDD pfet_03v3 ad=1.325p pd=5.53u as=1.325p ps=5.53u w=5u l=0.28u
X307 VR.t222 a_17709_13109.t156 VDD VDD pfet_03v3 ad=1.325p pd=5.53u as=2.225p ps=10.89u w=5u l=0.28u
X308 a_18109_11960.t52 a_35769_13109.t26 VR.t252 VDD pfet_03v3 ad=1.325p pd=5.53u as=1.325p ps=5.53u w=5u l=0.28u
X309 VR.t184 a_17709_13109.t116 VDD VDD pfet_03v3 ad=1.325p pd=5.53u as=1.325p ps=5.53u w=5u l=0.28u
X310 a_32345_81680# a_24387_78209# VSS VSS nfet_03v3 ad=1.78p pd=8.89u as=1.78p ps=8.89u w=4u l=0.28u
X311 a_17709_13109.t9 a_17709_13109.t8 VDD VDD pfet_03v3 ad=1.325p pd=5.53u as=1.325p ps=5.53u w=5u l=0.28u
X312 VSS a_12809_40129# a_3667_78209# VSS nfet_03v3 ad=1.335p pd=6.89u as=0.795p ps=3.53u w=3u l=0.28u
X313 VR.t329 VSS cap_mim_2f0_m4m5_noshield c_width=5u c_length=5u
X314 VR.t220 a_35769_13109.t63 a_18109_11960.t23 VDD pfet_03v3 ad=1.325p pd=5.53u as=1.325p ps=5.53u w=5u l=0.28u
X315 a_18109_11960.t27 a_17709_13109.t104 VDD VDD pfet_03v3 ad=1.325p pd=5.53u as=1.325p ps=5.53u w=5u l=0.28u
X316 VR.t251 a_35769_13109.t29 a_18109_11960.t51 VDD pfet_03v3 ad=1.325p pd=5.53u as=1.325p ps=5.53u w=5u l=0.28u
X317 VR.t329 VSS cap_mim_2f0_m4m5_noshield c_width=5u c_length=5u
X318 VDD a_17709_13109.t119 a_18109_11960.t55 VDD pfet_03v3 ad=1.325p pd=5.53u as=1.325p ps=5.53u w=5u l=0.28u
X319 a_21997_11960# a_17709_13109.t58 VDD VDD pfet_03v3 ad=1.325p pd=5.53u as=1.325p ps=5.53u w=5u l=0.28u
X320 a_22825_77340# a_26067_78209.t4 a_22825_81680# VSS nfet_03v3 ad=1.78p pd=8.89u as=1.78p ps=8.89u w=4u l=0.28u
X321 VR.t201 a_35769_13109.t15 a_18109_11960.t29 VDD pfet_03v3 ad=1.325p pd=5.53u as=1.325p ps=5.53u w=5u l=0.28u
X322 a_18109_11960.t14 a_35769_13109.t40 VR.t118 VDD pfet_03v3 ad=1.325p pd=5.53u as=1.325p ps=5.53u w=5u l=0.28u
X323 VDD a_17709_13109.t107 a_18109_11960.t41 VDD pfet_03v3 ad=1.325p pd=5.53u as=1.325p ps=5.53u w=5u l=0.28u
X324 a_38505_26660# a_16665_27002# a_38360_26660# VSS nfet_03v3 ad=0.89p pd=4.89u as=0.89p ps=4.89u w=2u l=0.28u
X325 VDD a_17709_13109.t33 VR.t302 VDD pfet_03v3 ad=1.325p pd=5.53u as=1.325p ps=5.53u w=5u l=0.28u
X326 VDD a_17709_13109.t135 VR.t128 VDD pfet_03v3 ad=1.325p pd=5.53u as=1.325p ps=5.53u w=5u l=0.28u
X327 LOIP.t2 a_3785_77340# VR.t32 VR.t31 pfet_03v3 ad=0.795p pd=3.53u as=1.335p ps=6.89u w=3u l=0.28u
X328 VDD a_17709_13109.t61 a_18109_11960.t13 VDD pfet_03v3 ad=1.325p pd=5.53u as=1.325p ps=5.53u w=5u l=0.28u
X329 a_17709_13109.t1 a_17709_13109.t0 VDD VDD pfet_03v3 ad=1.325p pd=5.53u as=1.325p ps=5.53u w=5u l=0.28u
X330 a_12809_40129# a_19487_39989# VSS VSS nfet_03v3 ad=0.89p pd=4.89u as=0.89p ps=4.89u w=2u l=0.28u
X331 a_18109_11960.t30 a_35769_13109.t18 VR.t177 VDD pfet_03v3 ad=1.325p pd=5.53u as=1.325p ps=5.53u w=5u l=0.28u
X332 a_18109_11960.t3 a_35769_13109.t58 VR.t311 VDD pfet_03v3 ad=1.325p pd=5.53u as=1.325p ps=5.53u w=5u l=0.28u
X333 a_21997_11960# a_31569_13109# VR.t95 VDD pfet_03v3 ad=1.325p pd=5.53u as=1.325p ps=5.53u w=5u l=0.28u
X334 VDD a_17709_13109.t19 a_18109_11960.t7 VDD pfet_03v3 ad=1.325p pd=5.53u as=1.325p ps=5.53u w=5u l=0.28u
X335 VDD a_17709_13109.t49 a_18109_11960.t6 VDD pfet_03v3 ad=1.325p pd=5.53u as=1.325p ps=5.53u w=5u l=0.28u
X336 a_17709_13109.t1 a_17709_13109.t3 VDD VDD pfet_03v3 ad=1.325p pd=5.53u as=1.325p ps=5.53u w=5u l=0.28u
X337 a_19487_39989# a_23253_52869# VR.t210 VR.t209 pfet_03v3 ad=0.795p pd=3.53u as=1.335p ps=6.89u w=3u l=0.4u
X338 a_3667_82549.t2 a_38569_65469# VSS VSS nfet_03v3 ad=0.795p pd=3.53u as=1.335p ps=6.89u w=3u l=0.28u
X339 VR.t219 a_35769_13109.t61 a_18109_11960.t43 VDD pfet_03v3 ad=1.325p pd=5.53u as=1.325p ps=5.53u w=5u l=0.28u
X340 LOIN.t1 a_13305_77340# VR.t5 VR.t4 pfet_03v3 ad=0.795p pd=3.53u as=0.795p ps=3.53u w=3u l=0.28u
X341 a_21997_11960# a_17709_13109.t52 VDD VDD pfet_03v3 ad=1.325p pd=5.53u as=1.325p ps=5.53u w=5u l=0.28u
X342 a_21997_11960# a_17709_13109.t130 VDD VDD pfet_03v3 ad=1.325p pd=5.53u as=1.325p ps=5.53u w=5u l=0.28u
X343 VSS a_23253_52869# a_19487_39989# VSS nfet_03v3 ad=1.78p pd=8.89u as=1.06p ps=4.53u w=4u l=0.4u
X344 VR.t113 a_35769_13109.t47 a_18109_11960.t10 VDD pfet_03v3 ad=1.325p pd=5.53u as=1.325p ps=5.53u w=5u l=0.28u
X345 a_19487_39989# a_22709_52000# VR.t226 VR.t225 pfet_03v3 ad=0.89p pd=4.89u as=0.89p ps=4.89u w=2u l=0.4u
X346 VR.t328 VSS cap_mim_2f0_m4m5_noshield c_width=5u c_length=5u
X347 a_21997_11960# a_17709_13109.t40 VDD VDD pfet_03v3 ad=1.325p pd=5.53u as=1.325p ps=5.53u w=5u l=0.28u
X348 VDD a_17709_13109.t105 VR.t287 VDD pfet_03v3 ad=1.325p pd=5.53u as=1.325p ps=5.53u w=5u l=0.28u
X349 VR.t329 VSS cap_mim_2f0_m4m5_noshield c_width=5u c_length=5u
X350 VR.t179 a_17709_13109.t68 VDD VDD pfet_03v3 ad=1.325p pd=5.53u as=1.325p ps=5.53u w=5u l=0.28u
X351 VR.t329 VSS cap_mim_2f0_m4m5_noshield c_width=5u c_length=5u
X352 VDD a_17709_13109.t133 a_18109_11960.t21 VDD pfet_03v3 ad=1.325p pd=5.53u as=1.325p ps=5.53u w=5u l=0.28u
X353 a_18109_11960.t47 a_35769_13109.t50 VR.t237 VDD pfet_03v3 ad=1.325p pd=5.53u as=1.325p ps=5.53u w=5u l=0.28u
X354 VR.t92 a_31569_13109# a_21997_11960# VDD pfet_03v3 ad=1.325p pd=5.53u as=1.325p ps=5.53u w=5u l=0.28u
X355 VDD a_17709_13109.t59 VR.t126 VDD pfet_03v3 ad=1.325p pd=5.53u as=1.325p ps=5.53u w=5u l=0.28u
X356 VDD a_17709_13109.t91 a_18109_11960.t44 VDD pfet_03v3 ad=1.325p pd=5.53u as=1.325p ps=5.53u w=5u l=0.28u
X357 VR.t142 a_12809_40129# a_3667_78209# VR.t141 pfet_03v3 ad=1.335p pd=6.89u as=0.795p ps=3.53u w=3u l=0.28u
X358 a_3640_77340# a_5347_78209.t3 VSS VSS nfet_03v3 ad=1.78p pd=8.89u as=1.78p ps=8.89u w=4u l=0.28u
X359 VDD a_17709_13109.t10 a_17709_13109.t9 VDD pfet_03v3 ad=1.325p pd=5.53u as=1.325p ps=5.53u w=5u l=0.28u
X360 VDD a_17709_13109.t121 a_18109_11960.t33 VDD pfet_03v3 ad=1.325p pd=5.53u as=1.325p ps=5.53u w=5u l=0.28u
X361 a_23253_52869# a_19487_65329# VR.t190 VR.t189 pfet_03v3 ad=0.89p pd=4.89u as=0.89p ps=4.89u w=2u l=0.4u
X362 a_13160_91200# a_3667_78209# VR.t49 VR.t48 pfet_03v3 ad=3.56p pd=16.89u as=3.56p ps=16.89u w=8u l=0.28u
X363 a_22680_91200# a_24387_78209# VR.t204 VR.t203 pfet_03v3 ad=3.56p pd=16.89u as=3.56p ps=16.89u w=8u l=0.28u
X364 a_32345_77340# a_26067_78209.t5 a_32200_91200# VR.t28 pfet_03v3 ad=3.56p pd=16.89u as=3.56p ps=16.89u w=8u l=0.28u
X365 a_49705_77682# a_43427_77929# VSS VSS nfet_03v3 ad=0.445p pd=2.89u as=0.445p ps=2.89u w=1u l=0.28u
X366 a_26067_78209.t0 a_10387_27249.t5 VR.t80 VR.t79 pfet_03v3 ad=0.795p pd=3.53u as=1.335p ps=6.89u w=3u l=0.28u
X367 a_18109_11960.t1 a_35769_13109.t6 VR.t235 VDD pfet_03v3 ad=1.325p pd=5.53u as=1.325p ps=5.53u w=5u l=0.28u
X368 a_21997_11960# a_31569_13109# VR.t90 VDD pfet_03v3 ad=1.325p pd=5.53u as=1.325p ps=5.53u w=5u l=0.28u
X369 a_19487_39989# VSS VSS VSS nfet_03v3 ad=1.06p pd=4.53u as=1.78p ps=8.89u w=4u l=0.4u
X370 VDD a_17709_13109.t57 a_21997_11960# VDD pfet_03v3 ad=1.325p pd=5.53u as=1.325p ps=5.53u w=5u l=0.28u
X371 VR.t154 a_28909_57069# a_19487_65329# VR.t153 pfet_03v3 ad=0.795p pd=3.53u as=0.795p ps=3.53u w=3u l=0.4u
X372 a_21997_11960# a_17709_13109.t124 VDD VDD pfet_03v3 ad=1.325p pd=5.53u as=1.325p ps=5.53u w=5u l=0.28u
X373 a_41865_77340# a_43427_77929# VR.t267 VR.t266 pfet_03v3 ad=0.89p pd=4.89u as=0.89p ps=4.89u w=2u l=0.28u
X374 VR.t76 a_12809_65469# a_12885_64740# VR.t75 pfet_03v3 ad=1.335p pd=6.89u as=0.795p ps=3.53u w=3u l=0.28u
X375 a_21997_11960# a_17709_13109.t112 VDD VDD pfet_03v3 ad=1.325p pd=5.53u as=1.325p ps=5.53u w=5u l=0.28u
X376 VR.t3 a_13305_77340# LOIN.t0 VR.t2 pfet_03v3 ad=0.795p pd=3.53u as=0.795p ps=3.53u w=3u l=0.28u
X377 VR.t98 a_17709_13109.t38 VDD VDD pfet_03v3 ad=1.325p pd=5.53u as=1.325p ps=5.53u w=5u l=0.28u
X378 VR.t112 a_17709_13109.t140 VDD VDD pfet_03v3 ad=1.325p pd=5.53u as=1.325p ps=5.53u w=5u l=0.28u
X379 a_5347_78209.t0 a_43427_77929# VR.t265 VR.t264 pfet_03v3 ad=0.795p pd=3.53u as=1.335p ps=6.89u w=3u l=0.28u
X380 VSS a_29925_57069# a_23253_52869# VSS nfet_03v3 ad=1.78p pd=8.89u as=1.06p ps=4.53u w=4u l=0.4u
X381 a_18109_11960.t16 a_17709_13109.t66 VDD VDD pfet_03v3 ad=1.325p pd=5.53u as=1.325p ps=5.53u w=5u l=0.28u
X382 a_25765_39400# a_22709_52000# VSS VSS nfet_03v3 ad=0.89p pd=4.89u as=0.89p ps=4.89u w=2u l=0.28u
X383 VDD a_17709_13109.t131 VR.t304 VDD pfet_03v3 ad=1.325p pd=5.53u as=1.325p ps=5.53u w=5u l=0.28u
X384 VR.t323 a_19487_39989# a_35309_56340# VR.t322 pfet_03v3 ad=0.795p pd=3.53u as=0.795p ps=3.53u w=3u l=0.4u
X385 VR.t171 a_35769_13109.t23 a_18109_11960.t26 VDD pfet_03v3 ad=1.325p pd=5.53u as=1.325p ps=5.53u w=5u l=0.28u
X386 VR.t93 a_31569_13109# a_21997_11960# VDD pfet_03v3 ad=1.325p pd=5.53u as=1.325p ps=5.53u w=5u l=0.28u
X387 VSS a_37337_52869# a_35309_56340# VSS nfet_03v3 ad=1.78p pd=8.89u as=1.06p ps=4.53u w=4u l=0.4u
X388 VDD a_17709_13109.t4 a_17709_13109.t1 VDD pfet_03v3 ad=1.325p pd=5.53u as=1.325p ps=5.53u w=5u l=0.28u
X389 a_36325_56340# VSS VSS VSS nfet_03v3 ad=1.06p pd=4.53u as=1.78p ps=8.89u w=4u l=0.4u
X390 a_35309_56340# a_36325_56340# VR.t291 VR.t290 pfet_03v3 ad=0.89p pd=4.89u as=0.89p ps=4.89u w=2u l=0.4u
X391 VR.t183 a_17709_13109.t54 VDD VDD pfet_03v3 ad=1.325p pd=5.53u as=1.325p ps=5.53u w=5u l=0.28u
X392 a_18109_11960.t28 a_35769_13109.t38 VR.t175 VDD pfet_03v3 ad=1.325p pd=5.53u as=1.325p ps=5.53u w=5u l=0.28u
X393 a_41480_3486# a_42320_1364# VSS ppolyf_u_1k r_width=1u r_length=10u
X394 VDD a_17709_13109.t69 a_18109_11960.t16 VDD pfet_03v3 ad=1.325p pd=5.53u as=1.325p ps=5.53u w=5u l=0.28u
X395 a_13160_77340# a_3667_82549.t3 VSS VSS nfet_03v3 ad=1.78p pd=8.89u as=1.78p ps=8.89u w=4u l=0.28u
X396 a_18109_11960.t20 a_35769_13109.t4 VR.t47 VDD pfet_03v3 ad=1.325p pd=5.53u as=1.325p ps=5.53u w=5u l=0.28u
X397 a_21997_11960# a_31569_13109# VR.t91 VDD pfet_03v3 ad=1.325p pd=5.53u as=1.325p ps=5.53u w=5u l=0.28u
X398 a_8825_26660# a_10387_27249.t4 VR.t313 VR.t312 pfet_03v3 ad=0.89p pd=4.89u as=0.89p ps=4.89u w=2u l=0.28u
X399 a_44840_3486# a_44000_1364# VSS ppolyf_u_1k r_width=1u r_length=10u
X400 VDD a_17709_13109.t129 a_21997_11960# VDD pfet_03v3 ad=1.325p pd=5.53u as=1.325p ps=5.53u w=5u l=0.28u
X401 VR.t297 a_36325_56340# a_29925_57069# VR.t296 pfet_03v3 ad=0.795p pd=3.53u as=0.795p ps=3.53u w=3u l=0.4u
X402 VDD a_17709_13109.t55 a_18109_11960.t35 VDD pfet_03v3 ad=1.325p pd=5.53u as=1.325p ps=5.53u w=5u l=0.28u
X403 a_3640_91200# a_3667_78209# VR.t51 VR.t50 pfet_03v3 ad=3.56p pd=16.89u as=3.56p ps=16.89u w=8u l=0.28u
X404 a_29925_57069# a_28909_57069# VR.t148 VR.t147 pfet_03v3 ad=0.89p pd=4.89u as=0.89p ps=4.89u w=2u l=0.4u
X405 LOIP.t0 a_3785_77340# VR.t36 VR.t35 pfet_03v3 ad=0.795p pd=3.53u as=0.795p ps=3.53u w=3u l=0.28u
X406 VR.t120 a_17709_13109.t110 VDD VDD pfet_03v3 ad=1.325p pd=5.53u as=1.325p ps=5.53u w=5u l=0.28u
X407 a_23253_52869# VSS VSS VSS nfet_03v3 ad=1.06p pd=4.53u as=1.78p ps=8.89u w=4u l=0.4u
X408 VR.t329 VSS cap_mim_2f0_m4m5_noshield c_width=5u c_length=5u
X409 VR.t329 VSS cap_mim_2f0_m4m5_noshield c_width=5u c_length=5u
X410 a_18109_11960.t8 a_17709_13109.t138 VDD VDD pfet_03v3 ad=1.325p pd=5.53u as=1.325p ps=5.53u w=5u l=0.28u
X411 VR.t52 a_35769_13109.t55 a_18109_11960.t2 VDD pfet_03v3 ad=1.325p pd=5.53u as=1.325p ps=5.53u w=5u l=0.28u
X412 a_21997_11960# a_31569_13109# VR.t89 VDD pfet_03v3 ad=1.325p pd=5.53u as=1.325p ps=5.53u w=5u l=0.28u
X413 VR.t117 a_17709_13109.t64 VDD VDD pfet_03v3 ad=1.325p pd=5.53u as=1.325p ps=5.53u w=5u l=0.28u
X414 a_16665_27002# a_10387_27249.t2 VSS VSS nfet_03v3 ad=0.445p pd=2.89u as=0.445p ps=2.89u w=1u l=0.28u
X415 a_21997_11960# a_17709_13109.t46 VDD VDD pfet_03v3 ad=1.325p pd=5.53u as=1.325p ps=5.53u w=5u l=0.28u
X416 a_38360_26660# a_40067_27249# VSS VSS nfet_03v3 ad=0.89p pd=4.89u as=0.89p ps=4.89u w=2u l=0.28u
X417 VR.t106 a_8707_27249# a_22707_78209.t1 VR.t105 pfet_03v3 ad=1.335p pd=6.89u as=0.795p ps=3.53u w=3u l=0.28u
X418 VR.t308 a_17709_13109.t126 VDD VDD pfet_03v3 ad=1.325p pd=5.53u as=1.325p ps=5.53u w=5u l=0.28u
X419 VDD a_17709_13109.t141 a_18109_11960.t46 VDD pfet_03v3 ad=1.325p pd=5.53u as=1.325p ps=5.53u w=5u l=0.28u
X420 a_32345_27002# a_23897_52869# VR.t306 VR.t305 pfet_03v3 ad=0.89p pd=4.89u as=0.89p ps=4.89u w=2u l=0.28u
X421 a_22709_52000# a_23897_52869# VSS VSS nfet_03v3 ad=1.06p pd=4.53u as=1.78p ps=8.89u w=4u l=0.4u
X422 a_18109_11960.t18 a_35769_13109.t36 VR.t124 VDD pfet_03v3 ad=1.325p pd=5.53u as=1.325p ps=5.53u w=5u l=0.28u
X423 VSS VSS a_29925_57069# VSS nfet_03v3 ad=1.78p pd=8.89u as=1.06p ps=4.53u w=4u l=0.4u
X424 VDD a_17709_13109.t127 a_18109_11960.t54 VDD pfet_03v3 ad=1.325p pd=5.53u as=1.325p ps=5.53u w=5u l=0.28u
X425 a_41480_3486# a_40640_1364# VSS ppolyf_u_1k r_width=1u r_length=10u
X426 VR.t95 a_31569_13109# a_21997_11960# VDD pfet_03v3 ad=1.325p pd=5.53u as=1.325p ps=5.53u w=5u l=0.28u
X427 a_60345_27002# a_25765_39400# VSS VSS nfet_03v3 ad=0.445p pd=2.89u as=0.445p ps=2.89u w=1u l=0.28u
X428 a_65385_77682# a_25765_64740# a_65385_81540# VR.t56 pfet_03v3 ad=1.78p pd=8.89u as=1.78p ps=8.89u w=4u l=0.28u
X429 VR.t286 a_38569_65469# a_3667_82549.t1 VR.t285 pfet_03v3 ad=1.335p pd=6.89u as=0.795p ps=3.53u w=3u l=0.28u
X430 a_43427_77929# a_29925_57069# VSS VSS nfet_03v3 ad=0.89p pd=4.89u as=0.89p ps=4.89u w=2u l=0.28u
X431 VR.t46 a_22825_77340# LOQN VR.t45 pfet_03v3 ad=1.335p pd=6.89u as=0.795p ps=3.53u w=3u l=0.28u
X432 a_65385_77682# a_12809_65469# VSS VSS nfet_03v3 ad=0.445p pd=2.89u as=0.445p ps=2.89u w=1u l=0.28u
X433 a_21997_11960# a_31569_13109# VR.t93 VDD pfet_03v3 ad=1.325p pd=5.53u as=1.325p ps=5.53u w=5u l=0.28u
X434 VR.t128 a_17709_13109.t136 VDD VDD pfet_03v3 ad=1.325p pd=5.53u as=1.325p ps=5.53u w=5u l=0.28u
X435 VR.t34 a_3785_77340# LOIP.t2 VR.t33 pfet_03v3 ad=0.795p pd=3.53u as=0.795p ps=3.53u w=3u l=0.28u
X436 VR.t328 VSS cap_mim_2f0_m4m5_noshield c_width=5u c_length=5u
X437 a_21997_11960# a_17709_13109.t118 VDD VDD pfet_03v3 ad=1.325p pd=5.53u as=1.325p ps=5.53u w=5u l=0.28u
X438 a_3667_78209# a_12809_40129# VR.t136 VR.t135 pfet_03v3 ad=0.795p pd=3.53u as=1.335p ps=6.89u w=3u l=0.28u
X439 a_28909_57069# a_29925_57069# VSS VSS nfet_03v3 ad=0.445p pd=2.89u as=0.445p ps=2.89u w=1u l=0.4u
X440 a_10387_27249.t0 a_35309_56340# VR.t11 VR.t10 pfet_03v3 ad=1.78p pd=8.89u as=1.78p ps=8.89u w=4u l=0.28u
X441 a_57545_77340# a_12809_65469# VR.t72 VR.t71 pfet_03v3 ad=0.89p pd=4.89u as=0.89p ps=4.89u w=2u l=0.28u
X442 VR.t166 a_29925_57069# a_23253_52869# VR.t165 pfet_03v3 ad=0.795p pd=3.53u as=0.795p ps=3.53u w=3u l=0.4u
X443 VR.t89 a_31569_13109# a_21997_11960# VDD pfet_03v3 ad=1.325p pd=5.53u as=2.225p ps=10.89u w=5u l=0.28u
X444 a_49705_81540# a_38569_65469# VR.t280 VR.t279 pfet_03v3 ad=1.78p pd=8.89u as=1.78p ps=8.89u w=4u l=0.28u
X445 VR.t126 a_17709_13109.t60 VDD VDD pfet_03v3 ad=1.325p pd=5.53u as=1.325p ps=5.53u w=5u l=0.28u
X446 a_8825_26660# a_8707_27249# VR.t108 VR.t107 pfet_03v3 ad=0.89p pd=4.89u as=0.89p ps=4.89u w=2u l=0.28u
X447 VR.t96 a_31569_13109# a_21997_11960# VDD pfet_03v3 ad=1.325p pd=5.53u as=1.325p ps=5.53u w=5u l=0.28u
X448 a_12885_64740# a_12809_65469# VR.t66 VR.t65 pfet_03v3 ad=0.795p pd=3.53u as=1.335p ps=6.89u w=3u l=0.28u
X449 a_19487_65329# VSS VSS VSS nfet_03v3 ad=1.06p pd=4.53u as=1.78p ps=8.89u w=4u l=0.4u
X450 VR.t104 a_8707_27249# a_22707_78209.t0 VR.t103 pfet_03v3 ad=0.795p pd=3.53u as=0.795p ps=3.53u w=3u l=0.28u
X451 a_3785_77340# a_7027_78209.t6 a_3640_91200# VR.t310 pfet_03v3 ad=3.56p pd=16.89u as=3.56p ps=16.89u w=8u l=0.28u
X452 VR.t235 a_35769_13109.t7 a_18109_11960.t53 VDD pfet_03v3 ad=1.325p pd=5.53u as=1.325p ps=5.53u w=5u l=0.28u
X453 VR.t329 VSS cap_mim_2f0_m4m5_noshield c_width=5u c_length=5u
X454 LOIN.t2 a_13305_77340# VSS VSS nfet_03v3 ad=0.795p pd=3.53u as=1.335p ps=6.89u w=3u l=0.28u
X455 a_23897_52869# a_8825_26660# VSS VSS nfet_03v3 ad=0.445p pd=2.89u as=0.445p ps=2.89u w=1u l=0.28u
X456 VSS a_25765_64740# a_24387_78209# VSS nfet_03v3 ad=1.335p pd=6.89u as=0.795p ps=3.53u w=3u l=0.28u
X457 a_38569_65469# a_28909_57069# VR.t152 VR.t151 pfet_03v3 ad=1.78p pd=8.89u as=1.78p ps=8.89u w=4u l=0.28u
X458 a_16665_30860# a_8707_27249# VR.t110 VR.t109 pfet_03v3 ad=1.78p pd=8.89u as=1.78p ps=8.89u w=4u l=0.28u
X459 VSS a_35309_56340# a_28909_57069# VSS nfet_03v3 ad=1.78p pd=8.89u as=1.06p ps=4.53u w=4u l=0.4u
X460 a_19487_65329# a_28909_57069# VSS VSS nfet_03v3 ad=1.06p pd=4.53u as=1.78p ps=8.89u w=4u l=0.4u
X461 VR.t282 a_38569_65469# a_3667_82549.t0 VR.t281 pfet_03v3 ad=0.795p pd=3.53u as=0.795p ps=3.53u w=3u l=0.28u
X462 VR.t304 a_17709_13109.t132 VDD VDD pfet_03v3 ad=1.325p pd=5.53u as=1.325p ps=5.53u w=5u l=0.28u
X463 a_18109_11960.t5 a_35769_13109.t2 VR.t78 VDD pfet_03v3 ad=2.225p pd=10.89u as=1.325p ps=5.53u w=5u l=0.28u
X464 VR.t328 VSS cap_mim_2f0_m4m5_noshield c_width=5u c_length=5u
X465 a_21997_11960# a_31569_13109# VR.t92 VDD pfet_03v3 ad=1.325p pd=5.53u as=1.325p ps=5.53u w=5u l=0.28u
X466 a_43160_3486# a_44000_1364# VSS ppolyf_u_1k r_width=1u r_length=10u
X467 VR.t175 a_35769_13109.t39 a_18109_11960.t14 VDD pfet_03v3 ad=1.325p pd=5.53u as=1.325p ps=5.53u w=5u l=0.28u
X468 a_31569_13109# B0 VDD VDD pfet_03v3 ad=0.89p pd=4.89u as=0.89p ps=4.89u w=2u l=0.28u
X469 a_52360_26660# a_25765_39400# VSS VSS nfet_03v3 ad=0.89p pd=4.89u as=0.89p ps=4.89u w=2u l=0.28u
X470 VR.t47 a_35769_13109.t5 a_18109_11960.t1 VDD pfet_03v3 ad=1.325p pd=5.53u as=1.325p ps=5.53u w=5u l=0.28u
X471 a_46520_3486# a_45680_1364# VSS ppolyf_u_1k r_width=1u r_length=10u
X472 VR.t91 a_31569_13109# a_21997_11960# VDD pfet_03v3 ad=1.325p pd=5.53u as=1.325p ps=5.53u w=5u l=0.28u
X473 a_37337_52869# a_38505_26660# VR.t22 VR.t21 pfet_03v3 ad=0.89p pd=4.89u as=0.89p ps=4.89u w=2u l=0.28u
X474 a_26067_78209.t2 a_10387_27249.t5 VSS VSS nfet_03v3 ad=0.795p pd=3.53u as=1.335p ps=6.89u w=3u l=0.28u
X475 a_23253_52869# a_29925_57069# VSS VSS nfet_03v3 ad=1.06p pd=4.53u as=1.78p ps=8.89u w=4u l=0.4u
X476 a_22707_78209.t0 a_8707_27249# VR.t100 VR.t99 pfet_03v3 ad=0.795p pd=3.53u as=1.335p ps=6.89u w=3u l=0.28u
X477 a_28909_57069# VSS VSS VSS nfet_03v3 ad=1.06p pd=4.53u as=1.78p ps=8.89u w=4u l=0.4u
X478 VSS VSS a_36325_56340# VSS nfet_03v3 ad=1.78p pd=8.89u as=1.06p ps=4.53u w=4u l=0.4u
X479 a_22680_77340# a_24387_78209# VSS VSS nfet_03v3 ad=1.78p pd=8.89u as=1.78p ps=8.89u w=4u l=0.28u
X480 a_32345_77340# a_26067_78209.t3 a_32345_81680# VSS nfet_03v3 ad=1.78p pd=8.89u as=1.78p ps=8.89u w=4u l=0.28u
X481 VR.t329 VSS cap_mim_2f0_m4m5_noshield c_width=5u c_length=5u
X482 a_13305_77340# a_3667_78209# a_13160_77340# VSS nfet_03v3 ad=1.78p pd=8.89u as=1.78p ps=8.89u w=4u l=0.28u
X483 VR.t212 a_23253_52869# a_19487_39989# VR.t211 pfet_03v3 ad=0.795p pd=3.53u as=0.795p ps=3.53u w=3u l=0.4u
X484 a_18109_11960.t17 a_35769_13109.t34 VR.t123 VDD pfet_03v3 ad=2.225p pd=10.89u as=1.325p ps=5.53u w=5u l=0.28u
X485 a_21997_11960# a_31569_13109# VR.t96 VDD pfet_03v3 ad=2.225p pd=10.89u as=1.325p ps=5.53u w=5u l=0.28u
X486 VDD a_17709_13109.t65 a_18109_11960.t16 VDD pfet_03v3 ad=1.325p pd=5.53u as=1.325p ps=5.53u w=5u l=0.28u
X487 a_36325_56340# a_22709_52000# VR.t230 VR.t229 pfet_03v3 ad=0.795p pd=3.53u as=0.795p ps=3.53u w=3u l=0.4u
X488 a_35309_56340# a_19487_39989# VSS VSS nfet_03v3 ad=1.06p pd=4.53u as=1.78p ps=8.89u w=4u l=0.4u
X489 a_3667_82549.t0 a_38569_65469# VR.t278 VR.t277 pfet_03v3 ad=0.795p pd=3.53u as=1.335p ps=6.89u w=3u l=0.28u
X490 VSS a_23897_52869# a_22709_52000# VSS nfet_03v3 ad=1.78p pd=8.89u as=1.06p ps=4.53u w=4u l=0.4u
X491 VR.t124 a_35769_13109.t37 a_18109_11960.t28 VDD pfet_03v3 ad=1.325p pd=5.53u as=1.325p ps=5.53u w=5u l=0.28u
X492 VR.t78 a_35769_13109.t3 a_18109_11960.t20 VDD pfet_03v3 ad=1.325p pd=5.53u as=1.325p ps=5.53u w=5u l=0.28u
X493 a_43160_3486# a_42320_1364# VSS ppolyf_u_1k r_width=1u r_length=10u
X494 a_44840_3486# a_45680_1364# VSS ppolyf_u_1k r_width=1u r_length=10u
X495 a_28909_57069# a_35309_56340# VR.t17 VR.t16 pfet_03v3 ad=0.795p pd=3.53u as=0.795p ps=3.53u w=3u l=0.4u
X496 VDD VR.t309 VSS ppolyf_u_1k r_width=2u r_length=5u
X497 LOQP a_32345_77340# VSS VSS nfet_03v3 ad=0.795p pd=3.53u as=1.335p ps=6.89u w=3u l=0.28u
X498 a_7027_78209.t1 a_25765_39400# VR.t258 VR.t257 pfet_03v3 ad=0.795p pd=3.53u as=0.795p ps=3.53u w=3u l=0.28u
X499 a_19487_39989# a_22709_52000# VSS VSS nfet_03v3 ad=0.445p pd=2.89u as=0.445p ps=2.89u w=1u l=0.4u
X500 VDD a_17709_13109.t137 a_18109_11960.t8 VDD pfet_03v3 ad=1.325p pd=5.53u as=1.325p ps=5.53u w=5u l=0.28u
X501 VR.t90 a_31569_13109# a_21997_11960# VDD pfet_03v3 ad=1.325p pd=5.53u as=1.325p ps=5.53u w=5u l=0.28u
X502 VR.t328 VSS cap_mim_2f0_m4m5_noshield c_width=5u c_length=5u
X503 a_19487_65329# a_28909_57069# VR.t156 VR.t155 pfet_03v3 ad=0.795p pd=3.53u as=0.795p ps=3.53u w=3u l=0.4u
X504 a_22709_52000# a_19487_65329# VR.t192 VR.t191 pfet_03v3 ad=0.795p pd=3.53u as=1.335p ps=6.89u w=3u l=0.4u
X505 a_60345_27002# a_12809_40129# VSS VSS nfet_03v3 ad=0.445p pd=2.89u as=0.445p ps=2.89u w=1u l=0.28u
X506 a_49705_77682# a_43427_77929# a_49705_81540# VR.t268 pfet_03v3 ad=1.78p pd=8.89u as=1.78p ps=8.89u w=4u l=0.28u
X507 VR.t329 VSS cap_mim_2f0_m4m5_noshield c_width=5u c_length=5u
X508 a_38505_26660# a_16665_27002# VR.t239 VR.t238 pfet_03v3 ad=0.89p pd=4.89u as=0.89p ps=4.89u w=2u l=0.28u
X509 a_41900_3486# a_41060_1364# VSS ppolyf_u_1k r_width=1u r_length=10u
X510 a_35769_13109.t0 B1.t1 VDD VDD pfet_03v3 ad=0.89p pd=4.89u as=0.89p ps=4.89u w=2u l=0.28u
X511 a_3785_77340# a_3667_78209# a_3640_77340# VSS nfet_03v3 ad=1.78p pd=8.89u as=1.78p ps=8.89u w=4u l=0.28u
X512 VR.t123 a_35769_13109.t35 a_18109_11960.t18 VDD pfet_03v3 ad=1.325p pd=5.53u as=1.325p ps=5.53u w=5u l=0.28u
X513 a_24387_78209# a_25765_64740# VR.t62 VR.t61 pfet_03v3 ad=0.795p pd=3.53u as=0.795p ps=3.53u w=3u l=0.28u
X514 a_22680_91200# a_22707_78209.t6 VR.t289 VR.t288 pfet_03v3 ad=3.56p pd=16.89u as=3.56p ps=16.89u w=8u l=0.28u
X515 a_32200_91200# a_12885_64740# VR.t25 VR.t24 pfet_03v3 ad=3.56p pd=16.89u as=3.56p ps=16.89u w=8u l=0.28u
X516 a_35309_56340# a_19487_39989# VR.t325 VR.t324 pfet_03v3 ad=0.795p pd=3.53u as=0.795p ps=3.53u w=3u l=0.4u
X517 a_41865_77340# a_38569_65469# a_41720_77340# VSS nfet_03v3 ad=0.89p pd=4.89u as=0.89p ps=4.89u w=2u l=0.28u
X518 VR.t94 a_31569_13109# a_21997_11960# VDD pfet_03v3 ad=1.325p pd=5.53u as=1.325p ps=5.53u w=5u l=0.28u
X519 a_12809_65469# a_19487_65329# VR.t188 VR.t187 pfet_03v3 ad=1.78p pd=8.89u as=1.78p ps=8.89u w=4u l=0.28u
X520 a_29925_57069# a_36325_56340# VR.t299 VR.t298 pfet_03v3 ad=0.795p pd=3.53u as=0.795p ps=3.53u w=3u l=0.4u
X521 a_3667_78209# a_12809_40129# VSS VSS nfet_03v3 ad=0.795p pd=3.53u as=1.335p ps=6.89u w=3u l=0.28u
X522 a_23253_52869# a_19487_65329# VSS VSS nfet_03v3 ad=0.445p pd=2.89u as=0.445p ps=2.89u w=1u l=0.4u
X523 VR.t329 VSS cap_mim_2f0_m4m5_noshield c_width=5u c_length=5u
X524 a_24387_78209# a_25765_64740# VSS VSS nfet_03v3 ad=0.795p pd=3.53u as=1.335p ps=6.89u w=3u l=0.28u
X525 a_22707_78209.t1 a_8707_27249# VR.t102 VR.t101 pfet_03v3 ad=0.795p pd=3.53u as=0.795p ps=3.53u w=3u l=0.28u
X526 a_23897_52869# a_26067_27389# a_24505_30860# VR.t20 pfet_03v3 ad=1.78p pd=8.89u as=1.78p ps=8.89u w=4u l=0.28u
X527 VSS a_8707_27249# a_22707_78209.t2 VSS nfet_03v3 ad=1.335p pd=6.89u as=0.795p ps=3.53u w=3u l=0.28u
X528 VR.t328 VSS cap_mim_2f0_m4m5_noshield c_width=5u c_length=5u
X529 VR.t329 VSS cap_mim_2f0_m4m5_noshield c_width=5u c_length=5u
X530 a_13305_77340# a_5347_78209.t6 a_13160_91200# VR.t145 pfet_03v3 ad=3.56p pd=16.89u as=3.56p ps=16.89u w=8u l=0.28u
X531 a_38569_65469# a_28909_57069# VSS VSS nfet_03v3 ad=0.89p pd=4.89u as=0.89p ps=4.89u w=2u l=0.28u
X532 VSS a_43427_77929# a_5347_78209.t2 VSS nfet_03v3 ad=1.335p pd=6.89u as=0.795p ps=3.53u w=3u l=0.28u
X533 a_3667_82549.t1 a_38569_65469# VR.t284 VR.t283 pfet_03v3 ad=0.795p pd=3.53u as=0.795p ps=3.53u w=3u l=0.28u
X534 VR.t301 a_36325_56340# a_29925_57069# VR.t300 pfet_03v3 ad=1.335p pd=6.89u as=0.795p ps=3.53u w=3u l=0.4u
X535 a_3785_77340# a_7027_78209.t4 a_3785_81680# VSS nfet_03v3 ad=1.78p pd=8.89u as=1.78p ps=8.89u w=4u l=0.28u
X536 a_22709_52000# a_19487_39989# VSS VSS nfet_03v3 ad=0.445p pd=2.89u as=0.445p ps=2.89u w=1u l=0.4u
X537 a_36325_56340# a_35309_56340# VSS VSS nfet_03v3 ad=0.445p pd=2.89u as=0.445p ps=2.89u w=1u l=0.4u
X538 a_8707_27249# a_36325_56340# VR.t293 VR.t292 pfet_03v3 ad=1.78p pd=8.89u as=1.78p ps=8.89u w=4u l=0.28u
X539 a_65385_81540# a_12809_65469# VR.t70 VR.t69 pfet_03v3 ad=1.78p pd=8.89u as=1.78p ps=8.89u w=4u l=0.28u
X540 a_25765_64740# a_23253_52869# VR.t206 VR.t205 pfet_03v3 ad=1.78p pd=8.89u as=1.78p ps=8.89u w=4u l=0.28u
X541 VR.t19 a_35309_56340# a_28909_57069# VR.t18 pfet_03v3 ad=1.335p pd=6.89u as=0.795p ps=3.53u w=3u l=0.4u
X542 a_46520_3486# a_8825_26660# VSS ppolyf_u_1k r_width=1u r_length=10u
X543 a_29925_57069# a_36325_56340# VSS VSS nfet_03v3 ad=1.06p pd=4.53u as=1.78p ps=8.89u w=4u l=0.4u
C0 VR a_53924_30660# 0.36374f
C1 a_24332_51940# a_19487_39989# 0.03353f
C2 a_5614_77280# a_3640_77340# 0.04066f
C3 a_22680_91200# a_22825_77340# 0.99338f
C4 a_16665_30860# a_16814_30800# 0.0476f
C5 a_25765_64740# LOIP 0.05518f
C6 a_8680_26660# a_8974_26600# 0.01069f
C7 VR a_24432_56280# 0.5866f
C8 a_35309_56340# a_37128_51940# 0.0132f
C9 a_41604_81340# VR 0.36293f
C10 VR a_32494_30800# 0.3476f
C11 LOQP LOIN 0.89353f
C12 B1 VDD 2.12669f
C13 a_12624_68880# VR 0.50376f
C14 a_8707_27249# a_16665_27002# 0.05727f
C15 a_5204_85960# a_3640_91200# 0.01851f
C16 a_41604_81340# a_41865_77340# 0.01205f
C17 a_13305_81680# a_3667_78209# 0.24352f
C18 a_8707_27249# a_23897_52869# 0.11954f
C19 a_12885_64740# a_24387_78209# 2.1143f
C20 a_32345_77340# a_35854_85960# 0.07629f
C21 a_23688_51940# a_19487_39989# 0.01482f
C22 a_5204_77280# a_3640_77340# 0.01615f
C23 a_22564_91140# a_22825_77340# 0.01114f
C24 a_12809_65469# a_3667_78209# 0.04103f
C25 a_16404_30800# a_16814_30800# 0.0129f
C26 a_28909_57069# VDD 0.25314f
C27 VR a_19487_39989# 6.34905f
C28 a_35309_56340# a_36484_51940# 0.0176f
C29 a_33764_85960# a_34174_85960# 0.02581f
C30 a_24387_78209# a_25765_64740# 0.61683f
C31 a_40334_26600# a_38360_26660# 0.01988f
C32 a_34758_52282# a_23253_52869# 0.0146f
C33 a_43160_3486# a_43580_3486# 0.1684f
C34 a_35309_56340# a_22709_52000# 0.15869f
C35 a_3934_85960# a_3640_91200# 0.08217f
C36 a_44000_1364# a_44420_1364# 0.1684f
C37 a_44520_56280# a_28909_57069# 0.01615f
C38 a_22564_85960# a_22974_85960# 0.02581f
C39 a_12885_64740# a_22974_91140# 0.01735f
C40 a_23253_52869# VDD 0.25314f
C41 a_32345_77340# a_35444_85960# 0.02926f
C42 a_36325_56340# a_29925_57069# 0.59851f
C43 a_44492_51940# a_29925_57069# 0.01577f
C44 a_41720_77340# a_38569_65469# 0.03744f
C45 a_3785_77340# B1 0.04262f
C46 a_8564_26600# a_8680_26660# 0.01998f
C47 a_60345_27002# a_60494_26942# 0.01511f
C48 a_24387_78209# a_32494_85960# 0.0111f
C49 VR a_23416_56280# 0.59569f
C50 a_13160_91200# a_13044_85960# 0.01114f
C51 a_8707_27249# a_32345_27002# 0.04359f
C52 a_19487_39989# a_24432_56280# 0.01002f
C53 VR a_22400_56280# 0.5866f
C54 a_12809_65469# a_19754_64680# 0.02481f
C55 a_8825_26660# a_16665_27002# 0.38118f
C56 a_40640_1364# a_41060_1364# 0.1684f
C57 a_3524_85960# a_3640_91200# 0.01114f
C58 a_32345_77340# a_24387_78209# 0.73153f
C59 a_43332_56280# a_28909_57069# 0.01274f
C60 a_23897_52869# a_8825_26660# 0.02056f
C61 a_12885_64740# a_22680_91200# 0.25371f
C62 a_12809_65469# a_65385_81540# 0.0727f
C63 a_22825_81680# VR 0.25314f
C64 a_43848_51940# a_29925_57069# 0.01515f
C65 a_23688_51940# a_22709_52000# 0.01307f
C66 a_40067_27249# a_25765_39400# 0.63268f
C67 a_3785_77340# a_7294_77280# 0.04071f
C68 a_24387_78209# a_32084_85960# 0.01119f
C69 a_57694_81340# VR 0.35048f
C70 VR a_22709_52000# 5.18362f
C71 a_13044_85960# a_3667_78209# 0.0193f
C72 a_25765_64740# LOQN 0.03161f
C73 a_43427_77929# a_51674_64680# 0.02481f
C74 a_12885_64740# a_22564_91140# 0.0201f
C75 a_3785_81680# a_3667_78209# 0.04359f
C76 a_31569_13109# a_44954_14482# 0.01511f
C77 VR a_26067_27389# 1.72125f
C78 B1 LOIN 0.08426f
C79 a_43427_77929# a_29925_57069# 0.09387f
C80 a_43204_51940# a_29925_57069# 0.01802f
C81 a_23044_51940# a_22709_52000# 0.01785f
C82 a_35309_56340# a_29925_57069# 1.32356f
C83 a_3785_77340# a_6884_77280# 0.01991f
C84 a_32200_91200# a_35854_85960# 0.01096f
C85 a_36325_56340# LOIP 0.05403f
C86 a_38569_65469# VDD 0.25314f
C87 a_57545_77340# VR 1.37214f
C88 a_13305_81680# a_13305_77340# 0.31418f
C89 a_28909_57069# LOIN 0.08718f
C90 a_44840_3486# a_45260_3486# 0.1684f
C91 a_12809_65469# a_43427_77929# 1.00312f
C92 a_32345_77340# LOQN 0.04457f
C93 a_51264_68740# VR 0.63535f
C94 a_8707_27249# B1 0.01554f
C95 VR a_24654_30800# 0.60202f
C96 a_24387_78209# a_32494_91140# 0.01749f
C97 a_32200_91200# a_35444_85960# 0.08455f
C98 a_3640_91200# a_3934_91140# 0.02009f
C99 a_3640_77340# a_3934_77280# 0.01483f
C100 a_57284_81340# VR 0.36293f
C101 a_22709_52000# a_19487_39989# 1.96754f
C102 a_60345_27002# a_62174_26942# 0.01149f
C103 a_29925_57069# VR 5.89662f
C104 a_22825_81680# a_22974_81620# 0.0476f
C105 VR a_24505_30860# 0.89698f
C106 a_26334_85960# a_25924_85960# 0.02581f
C107 a_24387_78209# a_32200_91200# 0.3401f
C108 a_13305_81680# VR 0.2465f
C109 a_22825_77340# B1 0.04262f
C110 a_40067_27249# a_35000_1180# 0.0555f
C111 a_32200_77340# a_34174_77280# 0.04066f
C112 a_32200_91200# a_34174_85960# 0.08073f
C113 a_3524_91140# a_3934_91140# 0.02581f
C114 a_3524_77280# a_3934_77280# 0.0129f
C115 a_35309_56340# LOIP 0.17574f
C116 a_13305_77340# LOIP 0.16f
C117 a_22680_91200# a_26334_85960# 0.01096f
C118 a_12809_65469# VR 6.70543f
C119 a_22709_52000# a_23416_56280# 0.01012f
C120 a_12809_40129# a_60345_27002# 0.02056f
C121 VR a_30084_11900# 0.0136f
C122 a_45514_68740# VR 0.60202f
C123 a_22564_81620# a_22974_81620# 0.0129f
C124 VR a_24244_30800# 0.63502f
C125 a_25765_39400# a_37337_52869# 0.1124f
C126 a_24387_78209# a_32084_91140# 0.02024f
C127 a_36484_51940# a_22709_52000# 0.01952f
C128 a_3524_91140# a_3640_91200# 0.07639f
C129 a_32200_77340# a_33764_77280# 0.01615f
C130 a_3524_77280# a_3640_77340# 0.04076f
C131 a_12809_40129# a_23897_52869# 0.04322f
C132 a_52244_26600# a_52360_26660# 0.01998f
C133 a_32345_77340# LOQP 0.57803f
C134 a_35854_85960# VR 1.06472f
C135 a_52505_26660# a_25765_39400# 0.55283f
C136 a_45104_68740# VR 0.63535f
C137 a_41720_77340# a_42014_77280# 0.01069f
C138 a_19487_65329# VDD 0.25314f
C139 a_29925_57069# a_19487_39989# 0.76929f
C140 VR LOIP 2.63727f
C141 a_40067_27249# VDD 1.22732f
C142 B1 a_50704_18340# 0.01161f
C143 a_25765_39400# VDD 0.25015f
C144 a_32200_77340# a_32494_77280# 0.01483f
C145 a_24244_77280# a_24654_77280# 0.0129f
C146 a_19344_43400# a_19754_43400# 0.0129f
C147 a_35444_85960# VR 1.06472f
C148 a_57545_77340# a_57694_81340# 0.02238f
C149 a_34300_52282# a_19487_65329# 0.01032f
C150 a_35000_1180# a_35956_1120# 0.08666f
C151 a_13044_85960# VR 1.15401f
C152 a_12885_64740# B1 0.09213f
C153 a_25914_68740# a_25765_64740# 0.0476f
C154 VR a_35584_13271# 0.01175f
C155 a_13160_91200# a_16404_85960# 0.08455f
C156 a_22825_77340# a_26334_77280# 0.04071f
C157 a_3785_81680# VR 0.25314f
C158 a_32084_77280# a_32494_77280# 0.0129f
C159 a_24387_78209# VR 6.83005f
C160 a_34174_85960# VR 1.0911f
C161 a_43427_77929# LOQN 0.12158f
C162 a_25765_64740# B1 0.03293f
C163 a_32345_81680# LOIN 0.04191f
C164 a_25914_39340# a_25765_39400# 0.02481f
C165 a_12885_64740# a_32200_77340# 0.09664f
C166 a_29925_57069# a_22709_52000# 0.05363f
C167 a_7294_85960# VR 1.06472f
C168 a_41604_77280# a_41720_77340# 0.01998f
C169 a_38360_26660# a_16665_27002# 0.03744f
C170 a_32345_81680# a_35444_77280# 0.04759f
C171 VR a_34224_11900# 0.01634f
C172 a_13160_91200# a_15134_85960# 0.08073f
C173 LOIP a_19487_39989# 0.58903f
C174 a_22825_77340# a_25924_77280# 0.01991f
C175 a_49705_81540# a_38569_65469# 0.0727f
C176 a_3785_77340# a_3934_77280# 0.04851f
C177 a_3785_77340# a_3934_91140# 0.08473f
C178 a_22680_77340# a_24654_77280# 0.04066f
C179 a_22974_91140# VR 1.06472f
C180 a_60345_27002# a_60345_30860# 0.38839f
C181 a_57284_81340# a_57545_77340# 0.01168f
C182 VR a_27618_56280# 0.40496f
C183 a_24505_30860# a_26067_27389# 0.10248f
C184 a_34840_1120# a_35000_1180# 0.07454f
C185 VR a_35584_11900# 0.01621f
C186 a_52505_26660# a_52654_30660# 0.02238f
C187 a_32345_77340# B1 0.04067f
C188 a_6884_85960# VR 1.06472f
C189 a_23253_52869# a_25765_64740# 0.09387f
C190 VDD a_17524_13271# 0.75357f
C191 a_25924_85960# VR 1.06472f
C192 VR a_31384_11900# 0.01692f
C193 a_13160_91200# a_14724_85960# 0.02016f
C194 a_45680_1364# a_44420_1364# 0.01209f
C195 a_12809_40129# B1 0.04359f
C196 a_3785_77340# a_3640_91200# 1.00081f
C197 VR LOQN 2.58586f
C198 a_3785_77340# a_3640_77340# 0.41268f
C199 a_49444_81480# a_38569_65469# 0.01549f
C200 a_8707_27249# a_8680_26660# 0.03744f
C201 a_22680_77340# a_24244_77280# 0.01615f
C202 a_22680_91200# VR 3.28133f
C203 a_61764_30800# a_60345_30860# 0.04818f
C204 a_41865_77340# LOQN 0.61926f
C205 a_12809_65469# a_57545_77340# 0.92663f
C206 VR a_27160_56280# 0.42934f
C207 a_24505_30860# a_24654_30800# 0.0476f
C208 VR a_62174_30800# 0.58576f
C209 a_32345_77340# a_32200_77340# 0.41268f
C210 a_13305_81680# a_13454_81620# 0.0476f
C211 a_42320_1364# a_41060_1364# 0.01209f
C212 a_40067_27249# a_8707_27249# 0.10622f
C213 LOIP a_22709_52000# 0.09588f
C214 a_37337_52869# VDD 0.50629f
C215 a_13160_91200# a_13454_85960# 0.08382f
C216 a_57284_77280# a_57400_77340# 0.01998f
C217 a_3667_78209# B1 0.08838f
C218 a_52360_26660# a_54334_26600# 0.01988f
C219 a_46940_3486# a_8825_26660# 0.0513f
C220 VDD a_17524_11900# 0.75817f
C221 a_3785_77340# a_3524_91140# 0.01114f
C222 a_8825_26660# a_8974_26600# 0.01991f
C223 a_22564_91140# VR 1.06472f
C224 a_25765_39400# a_8707_27249# 0.12507f
C225 VR a_18494_30800# 0.58576f
C226 a_22680_77340# a_22974_77280# 0.01483f
C227 a_60494_30800# a_60345_30860# 0.0476f
C228 a_24244_30800# a_24654_30800# 0.0129f
C229 VR a_26078_56280# 0.40473f
C230 VR a_60345_27002# 0.8238f
C231 a_52244_30660# a_52505_26660# 0.01168f
C232 a_19487_39989# a_27618_56280# 0.03782f
C233 a_38505_26660# a_16665_27002# 0.99366f
C234 a_48198_52282# a_28909_57069# 0.01587f
C235 a_13044_81620# a_13454_81620# 0.0129f
C236 a_12809_65469# a_29925_57069# 0.85368f
C237 a_24654_85960# VR 1.0911f
C238 a_24387_78209# a_22825_81680# 0.04359f
C239 a_26040_52282# a_19487_39989# 0.01507f
C240 a_27580_52282# a_22709_52000# 0.01468f
C241 a_46940_3486# a_46520_3486# 0.1684f
C242 a_8825_26660# a_8680_26660# 0.1904f
C243 VDD a_30084_13271# 0.75357f
C244 a_46494_30800# a_37337_52869# 0.02481f
C245 a_38569_65469# a_25765_64740# 0.06904f
C246 VR a_16665_27002# 3.15996f
C247 a_60494_30800# a_60084_30800# 0.0129f
C248 a_23897_52869# VR 1.89243f
C249 VR a_25620_56280# 0.43051f
C250 a_32494_26942# a_32345_27002# 0.01511f
C251 VR a_61764_30800# 0.58512f
C252 a_57694_77280# a_57545_77340# 0.01991f
C253 a_13305_77340# a_16404_85960# 0.02926f
C254 a_41900_3486# a_41480_3486# 0.1684f
C255 a_24244_85960# VR 1.15119f
C256 a_40067_27249# a_8825_26660# 0.0418f
C257 LOQP VR 1.61195f
C258 a_26498_52282# a_22709_52000# 0.02098f
C259 a_52360_26660# a_52654_26600# 0.01069f
C260 a_24976_51940# a_19487_39989# 0.01823f
C261 a_8825_26660# a_8564_26600# 0.01292f
C262 VDD a_21997_11960# 8.04466f
C263 a_44492_51940# a_28909_57069# 0.01173f
C264 VR a_18084_30800# 0.58512f
C265 a_42740_1364# a_42320_1364# 0.1684f
C266 a_12885_64740# a_32345_81680# 0.04359f
C267 a_46518_56280# VR 0.40926f
C268 VR a_60494_30800# 0.60202f
C269 a_3785_77340# VDD 0.25314f
C270 VR a_58320_68880# 0.50376f
C271 a_38569_65469# a_45514_64680# 0.02481f
C272 VR a_32345_27002# 0.93665f
C273 a_12809_65469# LOIP 0.04359f
C274 a_45104_68740# a_45514_68740# 0.0129f
C275 a_12885_64740# a_22974_85960# 0.0111f
C276 a_43427_77929# a_51674_68740# 0.0476f
C277 a_43848_51940# a_28909_57069# 0.0158f
C278 a_3934_81620# a_3524_81620# 0.0129f
C279 VR a_16814_30800# 0.60202f
C280 a_32345_81680# a_25765_64740# 0.0412f
C281 a_25765_39400# a_25914_43400# 0.0476f
C282 a_16404_85960# VR 1.06472f
C283 a_46060_56280# VR 0.42896f
C284 a_22564_77280# a_22974_77280# 0.0129f
C285 a_31664_68880# VR 0.50376f
C286 a_40067_27249# a_31569_13109# 0.04198f
C287 a_23897_52869# a_19487_39989# 0.41588f
C288 a_43427_77929# B1 0.086f
C289 a_35309_56340# B1 1.54038f
C290 a_13305_77340# B1 0.04067f
C291 a_38569_65469# a_49705_77682# 0.02056f
C292 VR a_57424_68880# 0.50376f
C293 a_37337_52869# a_8707_27249# 0.0312f
C294 VR a_32084_30800# 0.36569f
C295 a_12885_64740# a_22564_85960# 0.01119f
C296 VDD a_44954_18340# 0.3476f
C297 a_35309_56340# a_28909_57069# 0.6473f
C298 a_51264_43400# a_51674_43400# 0.0129f
C299 a_25504_43400# a_25914_43400# 0.0129f
C300 a_32345_27002# a_32494_30800# 0.02481f
C301 a_15134_85960# VR 1.0911f
C302 a_43160_3486# a_41900_3486# 0.01209f
C303 a_24387_78209# a_12809_65469# 0.14936f
C304 a_32345_77340# a_32345_81680# 0.31418f
C305 a_44978_56280# VR 0.40926f
C306 a_22564_77280# a_22680_77340# 0.04076f
C307 VDD LOIN 0.97865f
C308 a_25914_68740# VR 0.60202f
C309 a_35854_77280# a_35444_77280# 0.0129f
C310 a_22709_52000# a_26078_56280# 0.04023f
C311 a_35444_85960# a_35854_85960# 0.02581f
C312 a_40218_56280# a_36325_56340# 0.0254f
C313 VR a_51674_68740# 0.60202f
C314 VR a_26334_30800# 0.58576f
C315 a_8707_27249# VDD 0.25314f
C316 B1 VR 3.69497f
C317 a_40067_27249# B0 0.04326f
C318 a_14724_85960# VR 1.15119f
C319 a_25504_68740# VR 0.63535f
C320 a_45260_3486# a_46520_3486# 0.01209f
C321 a_46658_52282# a_29925_57069# 0.01862f
C322 a_23897_52869# a_22709_52000# 0.47526f
C323 a_3667_78209# a_3524_85960# 0.01887f
C324 a_22974_77280# a_22825_77340# 0.04851f
C325 a_39760_56280# a_36325_56340# 0.01479f
C326 a_28038_52282# a_19487_39989# 0.01874f
C327 a_28909_57069# VR 6.0731f
C328 a_24387_78209# LOIP 0.03849f
C329 a_16665_27002# a_26067_27389# 0.07952f
C330 a_3785_81680# a_3934_81620# 0.0476f
C331 VR a_25924_30800# 0.58512f
C332 a_23897_52869# a_26067_27389# 0.69929f
C333 a_13160_77340# a_14724_77280# 0.01615f
C334 a_23688_51940# a_23253_52869# 0.0129f
C335 a_12809_65469# LOQN 0.04322f
C336 a_13454_85960# VR 1.08855f
C337 a_23253_52869# VR 5.93733f
C338 VDD a_51114_18340# 0.3476f
C339 a_22825_77340# VDD 0.25314f
C340 VR a_35000_56280# 0.5866f
C341 a_38678_56280# a_36325_56340# 0.0112f
C342 a_8707_27249# a_16665_30860# 0.0727f
C343 a_22680_77340# a_22825_77340# 0.41268f
C344 a_25765_39400# a_12809_40129# 0.34146f
C345 a_39280_68880# VR 0.50376f
C346 VDD a_8825_26660# 0.50629f
C347 a_13160_77340# a_13454_77280# 0.01483f
C348 a_38569_65469# a_43427_77929# 0.21521f
C349 VR a_33918_56280# 0.40926f
C350 a_8707_27249# a_16404_30800# 0.01563f
C351 a_38220_56280# a_36325_56340# 0.01031f
C352 a_5614_85960# VR 1.0911f
C353 a_38384_68880# VR 0.50376f
C354 a_28909_57069# a_19487_39989# 0.07326f
C355 a_23897_52869# a_24505_30860# 0.38839f
C356 a_13044_77280# a_13454_77280# 0.0129f
C357 a_13160_91200# a_16814_85960# 0.01096f
C358 a_40218_56280# VR 0.40926f
C359 VDD a_50704_18340# 0.36569f
C360 a_23253_52869# a_19487_39989# 0.8367f
C361 a_25765_64740# a_67214_81480# 0.01196f
C362 a_40067_27249# VCTRL 0.5674f
C363 VR a_33460_56280# 0.42713f
C364 a_38678_56280# a_35309_56340# 0.03013f
C365 VDD a_31569_13109# 6.77969f
C366 a_19754_43400# a_12809_40129# 0.0476f
C367 a_5204_85960# VR 1.15119f
C368 a_32560_68880# VR 0.50376f
C369 a_15134_77280# a_14724_77280# 0.0129f
C370 a_38569_65469# VR 5.34782f
C371 a_46084_30800# a_38505_26660# 0.01161f
C372 a_22825_81680# B1 0.11337f
C373 a_3667_78209# a_3640_91200# 0.08062f
C374 a_39800_3486# a_40220_3486# 0.1684f
C375 a_57400_77340# a_25765_64740# 0.04098f
C376 a_3667_78209# a_3640_77340# 0.06129f
C377 a_40067_27249# a_38360_26660# 0.04098f
C378 a_13044_77280# a_13160_77340# 0.04076f
C379 a_38569_65469# a_41865_77340# 0.92105f
C380 a_39760_56280# VR 0.42485f
C381 a_12885_64740# VDD 0.23364f
C382 a_6884_85960# a_7294_85960# 0.02581f
C383 a_22680_91200# a_24387_78209# 0.18584f
C384 a_46084_30800# VR 0.36569f
C385 a_23253_52869# a_23416_56280# 0.01042f
C386 VR a_32378_56280# 0.40703f
C387 a_26334_30800# a_26067_27389# 0.01196f
C388 a_38220_56280# a_35309_56340# 0.01179f
C389 VDD a_44544_18340# 0.36569f
C390 a_31569_13109# a_21997_11960# 0.91962f
C391 a_65385_77682# a_67214_81480# 0.04066f
C392 a_3934_85960# VR 1.08855f
C393 a_46060_56280# a_29925_57069# 0.01322f
C394 a_40334_30660# a_38505_26660# 0.0199f
C395 a_22825_77340# LOIN 0.16f
C396 a_25765_64740# VDD 0.25314f
C397 a_38678_56280# VR 0.40794f
C398 a_51264_68740# a_51674_68740# 0.0129f
C399 a_22680_91200# a_22974_91140# 0.02009f
C400 a_19754_68740# VR 0.60202f
C401 a_37337_52869# a_12809_40129# 0.04359f
C402 a_23253_52869# a_22709_52000# 1.18349f
C403 a_40334_30660# VR 0.35048f
C404 B0 VDD 2.68049f
C405 a_16404_77280# a_16814_77280# 0.0129f
C406 a_10654_30660# a_8825_26660# 0.0199f
C407 a_25765_39400# a_60345_30860# 0.10248f
C408 a_25924_30800# a_26067_27389# 0.01245f
C409 a_66804_81480# a_67214_81480# 0.0129f
C410 a_3524_85960# VR 1.15401f
C411 a_15134_77280# a_13160_77340# 0.04066f
C412 a_32345_81680# VR 0.23364f
C413 a_44978_56280# a_29925_57069# 0.03014f
C414 a_52505_26660# a_12809_40129# 0.9294f
C415 a_22680_91200# a_25924_85960# 0.08463f
C416 a_32345_77340# a_35854_77280# 0.04071f
C417 a_8707_27249# a_8825_26660# 1.05582f
C418 a_32345_77340# VDD 0.25314f
C419 a_22564_91140# a_22974_91140# 0.02581f
C420 a_38220_56280# VR 0.42934f
C421 a_19344_68740# VR 0.63535f
C422 a_33764_77280# a_34174_77280# 0.0129f
C423 a_39924_30660# VR 0.36374f
C424 a_22974_85960# VR 1.08855f
C425 a_12809_40129# VDD 0.25314f
C426 a_29925_57069# B1 0.10774f
C427 a_31569_13109# a_44954_18340# 0.02481f
C428 a_40067_27249# a_38505_26660# 0.17062f
C429 a_24387_78209# a_24244_85960# 0.02163f
C430 a_8825_26660# a_8974_30660# 0.02238f
C431 VCTRL a_35000_1180# 0.38172f
C432 a_44840_3486# a_43580_3486# 0.01209f
C433 a_13305_81680# B1 0.11337f
C434 a_25765_39400# a_38505_26660# 0.42858f
C435 a_28909_57069# a_29925_57069# 1.38726f
C436 a_19487_65329# VR 8.35749f
C437 a_22564_91140# a_22680_91200# 0.07639f
C438 a_12809_65469# B1 0.03849f
C439 a_3667_78209# VDD 0.73992f
C440 a_40067_27249# VR 1.25428f
C441 a_22564_85960# VR 1.15401f
C442 a_25924_30800# a_24505_30860# 0.04818f
C443 a_25765_39400# a_54334_30660# 0.01027f
C444 a_23253_52869# a_32760_52282# 0.01507f
C445 a_25765_39400# VR 6.08485f
C446 a_23253_52869# a_29925_57069# 0.78216f
C447 a_22825_81680# a_25924_77280# 0.04759f
C448 a_36325_56340# a_37337_52869# 0.24052f
C449 a_22680_91200# a_24654_85960# 0.07953f
C450 a_60345_27002# a_62174_30800# 0.04066f
C451 a_12809_65469# a_28909_57069# 0.10562f
C452 a_16814_85960# a_13305_77340# 0.07629f
C453 a_3934_91140# VR 1.06472f
C454 a_13520_68880# VR 0.50376f
C455 a_25765_64740# LOIN 0.0388f
C456 a_51534_77622# a_49705_77682# 0.01149f
C457 a_23253_52869# a_12809_65469# 0.09321f
C458 a_23253_52869# a_31696_51940# 0.01823f
C459 a_45680_1364# a_46100_1364# 0.1684f
C460 VR a_31920_56280# 0.42707f
C461 a_25504_43400# VR 0.63535f
C462 LOQP LOQN 0.05121f
C463 B1 LOIP 0.08914f
C464 a_41720_77340# a_43427_77929# 0.04098f
C465 a_22680_91200# a_24244_85960# 0.02016f
C466 a_61764_30800# a_62174_30800# 0.0129f
C467 a_3785_77340# a_3667_78209# 0.10245f
C468 a_46520_3486# a_8825_26660# 0.01166f
C469 a_8564_30660# a_8825_26660# 0.01168f
C470 a_36325_56340# VDD 0.23364f
C471 a_3640_91200# VR 3.27006f
C472 a_16665_27002# a_18494_30800# 0.04066f
C473 a_19487_65329# a_19487_39989# 0.20896f
C474 a_32345_77340# LOIN 1.0873f
C475 a_16814_85960# VR 1.06472f
C476 a_31569_13109# a_8825_26660# 0.53824f
C477 a_23253_52869# a_31052_51940# 0.03022f
C478 a_12885_64740# a_22825_77340# 0.20515f
C479 VR a_30732_56280# 0.58375f
C480 a_19754_43400# VR 0.60202f
C481 a_42014_77280# a_41865_77340# 0.01988f
C482 a_32345_77340# a_35444_77280# 0.01983f
C483 a_35309_56340# a_37337_52869# 0.25434f
C484 a_61764_30800# a_60345_27002# 0.02019f
C485 a_19754_39340# a_12809_40129# 0.02481f
C486 a_23253_52869# LOIP 0.08014f
C487 a_46100_1364# a_8825_26660# 0.04189f
C488 a_45514_43400# a_8707_27249# 0.0476f
C489 a_3785_81680# B1 0.11337f
C490 a_24387_78209# B1 0.09005f
C491 a_3524_91140# VR 1.06472f
C492 a_40067_27249# a_40640_1364# 0.01427f
C493 a_38569_65469# a_29925_57069# 0.05285f
C494 a_18084_30800# a_18494_30800# 0.0129f
C495 a_23897_52869# a_16665_27002# 0.27789f
C496 a_19487_65329# a_22400_56280# 0.01121f
C497 a_24244_85960# a_24654_85960# 0.02581f
C498 a_8707_27249# a_12809_40129# 0.04359f
C499 VR a_29716_56280# 0.59569f
C500 a_19344_43400# VR 0.63535f
C501 a_41720_77340# a_41865_77340# 0.1904f
C502 a_37337_52869# a_38505_26660# 0.10471f
C503 a_13044_85960# a_13454_85960# 0.02581f
C504 a_3667_78209# a_13160_77340# 0.06129f
C505 a_12809_65469# a_38569_65469# 2.22842f
C506 a_52654_30660# VR 0.35048f
C507 a_43427_77929# VDD 0.25015f
C508 a_35309_56340# VDD 0.1975f
C509 a_13305_77340# VDD 0.25314f
C510 VR a_67214_81480# 0.58576f
C511 a_18084_30800# a_16665_27002# 0.02019f
C512 a_38569_65469# a_45514_68740# 0.0476f
C513 a_42740_1364# a_44000_1364# 0.01209f
C514 a_19487_65329# a_22709_52000# 1.68004f
C515 a_37337_52869# VR 1.83233f
C516 a_47740_52282# a_28909_57069# 0.0111f
C517 VR a_28700_56280# 0.5866f
C518 a_52505_26660# a_54334_30660# 0.0199f
C519 a_41604_77280# a_41865_77340# 0.01292f
C520 a_25765_39400# a_22709_52000# 0.57681f
C521 a_52505_26660# VR 1.37387f
C522 a_6884_77280# a_3785_81680# 0.04759f
C523 a_32345_27002# a_16665_27002# 0.05637f
C524 a_25765_64740# a_59374_81340# 0.01027f
C525 B1 LOQN 0.08277f
C526 a_23897_52869# a_32345_27002# 0.06039f
C527 a_40067_27249# a_26067_27389# 0.32468f
C528 a_16665_27002# a_16814_26942# 0.01511f
C529 a_57424_43540# VR 0.50376f
C530 a_12809_65469# a_19754_68740# 0.0476f
C531 a_33218_52282# a_19487_65329# 0.01587f
C532 a_46658_52282# a_28909_57069# 0.01321f
C533 a_3785_77340# a_13305_77340# 0.21795f
C534 VR VDD 37.4367f
C535 a_32200_91200# LOIN 0.05574f
C536 a_32345_77340# a_32494_77280# 0.04851f
C537 a_52244_30660# VR 0.36293f
C538 a_12885_64740# a_33764_85960# 0.02163f
C539 a_25765_39400# a_52360_26660# 0.04098f
C540 B0 a_31569_13109# 0.27231f
C541 a_23897_52869# a_32084_30800# 0.0116f
C542 a_36325_56340# a_8707_27249# 0.21095f
C543 a_26334_85960# a_22825_77340# 0.07629f
C544 a_44520_56280# VR 0.42896f
C545 a_12885_64740# a_25765_64740# 0.03998f
C546 a_51674_43400# VR 0.60202f
C547 a_49705_81540# a_49705_77682# 0.38839f
C548 a_46200_52282# a_28909_57069# 0.01707f
C549 VR a_21997_11960# 7.55857f
C550 a_13305_77340# a_13454_77280# 0.04851f
C551 a_19487_65329# a_29925_57069# 0.7038f
C552 a_23897_52869# a_26334_26942# 0.01149f
C553 a_46494_30800# VR 0.3476f
C554 B0 a_44544_18340# 0.01161f
C555 a_23897_52869# a_26334_30800# 0.04066f
C556 a_65124_81480# a_65534_81480# 0.0129f
C557 a_43332_56280# VR 0.58375f
C558 a_3785_77340# VR 3.6411f
C559 VR a_16665_30860# 0.89698f
C560 B1 a_16665_27002# 2.14114f
C561 a_37337_52869# a_37128_51940# 0.01025f
C562 a_12809_65469# a_19487_65329# 0.18995f
C563 a_12885_64740# a_32345_77340# 0.03748f
C564 a_49705_81540# a_51124_81480# 0.04818f
C565 a_13160_91200# a_12885_64740# 0.05769f
C566 a_13305_77340# LOIN 0.57803f
C567 a_35956_1120# a_26067_27389# 0.0139f
C568 a_45136_51940# a_28909_57069# 0.0202f
C569 a_13305_77340# a_13160_77340# 0.41268f
C570 a_52505_26660# a_52244_26600# 0.01292f
C571 VDD a_19487_39989# 0.25314f
C572 a_23897_52869# a_25924_30800# 0.02019f
C573 a_25765_64740# a_65385_77682# 0.69929f
C574 a_42316_56280# VR 0.59569f
C575 VR a_16404_30800# 0.63502f
C576 a_32345_77340# a_25765_64740# 0.0388f
C577 a_51264_43400# VR 0.63535f
C578 a_46494_26942# a_37337_52869# 0.01511f
C579 a_16814_77280# a_13305_77340# 0.04071f
C580 a_41480_3486# a_40220_3486# 0.01209f
C581 a_49705_81540# a_49854_81480# 0.0476f
C582 a_13160_91200# a_13454_91140# 0.02009f
C583 a_35000_1180# a_26067_27389# 0.45175f
C584 a_23253_52869# a_23897_52869# 0.14503f
C585 a_37337_52869# a_22709_52000# 0.01116f
C586 a_8707_27249# a_45514_39340# 0.02481f
C587 a_12885_64740# a_3667_78209# 1.37735f
C588 a_38569_65469# LOQN 0.20181f
C589 a_23897_52869# a_24654_26942# 0.01511f
C590 a_29764_51940# a_23253_52869# 0.02443f
C591 a_24387_78209# a_32345_81680# 0.62125f
C592 a_19487_65329# LOIP 0.04359f
C593 VR LOIN 3.93312f
C594 a_46518_56280# a_28909_57069# 0.02789f
C595 VR a_58320_43540# 0.50376f
C596 a_25765_64740# a_66804_81480# 0.01245f
C597 VR a_10654_30660# 0.35048f
C598 a_39280_104720# VR 0.50376f
C599 a_29925_57069# a_30732_56280# 0.0136f
C600 a_41300_56280# VR 0.5866f
C601 a_16404_77280# a_13305_77340# 0.01983f
C602 a_32084_85960# a_32494_85960# 0.02581f
C603 a_13044_91140# a_13454_91140# 0.02581f
C604 a_49444_81480# a_49854_81480# 0.0129f
C605 a_25765_64740# a_49705_77682# 0.0361f
C606 a_34840_1120# a_26067_27389# 0.01454f
C607 a_13305_77340# a_22825_77340# 0.1399f
C608 a_8707_27249# VR 6.68679f
C609 a_57400_77340# a_57545_77340# 0.1904f
C610 VDD a_22709_52000# 0.25314f
C611 a_43694_77280# a_41720_77340# 0.01988f
C612 a_45104_43400# a_45514_43400# 0.0129f
C613 a_49705_81540# a_43427_77929# 0.10248f
C614 a_46060_56280# a_28909_57069# 0.01004f
C615 a_38384_104720# VR 0.50376f
C616 VR a_10244_30660# 0.36374f
C617 a_52505_26660# a_52360_26660# 0.1904f
C618 a_66804_81480# a_65385_77682# 0.02019f
C619 VDD a_26067_27389# 1.70541f
C620 a_14724_85960# a_15134_85960# 0.02581f
C621 a_13044_91140# a_13160_91200# 0.07639f
C622 a_25504_68740# a_25914_68740# 0.0129f
C623 a_13160_91200# a_3667_78209# 0.08165f
C624 a_12885_64740# a_32200_91200# 0.18615f
C625 VR a_8974_30660# 0.35048f
C626 a_32560_43540# VR 0.50376f
C627 a_18494_26942# a_16665_27002# 0.01149f
C628 a_57284_77280# a_57545_77340# 0.01292f
C629 a_3667_78209# a_12809_40129# 0.7307f
C630 a_49705_77682# a_51534_81480# 0.04066f
C631 a_33764_85960# a_32200_91200# 0.02016f
C632 a_25765_64740# a_65385_81540# 0.10248f
C633 a_22825_77340# VR 3.95834f
C634 B0 VCTRL 1.97623f
C635 a_32345_77340# a_32494_91140# 0.08473f
C636 a_22680_91200# a_22974_85960# 0.08382f
C637 a_49705_81540# VR 0.89698f
C638 a_25924_30800# a_26334_30800# 0.0129f
C639 VR a_8825_26660# 5.11783f
C640 a_65124_81480# VR 0.63502f
C641 a_31664_43540# VR 0.50376f
C642 a_57400_77340# a_12809_65469# 0.02889f
C643 a_28909_57069# B1 0.10896f
C644 a_51124_81480# a_51534_81480# 0.0129f
C645 a_59374_77280# a_57400_77340# 0.01988f
C646 a_32494_85960# a_32200_91200# 0.08382f
C647 a_29925_57069# VDD 0.25314f
C648 a_32560_104720# VR 0.50376f
C649 a_65385_81540# a_65385_77682# 0.38839f
C650 a_12885_64740# a_13305_77340# 1.16646f
C651 a_32345_77340# a_32200_91200# 1.00157f
C652 a_22680_91200# a_22564_85960# 0.01114f
C653 a_49444_81480# VR 0.63502f
C654 VR a_8564_30660# 0.36293f
C655 a_59374_81340# VR 0.35048f
C656 a_25914_43400# VR 0.60202f
C657 a_7294_85960# a_3640_91200# 0.01096f
C658 a_46940_3486# a_16665_27002# 0.05175f
C659 a_12809_65469# VDD 0.25015f
C660 a_25765_64740# a_43427_77929# 3.01558f
C661 a_51124_81480# a_49705_77682# 0.02019f
C662 VDD a_30084_11900# 0.75817f
C663 a_23253_52869# a_28909_57069# 0.06975f
C664 a_37337_52869# LOIP 0.07839f
C665 a_32084_85960# a_32200_91200# 0.01114f
C666 a_25765_39400# a_62174_30800# 0.01196f
C667 VR a_31569_13109# 1.11944f
C668 a_65385_81540# a_66804_81480# 0.04818f
C669 a_13454_91140# a_13305_77340# 0.08473f
C670 a_32345_77340# a_32084_91140# 0.01114f
C671 a_43694_81340# VR 0.35048f
C672 a_58964_81340# VR 0.36374f
C673 a_46000_104720# VR 0.50376f
C674 a_6884_85960# a_3640_91200# 0.08463f
C675 a_30408_51940# a_19487_65329# 0.0142f
C676 a_12885_64740# VR 6.88125f
C677 a_43694_81340# a_41865_77340# 0.0199f
C678 a_12809_40129# a_60345_30860# 0.0727f
C679 a_36325_56340# a_37032_56280# 0.01555f
C680 a_6884_77280# a_7294_77280# 0.0129f
C681 a_57694_77280# a_57400_77340# 0.01069f
C682 a_32084_77280# a_32200_77340# 0.04076f
C683 a_25765_39400# a_60345_27002# 0.69929f
C684 a_13520_43540# VR 0.50376f
C685 a_65385_81540# a_65534_81480# 0.0476f
C686 VDD LOIP 1.04438f
C687 a_33764_85960# VR 1.15119f
C688 a_13160_91200# a_13305_77340# 1.00266f
C689 a_8707_27249# a_26067_27389# 0.14656f
C690 VDD a_41016_13271# 0.69733f
C691 a_51534_81480# a_43427_77929# 0.0121f
C692 a_38360_26660# a_38654_26600# 0.01069f
C693 a_52505_26660# a_52654_26600# 0.01991f
C694 a_40067_27249# a_16665_27002# 0.12962f
C695 a_43284_81340# VR 0.36374f
C696 a_36325_56340# a_41478_52282# 0.01669f
C697 a_25765_64740# VR 5.9059f
C698 a_23253_52869# a_33918_56280# 0.0284f
C699 a_32200_91200# a_32494_91140# 0.02009f
C700 a_45104_104720# VR 0.50376f
C701 a_25765_39400# a_16665_27002# 0.03741f
C702 a_38569_65469# B1 0.07079f
C703 a_13454_91140# VR 1.06472f
C704 a_22825_81680# a_22825_77340# 0.31831f
C705 a_25765_39400# a_23897_52869# 0.95174f
C706 a_25765_64740# a_41865_77340# 0.02479f
C707 a_12809_40129# a_60084_30800# 0.0155f
C708 B0 VR 0.10689f
C709 a_25765_39400# a_61764_30800# 0.01245f
C710 a_12624_43540# VR 0.50376f
C711 a_13044_91140# a_13305_77340# 0.01114f
C712 a_32494_85960# VR 1.08855f
C713 a_49705_77682# a_43427_77929# 0.73653f
C714 VDD a_35584_13271# 0.69733f
C715 a_38569_65469# a_28909_57069# 0.14638f
C716 a_41720_77340# LOQN 0.03991f
C717 a_29925_57069# LOIN 0.04359f
C718 a_3667_78209# a_13305_77340# 0.10193f
C719 a_45514_43400# VR 0.60202f
C720 a_24387_78209# VDD 0.23364f
C721 VR a_65385_77682# 0.8238f
C722 a_24387_78209# a_22680_77340# 0.09664f
C723 a_23253_52869# a_33460_56280# 0.01347f
C724 a_29120_51940# a_19487_65329# 0.02547f
C725 a_32084_91140# a_32494_91140# 0.02581f
C726 a_32345_77340# VR 3.76721f
C727 a_3785_77340# LOIP 0.57803f
C728 a_13160_91200# VR 3.28833f
C729 a_51534_81480# VR 0.58576f
C730 a_12809_65469# LOIN 0.04103f
C731 a_12809_40129# VR 5.27533f
C732 a_32084_85960# VR 1.15401f
C733 a_8825_26660# a_26067_27389# 0.09997f
C734 VDD a_34224_11900# 0.70783f
C735 a_51124_81480# a_43427_77929# 0.01259f
C736 a_38244_26600# a_38360_26660# 0.01998f
C737 a_25765_39400# a_32345_27002# 0.06838f
C738 a_45104_43400# VR 0.63535f
C739 VR a_66804_81480# 0.58512f
C740 a_32084_91140# a_32200_91200# 0.07639f
C741 a_23253_52869# a_32378_56280# 0.01452f
C742 a_32345_81680# B1 0.11086f
C743 a_13044_91140# VR 1.06472f
C744 a_3785_77340# a_3785_81680# 0.31831f
C745 VDD a_35584_11900# 0.70298f
C746 a_3667_78209# VR 5.26697f
C747 a_35309_56340# a_36325_56340# 1.78506f
C748 a_49705_77682# VR 0.81882f
C749 a_38654_26600# a_38505_26660# 0.01991f
C750 a_26334_85960# VR 1.06472f
C751 a_5204_85960# a_5614_85960# 0.02581f
C752 a_34224_11900# a_21997_11960# 0.0514f
C753 VDD a_31384_11900# 0.70783f
C754 a_39280_43540# VR 0.50376f
C755 VDD LOQN 2.65625f
C756 a_12885_64740# a_22825_81680# 0.06235f
C757 LOIP LOIN 2.88117f
C758 a_35309_56340# a_41020_52282# 0.0136f
C759 a_36325_56340# a_39480_52282# 0.01514f
C760 a_37032_56280# VR 0.58366f
C761 VR a_65534_81480# 0.60202f
C762 a_16404_77280# a_13305_81680# 0.04759f
C763 a_3785_77340# a_7294_85960# 0.07629f
C764 a_57545_77340# a_59374_81340# 0.0199f
C765 a_8680_26660# a_10654_26600# 0.01988f
C766 a_36325_56340# a_42560_51940# 0.0135f
C767 a_5204_77280# a_5614_77280# 0.0129f
C768 a_32494_91140# VR 1.06472f
C769 a_25924_77280# a_26334_77280# 0.0129f
C770 a_51124_81480# VR 0.58512f
C771 a_67214_77622# a_65385_77682# 0.01149f
C772 a_38360_26660# a_38505_26660# 0.1904f
C773 a_12809_40129# a_19487_39989# 0.29269f
C774 a_8825_26660# a_24505_30860# 0.0727f
C775 a_31384_11900# a_21997_11960# 0.05586f
C776 VCTRL VR 0.46828f
C777 a_37337_52869# a_16665_27002# 0.04307f
C778 a_38384_43540# VR 0.50376f
C779 a_35309_56340# a_39938_52282# 0.02044f
C780 a_16814_85960# a_16404_85960# 0.02581f
C781 a_36325_56340# VR 4.9031f
C782 a_25765_39400# B1 0.04281f
C783 VR a_65385_81540# 0.89698f
C784 a_3785_77340# a_6884_85960# 0.0275f
C785 a_12809_65469# a_65124_81480# 0.0155f
C786 a_28909_57069# a_19487_65329# 1.23297f
C787 a_32200_91200# VR 3.28833f
C788 a_35309_56340# a_43204_51940# 0.02261f
C789 a_24387_78209# LOIN 2.63526f
C790 a_49854_81480# VR 0.60202f
C791 a_38244_26600# a_38505_26660# 0.01292f
C792 a_8825_26660# a_24244_30800# 0.0155f
C793 a_36325_56340# a_38416_51940# 0.01823f
C794 a_23253_52869# a_19487_65329# 1.35144f
C795 a_36016_56280# VR 0.59569f
C796 a_22825_77340# LOIP 0.07919f
C797 B0 a_26067_27389# 0.04385f
C798 VDD a_16665_27002# 0.45065f
C799 a_57545_77340# a_25765_64740# 0.55283f
C800 a_31664_104720# VR 0.50376f
C801 a_23897_52869# VDD 0.50329f
C802 VR a_60345_30860# 0.89698f
C803 a_38505_26660# a_38654_30660# 0.02238f
C804 a_32084_91140# VR 1.06472f
C805 a_65534_77622# a_65385_77682# 0.01511f
C806 LOQP VDD 0.28495f
C807 a_36325_56340# a_37772_51940# 0.03352f
C808 a_43427_77929# VR 5.37097f
C809 VR a_38654_30660# 0.35048f
C810 a_35309_56340# VR 5.13453f
C811 a_12885_64740# a_13305_81680# 0.04191f
C812 a_13305_77340# VR 3.85008f
C813 a_36325_56340# a_19487_39989# 0.01175f
C814 a_41865_77340# a_43427_77929# 0.34338f
C815 a_12885_64740# a_12809_65469# 0.73244f
C816 a_23253_52869# a_31920_56280# 0.01758f
C817 VR a_60084_30800# 0.63502f
C818 a_24387_78209# a_22825_77340# 0.1594f
C819 a_16665_30860# a_16665_27002# 0.38839f
C820 VDD a_41016_11900# 0.70298f
C821 a_3524_85960# a_3934_85960# 0.02581f
C822 a_49854_77622# a_49705_77682# 0.01511f
C823 a_12809_40129# a_52360_26660# 0.03744f
C824 a_32345_81680# a_32494_81620# 0.0476f
C825 a_36325_56340# a_37128_51940# 0.01477f
C826 a_42014_81340# VR 0.35048f
C827 a_19487_65329# a_33460_56280# 0.01187f
C828 VR a_38505_26660# 2.34588f
C829 a_36016_56280# a_19487_39989# 0.01501f
C830 a_25840_104720# VR 0.50376f
C831 a_12809_65469# a_25765_64740# 0.42958f
C832 a_41865_77340# a_42014_81340# 0.02277f
C833 a_23253_52869# a_30732_56280# 0.01274f
C834 a_38244_30660# a_38505_26660# 0.01168f
C835 VR a_54334_30660# 0.35048f
C836 a_22974_91140# a_22825_77340# 0.08473f
C837 a_16665_30860# a_18084_30800# 0.04818f
C838 a_28909_57069# a_29716_56280# 0.01046f
C839 a_19344_68740# a_19754_68740# 0.0129f
C840 a_32084_81620# a_32494_81620# 0.0129f
C841 a_12885_64740# LOIP 0.03849f
C842 a_37337_52869# B1 0.4495f
C843 a_41865_77340# VR 1.36496f
C844 a_19487_65329# a_32378_56280# 0.02915f
C845 VR a_38244_30660# 0.36293f
C846 a_35309_56340# a_19487_39989# 0.4424f
C847 a_36325_56340# a_22709_52000# 0.5051f
C848 a_24944_104720# VR 0.50376f
C849 a_25924_85960# a_22825_77340# 0.02926f
C850 a_5614_85960# a_3640_91200# 0.08073f
C851 a_25765_64740# a_25914_64680# 0.02481f
C852 a_12809_65469# a_65385_77682# 0.02056f
C853 a_23253_52869# a_29716_56280# 0.01063f
C854 VCTRL a_26067_27389# 2.32671f
C855 a_22825_77340# LOQN 0.57803f
R0 B1 B1.n0 196.123
R1 B1.n0 B1.t1 76.6929
R2 B1.n0 B1.t0 48.3305
R3 LOIN LOIN.n1 182.097
R4 LOIN.n1 LOIN.t2 13.5662
R5 LOIN.n1 LOIN.n0 7.6265
R6 LOIN.n0 LOIN.t0 5.68998
R7 LOIN.n0 LOIN.t1 5.56141
R8 LOIP LOIP.n1 220.107
R9 LOIP.n1 LOIP.t1 13.5662
R10 LOIP.n1 LOIP.n0 7.6265
R11 LOIP.n0 LOIP.t2 5.68998
R12 LOIP.n0 LOIP.t0 5.56141
R13 VR.n258 VR.t294 301.236
R14 VR.t18 VR.n364 301.236
R15 VR.n260 VR.t316 301.236
R16 VR.t233 VR.n357 301.236
R17 VR.n262 VR.t149 301.236
R18 VR.t169 VR.n350 301.236
R19 VR.n264 VR.t191 301.236
R20 VR.t215 VR.n343 301.236
R21 VR.n248 VR.t264 272.822
R22 VR.t273 VR.n335 272.822
R23 VR.n250 VR.t79 272.822
R24 VR.t85 VR.n374 272.822
R25 VR.n252 VR.t135 272.822
R26 VR.t141 VR.n385 272.822
R27 VR.n254 VR.t253 272.822
R28 VR.t259 VR.n507 272.822
R29 VR.n256 VR.t99 272.822
R30 VR.t105 VR.n513 272.822
R31 VR.n266 VR.t277 272.822
R32 VR.t285 VR.n533 272.822
R33 VR.n268 VR.t57 272.822
R34 VR.t63 VR.n540 272.822
R35 VR.n270 VR.t65 272.822
R36 VR.t75 VR.n557 272.822
R37 VR.n272 VR.t243 272.822
R38 VR.t249 VR.n593 272.822
R39 VR.n274 VR.t39 272.822
R40 VR.t45 VR.n599 272.822
R41 VR.n276 VR.t0 272.822
R42 VR.t6 VR.n611 272.822
R43 VR.n278 VR.t31 272.822
R44 VR.t37 VR.n605 272.822
R45 VR.t300 VR.n41 180.743
R46 VR.n41 VR.t8 180.743
R47 VR.t326 VR.n39 180.743
R48 VR.n39 VR.t223 180.743
R49 VR.t157 VR.n37 180.743
R50 VR.n37 VR.t161 180.743
R51 VR.t197 VR.n35 180.743
R52 VR.n35 VR.t209 180.743
R53 VR.t294 VR.t296 146.804
R54 VR.t296 VR.t298 146.804
R55 VR.t298 VR.t300 146.804
R56 VR.t8 VR.t14 146.804
R57 VR.t14 VR.t16 146.804
R58 VR.t16 VR.t18 146.804
R59 VR.t316 VR.t322 146.804
R60 VR.t322 VR.t324 146.804
R61 VR.t324 VR.t326 146.804
R62 VR.t223 VR.t227 146.804
R63 VR.t227 VR.t229 146.804
R64 VR.t229 VR.t233 146.804
R65 VR.t149 VR.t153 146.804
R66 VR.t153 VR.t155 146.804
R67 VR.t155 VR.t157 146.804
R68 VR.t161 VR.t165 146.804
R69 VR.t165 VR.t167 146.804
R70 VR.t167 VR.t169 146.804
R71 VR.t191 VR.t193 146.804
R72 VR.t193 VR.t195 146.804
R73 VR.t195 VR.t197 146.804
R74 VR.t209 VR.t211 146.804
R75 VR.t211 VR.t213 146.804
R76 VR.t213 VR.t215 146.804
R77 VR.t264 VR.t269 127.862
R78 VR.t271 VR.t273 127.862
R79 VR.t79 VR.t81 127.862
R80 VR.t83 VR.t85 127.862
R81 VR.t135 VR.t137 127.862
R82 VR.t139 VR.t141 127.862
R83 VR.t253 VR.t255 127.862
R84 VR.t257 VR.t259 127.862
R85 VR.t99 VR.t103 127.862
R86 VR.t101 VR.t105 127.862
R87 VR.t277 VR.t281 127.862
R88 VR.t283 VR.t285 127.862
R89 VR.t57 VR.t59 127.862
R90 VR.t61 VR.t63 127.862
R91 VR.t65 VR.t73 127.862
R92 VR.t67 VR.t75 127.862
R93 VR.t243 VR.t245 127.862
R94 VR.t247 VR.t249 127.862
R95 VR.t39 VR.t41 127.862
R96 VR.t43 VR.t45 127.862
R97 VR.t0 VR.t2 127.862
R98 VR.t4 VR.t6 127.862
R99 VR.t31 VR.t33 127.862
R100 VR.t35 VR.t37 127.862
R101 VR.n258 VR.n41 101.406
R102 VR.n364 VR.n41 101.406
R103 VR.n260 VR.n39 101.406
R104 VR.n357 VR.n39 101.406
R105 VR.n262 VR.n37 101.406
R106 VR.n350 VR.n37 101.406
R107 VR.n264 VR.n35 101.406
R108 VR.n343 VR.n35 101.406
R109 VR.n258 VR.n64 0.699361
R110 VR.n364 VR.n65 0.699361
R111 VR.n260 VR.n66 0.699361
R112 VR.n357 VR.n67 0.699361
R113 VR.n262 VR.n68 0.699361
R114 VR.n350 VR.n69 0.699361
R115 VR.n264 VR.n70 0.699361
R116 VR.n343 VR.n71 0.699361
R117 VR.n73 VR.n327 81.2342
R118 VR.n76 VR.n323 81.2342
R119 VR.n79 VR.n565 81.2342
R120 VR.n82 VR.n561 81.2342
R121 VR.n166 VR.n576 81.2342
R122 VR.n169 VR.n572 81.2342
R123 VR.n172 VR.t24 81.2342
R124 VR.n175 VR.t130 81.2342
R125 VR.n43 VR.n72 32.1775
R126 VR.n45 VR.n75 32.1775
R127 VR.n47 VR.n78 32.1775
R128 VR.n49 VR.n81 32.1775
R129 VR.n51 VR.n165 32.1775
R130 VR.n53 VR.n168 32.1775
R131 VR.n55 VR.n171 32.1775
R132 VR.n57 VR.n174 32.1775
R133 VR.n248 VR.n332 66.2717
R134 VR.n335 VR.n332 66.2717
R135 VR.n250 VR.n371 66.2717
R136 VR.n374 VR.n371 66.2717
R137 VR.n252 VR.n382 66.2717
R138 VR.n385 VR.n382 66.2717
R139 VR.n254 VR.n504 66.2717
R140 VR.n507 VR.n504 66.2717
R141 VR.n256 VR.n510 66.2717
R142 VR.n513 VR.n510 66.2717
R143 VR.n266 VR.n530 66.2717
R144 VR.n533 VR.n530 66.2717
R145 VR.n268 VR.n537 66.2717
R146 VR.n540 VR.n537 66.2717
R147 VR.n270 VR.n554 66.2717
R148 VR.n557 VR.n554 66.2717
R149 VR.n272 VR.n590 66.2717
R150 VR.n593 VR.n590 66.2717
R151 VR.n274 VR.n596 66.2717
R152 VR.n599 VR.n596 66.2717
R153 VR.n276 VR.n608 66.2717
R154 VR.n611 VR.n608 66.2717
R155 VR.n278 VR.n602 66.2717
R156 VR.n605 VR.n602 66.2717
R157 VR.n248 VR.n334 66.2111
R158 VR.n335 VR.n334 66.2111
R159 VR.n250 VR.n373 66.2111
R160 VR.n374 VR.n373 66.2111
R161 VR.n252 VR.n384 66.2111
R162 VR.n385 VR.n384 66.2111
R163 VR.n254 VR.n506 66.2111
R164 VR.n507 VR.n506 66.2111
R165 VR.n256 VR.n512 66.2111
R166 VR.n513 VR.n512 66.2111
R167 VR.n266 VR.n532 66.2111
R168 VR.n533 VR.n532 66.2111
R169 VR.n268 VR.n539 66.2111
R170 VR.n540 VR.n539 66.2111
R171 VR.n270 VR.n556 66.2111
R172 VR.n557 VR.n556 66.2111
R173 VR.n272 VR.n592 66.2111
R174 VR.n593 VR.n592 66.2111
R175 VR.n274 VR.n598 66.2111
R176 VR.n599 VR.n598 66.2111
R177 VR.n276 VR.n610 66.2111
R178 VR.n611 VR.n610 66.2111
R179 VR.n278 VR.n604 66.2111
R180 VR.n605 VR.n604 66.2111
R181 VR.t269 VR.n336 63.931
R182 VR.n336 VR.t271 63.931
R183 VR.t81 VR.n375 63.931
R184 VR.n375 VR.t83 63.931
R185 VR.t137 VR.n386 63.931
R186 VR.n386 VR.t139 63.931
R187 VR.t255 VR.n508 63.931
R188 VR.n508 VR.t257 63.931
R189 VR.t103 VR.n514 63.931
R190 VR.n514 VR.t101 63.931
R191 VR.t281 VR.n534 63.931
R192 VR.n534 VR.t283 63.931
R193 VR.t59 VR.n541 63.931
R194 VR.n541 VR.t61 63.931
R195 VR.t73 VR.n558 63.931
R196 VR.n558 VR.t67 63.931
R197 VR.t245 VR.n594 63.931
R198 VR.n594 VR.t247 63.931
R199 VR.t41 VR.n600 63.931
R200 VR.n600 VR.t43 63.931
R201 VR.t2 VR.n612 63.931
R202 VR.n612 VR.t4 63.931
R203 VR.t33 VR.n606 63.931
R204 VR.n606 VR.t35 63.931
R205 VR.n85 VR.n203 55.7918
R206 VR.n88 VR.n204 55.7918
R207 VR.n437 VR.n205 55.7918
R208 VR.n94 VR.n206 55.7918
R209 VR.n492 VR.n207 55.7918
R210 VR.n112 VR.n208 55.7918
R211 VR.n481 VR.n209 55.7918
R212 VR.n115 VR.n210 55.7918
R213 VR.n124 VR.n211 55.7918
R214 VR.n127 VR.n212 55.7918
R215 VR.n130 VR.n213 55.7918
R216 VR.n157 VR.n214 55.7918
R217 VR.n160 VR.n215 55.7918
R218 VR.n163 VR.n216 55.7918
R219 VR.n632 VR.n217 55.7918
R220 VR.n184 VR.n218 55.7918
R221 VR.n653 VR.n219 55.7918
R222 VR.n193 VR.n220 55.7918
R223 VR.n221 VR.n338 55.7313
R224 VR.n222 VR.n377 55.7313
R225 VR.n224 VR.n436 55.7313
R226 VR.n225 VR.n431 55.7313
R227 VR.n227 VR.n491 55.7313
R228 VR.n228 VR.n486 55.7313
R229 VR.n230 VR.n480 55.7313
R230 VR.n231 VR.n475 55.7313
R231 VR.n232 VR.n393 55.7313
R232 VR.n233 VR.n388 55.7313
R233 VR.n234 VR.n517 55.7313
R234 VR.n235 VR.n525 55.7313
R235 VR.n236 VR.n544 55.7313
R236 VR.n237 VR.n549 55.7313
R237 VR.n239 VR.n631 55.7313
R238 VR.n240 VR.n626 55.7313
R239 VR.n242 VR.n652 55.7313
R240 VR.n243 VR.n647 55.7313
R241 VR.n43 VR.t29 0.640653
R242 VR.n45 VR.t50 0.640653
R243 VR.n47 VR.t314 0.640653
R244 VR.n49 VR.t48 0.640653
R245 VR.n51 VR.t203 0.640653
R246 VR.n53 VR.t288 0.640653
R247 VR.n73 VR.n42 52.8503
R248 VR.n76 VR.n44 52.8503
R249 VR.n79 VR.n46 52.8503
R250 VR.n82 VR.n48 52.8503
R251 VR.n166 VR.n50 52.8503
R252 VR.n169 VR.n52 52.8503
R253 VR.n172 VR.n54 52.8503
R254 VR.n175 VR.n56 52.8503
R255 VR.n133 VR.t159 49.4918
R256 VR.n136 VR.t147 49.4918
R257 VR.n139 VR.t12 49.4918
R258 VR.n142 VR.t290 49.4918
R259 VR.n145 VR.t189 49.4918
R260 VR.n148 VR.t207 49.4918
R261 VR.n151 VR.t225 49.4918
R262 VR.n154 VR.t320 49.4918
R263 VR.n307 VR.n132 23.1419
R264 VR.n309 VR.n135 23.1419
R265 VR.n311 VR.n138 23.1419
R266 VR.n313 VR.n141 23.1419
R267 VR.n315 VR.n144 23.1419
R268 VR.n317 VR.n147 23.1419
R269 VR.n319 VR.n150 23.1419
R270 VR.n321 VR.n153 23.1419
R271 VR.n91 VR.n279 47.3111
R272 VR.n97 VR.n280 47.3111
R273 VR.n100 VR.n281 47.3111
R274 VR.n103 VR.n282 47.3111
R275 VR.n106 VR.n283 47.3111
R276 VR.n109 VR.n284 47.3111
R277 VR.n118 VR.n285 47.3111
R278 VR.n121 VR.n286 47.3111
R279 VR.n178 VR.n287 47.3111
R280 VR.n181 VR.n288 47.3111
R281 VR.n187 VR.n289 47.3111
R282 VR.n190 VR.n290 47.3111
R283 VR.n291 VR.n499 47.2505
R284 VR.n292 VR.n445 47.2505
R285 VR.n293 VR.n441 47.2505
R286 VR.n294 VR.n451 47.2505
R287 VR.n295 VR.n460 47.2505
R288 VR.n296 VR.n456 47.2505
R289 VR.n297 VR.n470 47.2505
R290 VR.n298 VR.n466 47.2505
R291 VR.n299 VR.n620 47.2505
R292 VR.n300 VR.n616 47.2505
R293 VR.n301 VR.n641 47.2505
R294 VR.n302 VR.n637 47.2505
R295 VR.n338 VR.n203 45.2772
R296 VR.n377 VR.n204 45.2772
R297 VR.n436 VR.n205 45.2772
R298 VR.n431 VR.n206 45.2772
R299 VR.n491 VR.n207 45.2772
R300 VR.n486 VR.n208 45.2772
R301 VR.n480 VR.n209 45.2772
R302 VR.n475 VR.n210 45.2772
R303 VR.n393 VR.n211 45.2772
R304 VR.n388 VR.n212 45.2772
R305 VR.n517 VR.n213 45.2772
R306 VR.n525 VR.n214 45.2772
R307 VR.n544 VR.n215 45.2772
R308 VR.n549 VR.n216 45.2772
R309 VR.n631 VR.n217 45.2772
R310 VR.n626 VR.n218 45.2772
R311 VR.n652 VR.n219 45.2772
R312 VR.n647 VR.n220 45.2772
R313 VR.n85 VR.n221 45.2371
R314 VR.n88 VR.n222 45.2371
R315 VR.n437 VR.n224 45.2371
R316 VR.n94 VR.n225 45.2371
R317 VR.n492 VR.n227 45.2371
R318 VR.n112 VR.n228 45.2371
R319 VR.n481 VR.n230 45.2371
R320 VR.n115 VR.n231 45.2371
R321 VR.n124 VR.n232 45.2371
R322 VR.n127 VR.n233 45.2371
R323 VR.n130 VR.n234 45.2371
R324 VR.n157 VR.n235 45.2371
R325 VR.n160 VR.n236 45.2371
R326 VR.n163 VR.n237 45.2371
R327 VR.n632 VR.n239 45.2371
R328 VR.n184 VR.n240 45.2371
R329 VR.n653 VR.n242 45.2371
R330 VR.n193 VR.n243 45.2371
R331 VR.n133 VR.n306 43.0191
R332 VR.n136 VR.n308 43.0191
R333 VR.n139 VR.n310 43.0191
R334 VR.n142 VR.n312 43.0191
R335 VR.n145 VR.n314 43.0191
R336 VR.n148 VR.n316 43.0191
R337 VR.n151 VR.n318 43.0191
R338 VR.n154 VR.n320 43.0191
R339 VR.n499 VR.n279 40.8435
R340 VR.n445 VR.n280 40.8435
R341 VR.n441 VR.n281 40.8435
R342 VR.n451 VR.n282 40.8435
R343 VR.n460 VR.n283 40.8435
R344 VR.n456 VR.n284 40.8435
R345 VR.n470 VR.n285 40.8435
R346 VR.n466 VR.n286 40.8435
R347 VR.n620 VR.n287 40.8435
R348 VR.n616 VR.n288 40.8435
R349 VR.n641 VR.n289 40.8435
R350 VR.n637 VR.n290 40.8435
R351 VR.n91 VR.n291 40.7981
R352 VR.n97 VR.n292 40.7981
R353 VR.n100 VR.n293 40.7981
R354 VR.n103 VR.n294 40.7981
R355 VR.n106 VR.n295 40.7981
R356 VR.n109 VR.n296 40.7981
R357 VR.n118 VR.n297 40.7981
R358 VR.n121 VR.n298 40.7981
R359 VR.n178 VR.n299 40.7981
R360 VR.n181 VR.n300 40.7981
R361 VR.n187 VR.n301 40.7981
R362 VR.n190 VR.n302 40.7981
R363 VR.n615 VR.n305 16.2989
R364 VR.n63 VR.t309 15.3541
R365 VR.n304 VR.t329 11.9381
R366 VR.n614 VR.n607 11.0797
R367 VR.n392 VR.n387 10.8277
R368 VR VR.n657 10.7861
R369 VR.n571 VR.n331 10.4374
R370 VR.n485 VR.n474 9.36346
R371 VR.n560 VR.n559 9.28061
R372 VR.n397 VR.n396 8.16573
R373 VR.n392 VR.n391 8.16573
R374 VR.n529 VR.n528 8.16573
R375 VR.n548 VR.n547 8.16573
R376 VR.n553 VR.n552 8.16573
R377 VR.n536 VR.n535 8.05572
R378 VR.n543 VR.n542 8.05572
R379 VR.n614 VR.n613 8.05572
R380 VR.n342 VR.n337 7.68702
R381 VR.n381 VR.n376 7.68702
R382 VR.n305 VR.n595 7.68702
R383 VR.n303 VR.n503 7.63564
R384 VR.n498 VR.n430 7.16825
R385 VR.n570 VR.n560 7.03737
R386 VR.n500 VR.t306 6.93035
R387 VR.n446 VR.t262 6.93035
R388 VR.n442 VR.t144 6.93035
R389 VR.n452 VR.t22 6.93035
R390 VR.n461 VR.t27 6.93035
R391 VR.n457 VR.t239 6.93035
R392 VR.n471 VR.t313 6.93035
R393 VR.n467 VR.t108 6.93035
R394 VR.n368 VR.t160 6.93035
R395 VR.n365 VR.t148 6.93035
R396 VR.n361 VR.t13 6.93035
R397 VR.n358 VR.t291 6.93035
R398 VR.n354 VR.t190 6.93035
R399 VR.n351 VR.t208 6.93035
R400 VR.n347 VR.t226 6.93035
R401 VR.n344 VR.t321 6.93035
R402 VR.n621 VR.t267 6.93035
R403 VR.n617 VR.t276 6.93035
R404 VR.n642 VR.t55 6.93035
R405 VR.n638 VR.t72 6.93035
R406 VR.n524 VR.n523 6.84204
R407 VR.n523 VR.n522 6.77904
R408 VR.n33 VR.t274 6.10958
R409 VR.n33 VR.t265 6.10958
R410 VR.n31 VR.t86 6.10958
R411 VR.n31 VR.t80 6.10958
R412 VR.n29 VR.t142 6.10958
R413 VR.n29 VR.t136 6.10958
R414 VR.n27 VR.t260 6.10958
R415 VR.n27 VR.t254 6.10958
R416 VR.n25 VR.t106 6.10958
R417 VR.n25 VR.t100 6.10958
R418 VR.n58 VR.t19 6.10958
R419 VR.n9 VR.t9 6.10958
R420 VR.n9 VR.t301 6.10958
R421 VR.n9 VR.t295 6.10958
R422 VR.n59 VR.t234 6.10958
R423 VR.n7 VR.t224 6.10958
R424 VR.n7 VR.t327 6.10958
R425 VR.n7 VR.t317 6.10958
R426 VR.n60 VR.t170 6.10958
R427 VR.n5 VR.t162 6.10958
R428 VR.n5 VR.t158 6.10958
R429 VR.n5 VR.t150 6.10958
R430 VR.n61 VR.t216 6.10958
R431 VR.n3 VR.t210 6.10958
R432 VR.n3 VR.t198 6.10958
R433 VR.n3 VR.t192 6.10958
R434 VR.n23 VR.t286 6.10958
R435 VR.n23 VR.t278 6.10958
R436 VR.n21 VR.t64 6.10958
R437 VR.n21 VR.t58 6.10958
R438 VR.n19 VR.t76 6.10958
R439 VR.n19 VR.t66 6.10958
R440 VR.n17 VR.t250 6.10958
R441 VR.n17 VR.t244 6.10958
R442 VR.n15 VR.t46 6.10958
R443 VR.n15 VR.t40 6.10958
R444 VR.n13 VR.t7 6.10958
R445 VR.n13 VR.t1 6.10958
R446 VR.n11 VR.t38 6.10958
R447 VR.n11 VR.t32 6.10958
R448 VR.n450 VR.n440 6.03376
R449 VR.n422 VR.t180 5.95626
R450 VR.n414 VR.t181 5.95626
R451 VR.n407 VR.t222 5.89952
R452 VR.n399 VR.t77 5.89952
R453 VR.n496 VR.n495 5.89846
R454 VR.n485 VR.n484 5.89846
R455 VR.n429 VR.n245 5.65467
R456 VR.n33 VR.t272 5.49125
R457 VR.n31 VR.t84 5.49125
R458 VR.n29 VR.t140 5.49125
R459 VR.n27 VR.t258 5.49125
R460 VR.n25 VR.t102 5.49125
R461 VR.n58 VR.t17 5.49125
R462 VR.n9 VR.t299 5.49125
R463 VR.n59 VR.t230 5.49125
R464 VR.n7 VR.t325 5.49125
R465 VR.n60 VR.t168 5.49125
R466 VR.n5 VR.t156 5.49125
R467 VR.n61 VR.t214 5.49125
R468 VR.n3 VR.t196 5.49125
R469 VR.n23 VR.t284 5.49125
R470 VR.n21 VR.t62 5.49125
R471 VR.n19 VR.t68 5.49125
R472 VR.n17 VR.t248 5.49125
R473 VR.n15 VR.t44 5.49125
R474 VR.n13 VR.t5 5.49125
R475 VR.n11 VR.t36 5.49125
R476 VR.n247 VR.n33 5.47764
R477 VR.n249 VR.n31 5.47764
R478 VR.n251 VR.n29 5.47764
R479 VR.n253 VR.n27 5.47764
R480 VR.n255 VR.n25 5.47764
R481 VR.n265 VR.n23 5.47764
R482 VR.n267 VR.n21 5.47764
R483 VR.n269 VR.n19 5.47764
R484 VR.n271 VR.n17 5.47764
R485 VR.n273 VR.n15 5.47764
R486 VR.n275 VR.n13 5.47764
R487 VR.n277 VR.n11 5.47764
R488 VR.n429 VR.n304 5.2763
R489 VR.n422 VR.t122 5.26198
R490 VR.n423 VR.t125 5.26198
R491 VR.n424 VR.t174 5.26198
R492 VR.n425 VR.t179 5.26198
R493 VR.n426 VR.t117 5.26198
R494 VR.n427 VR.t126 5.26198
R495 VR.n421 VR.t183 5.26198
R496 VR.n420 VR.t307 5.26198
R497 VR.n419 VR.t98 5.26198
R498 VR.n418 VR.t302 5.26198
R499 VR.n417 VR.t199 5.26198
R500 VR.n416 VR.t116 5.26198
R501 VR.n415 VR.t186 5.26198
R502 VR.n414 VR.t121 5.26198
R503 VR.n407 VR.t129 5.20524
R504 VR.n408 VR.t182 5.20524
R505 VR.n409 VR.t236 5.20524
R506 VR.n410 VR.t112 5.20524
R507 VR.n411 VR.t128 5.20524
R508 VR.n412 VR.t304 5.20524
R509 VR.n406 VR.t308 5.20524
R510 VR.n405 VR.t184 5.20524
R511 VR.n404 VR.t120 5.20524
R512 VR.n403 VR.t287 5.20524
R513 VR.n402 VR.t173 5.20524
R514 VR.n401 VR.t127 5.20524
R515 VR.n400 VR.t303 5.20524
R516 VR.n399 VR.t221 5.20524
R517 VR.n398 VR.n246 5.0954
R518 VR.n132 VR.n368 5.00836
R519 VR.n135 VR.n365 5.00836
R520 VR.n138 VR.n361 5.00836
R521 VR.n141 VR.n358 5.00836
R522 VR.n144 VR.n354 5.00836
R523 VR.n147 VR.n351 5.00836
R524 VR.n150 VR.n347 5.00836
R525 VR.n153 VR.n344 5.00836
R526 VR.n304 VR.n413 4.9694
R527 VR.n90 VR.n500 4.95693
R528 VR.n96 VR.n446 4.95693
R529 VR.n99 VR.n442 4.95693
R530 VR.n102 VR.n452 4.95693
R531 VR.n105 VR.n461 4.95693
R532 VR.n108 VR.n457 4.95693
R533 VR.n117 VR.n471 4.95693
R534 VR.n120 VR.n467 4.95693
R535 VR.n177 VR.n621 4.95693
R536 VR.n180 VR.n617 4.95693
R537 VR.n186 VR.n642 4.95693
R538 VR.n189 VR.n638 4.95693
R539 VR.n368 VR.n134 4.80907
R540 VR.n365 VR.n137 4.80907
R541 VR.n9 VR.n8 4.80907
R542 VR.n257 VR.n58 4.80907
R543 VR.n361 VR.n140 4.80907
R544 VR.n358 VR.n143 4.80907
R545 VR.n7 VR.n6 4.80907
R546 VR.n259 VR.n59 4.80907
R547 VR.n354 VR.n146 4.80907
R548 VR.n351 VR.n149 4.80907
R549 VR.n5 VR.n4 4.80907
R550 VR.n261 VR.n60 4.80907
R551 VR.n347 VR.n152 4.80907
R552 VR.n344 VR.n155 4.80907
R553 VR.n3 VR.n2 4.80907
R554 VR.n263 VR.n61 4.80907
R555 VR.n33 VR.n32 4.78336
R556 VR.n31 VR.n30 4.78336
R557 VR.n500 VR.n92 4.78336
R558 VR.n446 VR.n98 4.78336
R559 VR.n442 VR.n101 4.78336
R560 VR.n452 VR.n104 4.78336
R561 VR.n461 VR.n107 4.78336
R562 VR.n457 VR.n110 4.78336
R563 VR.n471 VR.n119 4.78336
R564 VR.n467 VR.n122 4.78336
R565 VR.n29 VR.n28 4.78336
R566 VR.n27 VR.n26 4.78336
R567 VR.n25 VR.n24 4.78336
R568 VR.n23 VR.n22 4.78336
R569 VR.n21 VR.n20 4.78336
R570 VR.n19 VR.n18 4.78336
R571 VR.n17 VR.n16 4.78336
R572 VR.n15 VR.n14 4.78336
R573 VR.n13 VR.n12 4.78336
R574 VR.n11 VR.n10 4.78336
R575 VR.n621 VR.n179 4.78336
R576 VR.n617 VR.n182 4.78336
R577 VR.n642 VR.n188 4.78336
R578 VR.n638 VR.n191 4.78336
R579 VR.n342 VR.n341 4.78023
R580 VR.n381 VR.n380 4.78023
R581 VR.n521 VR.n520 4.78023
R582 VR.n455 VR.n454 4.75923
R583 VR.n303 VR.n509 4.67022
R584 VR.n516 VR.n515 4.67022
R585 VR.n305 VR.n601 4.67022
R586 VR.n304 VR.n428 4.6544
R587 VR.n398 VR.n322 4.52967
R588 VR.n581 VR.n571 4.30647
R589 VR.n589 VR.n581 4.2773
R590 VR.n339 VR.t164 3.62993
R591 VR.n378 VR.t11 3.62993
R592 VR.n432 VR.t134 3.62993
R593 VR.n487 VR.t88 3.62993
R594 VR.n476 VR.t110 3.62993
R595 VR.n394 VR.t232 3.62993
R596 VR.n389 VR.t319 3.62993
R597 VR.n518 VR.t293 3.62993
R598 VR.n526 VR.t152 3.62993
R599 VR.n545 VR.t206 3.62993
R600 VR.n550 VR.t188 3.62993
R601 VR.n627 VR.t280 3.62993
R602 VR.n648 VR.t70 3.62993
R603 VR.n497 VR.n465 3.55047
R604 VR.n496 VR.n485 3.5285
R605 VR.n657 VR.n646 3.5213
R606 VR.n646 VR.n636 3.5213
R607 VR.n636 VR.n625 3.5213
R608 VR.n455 VR.n450 3.5213
R609 VR.n548 VR.n543 3.0245
R610 VR.n543 VR.n536 3.0245
R611 VR.n516 VR.n303 3.0173
R612 VR.n328 VR.t30 3.0148
R613 VR.n324 VR.t51 3.0148
R614 VR.n566 VR.t315 3.0148
R615 VR.n562 VR.t49 3.0148
R616 VR.n577 VR.t204 3.0148
R617 VR.n573 VR.t289 3.0148
R618 VR.n585 VR.t25 3.0148
R619 VR.n582 VR.t131 3.0148
R620 VR.n581 VR.n580 2.96285
R621 VR.n589 VR.n588 2.96285
R622 VR.n305 VR.n614 2.8634
R623 VR.n303 VR.n397 2.8634
R624 VR.n553 VR.n548 2.7725
R625 VR.n536 VR.n529 2.7725
R626 VR.n397 VR.n392 2.7725
R627 VR.n521 VR.n516 2.7653
R628 VR.n465 VR.n455 2.7653
R629 VR.n503 VR.n502 2.63688
R630 VR.n1 VR.n35 2.61657
R631 VR.n497 VR.n496 2.57757
R632 VR.n199 VR.n326 2.5407
R633 VR.n200 VR.n564 2.5407
R634 VR.n440 VR.n434 2.5407
R635 VR.n449 VR.n444 2.5407
R636 VR.n464 VR.n459 2.5407
R637 VR.n495 VR.n489 2.5407
R638 VR.n484 VR.n478 2.5407
R639 VR.n474 VR.n469 2.5407
R640 VR.n201 VR.n575 2.5407
R641 VR.n202 VR.n584 2.5407
R642 VR.n624 VR.n619 2.5407
R643 VR.n635 VR.n629 2.5407
R644 VR.n645 VR.n640 2.5407
R645 VR.n656 VR.n650 2.5407
R646 VR.n636 VR.n635 2.51296
R647 VR.n657 VR.n656 2.51296
R648 VR.n450 VR.n449 2.44996
R649 VR.n465 VR.n464 2.44996
R650 VR.n625 VR.n624 2.44996
R651 VR.n646 VR.n645 2.44996
R652 VR.n430 VR.n398 2.4413
R653 VR.n72 VR.n328 2.42166
R654 VR.n75 VR.n324 2.42166
R655 VR.n78 VR.n566 2.42166
R656 VR.n81 VR.n562 2.42166
R657 VR.n84 VR.n339 2.42166
R658 VR.n87 VR.n378 2.42166
R659 VR.n93 VR.n432 2.42166
R660 VR.n111 VR.n487 2.42166
R661 VR.n114 VR.n476 2.42166
R662 VR.n123 VR.n394 2.42166
R663 VR.n126 VR.n389 2.42166
R664 VR.n129 VR.n518 2.42166
R665 VR.n156 VR.n526 2.42166
R666 VR.n159 VR.n545 2.42166
R667 VR.n162 VR.n550 2.42166
R668 VR.n165 VR.n577 2.42166
R669 VR.n168 VR.n573 2.42166
R670 VR.n171 VR.n585 2.42166
R671 VR.n174 VR.n582 2.42166
R672 VR.n183 VR.n627 2.42166
R673 VR.n192 VR.n648 2.42166
R674 VR.n328 VR.n74 2.35657
R675 VR.n324 VR.n77 2.35657
R676 VR.n566 VR.n80 2.35657
R677 VR.n562 VR.n83 2.35657
R678 VR.n339 VR.n86 2.35657
R679 VR.n378 VR.n89 2.35657
R680 VR.n432 VR.n95 2.35657
R681 VR.n487 VR.n113 2.35657
R682 VR.n476 VR.n116 2.35657
R683 VR.n394 VR.n125 2.35657
R684 VR.n389 VR.n128 2.35657
R685 VR.n518 VR.n131 2.35657
R686 VR.n526 VR.n158 2.35657
R687 VR.n545 VR.n161 2.35657
R688 VR.n550 VR.n164 2.35657
R689 VR.n577 VR.n167 2.35657
R690 VR.n573 VR.n170 2.35657
R691 VR.n585 VR.n173 2.35657
R692 VR.n582 VR.n176 2.35657
R693 VR.n627 VR.n185 2.35657
R694 VR.n648 VR.n194 2.35657
R695 VR.n199 VR.n330 2.28877
R696 VR.n200 VR.n568 2.28877
R697 VR.n440 VR.n439 2.28877
R698 VR.n449 VR.n448 2.28877
R699 VR.n464 VR.n463 2.28877
R700 VR.n495 VR.n494 2.28877
R701 VR.n484 VR.n483 2.28877
R702 VR.n474 VR.n473 2.28877
R703 VR.n201 VR.n579 2.28877
R704 VR.n202 VR.n587 2.28877
R705 VR.n624 VR.n623 2.28877
R706 VR.n635 VR.n634 2.28877
R707 VR.n645 VR.n644 2.28877
R708 VR.n656 VR.n655 2.28877
R709 VR.n244 VR.n370 2.25805
R710 VR.n244 VR.n367 2.25805
R711 VR.n0 VR.n363 2.25805
R712 VR.n0 VR.n360 2.25805
R713 VR.n0 VR.n356 2.25805
R714 VR.n0 VR.n353 2.25805
R715 VR.n1 VR.n349 2.25805
R716 VR.n1 VR.n346 2.25805
R717 VR.n0 VR.n41 2.25748
R718 VR.n0 VR.n39 2.25748
R719 VR.n0 VR.n37 2.25748
R720 VR.n625 VR.n615 2.0723
R721 VR.n41 VR.n257 1.94704
R722 VR.n41 VR.n8 1.94704
R723 VR.n39 VR.n259 1.94704
R724 VR.n39 VR.n6 1.94704
R725 VR.n37 VR.n261 1.94704
R726 VR.n37 VR.n4 1.94704
R727 VR.n35 VR.n263 1.94704
R728 VR.n35 VR.n2 1.94704
R729 VR.n570 VR.n569 1.83785
R730 VR.n306 VR.n307 0.959193
R731 VR.n308 VR.n309 0.959193
R732 VR.n310 VR.n311 0.959193
R733 VR.n312 VR.n313 0.959193
R734 VR.n314 VR.n315 0.959193
R735 VR.n316 VR.n317 0.959193
R736 VR.n318 VR.n319 0.959193
R737 VR.n320 VR.n321 0.959193
R738 VR.n40 VR.n65 1.71424
R739 VR.n40 VR.n64 1.71424
R740 VR.n38 VR.n67 1.71424
R741 VR.n38 VR.n66 1.71424
R742 VR.n36 VR.n69 1.71424
R743 VR.n36 VR.n68 1.71424
R744 VR.n34 VR.n71 1.71424
R745 VR.n34 VR.n70 1.71424
R746 VR.n421 VR.n420 1.73621
R747 VR.n406 VR.n405 1.73621
R748 VR.n523 VR.n244 1.64524
R749 VR.n54 VR.n55 0.982975
R750 VR.n56 VR.n57 0.982975
R751 VR.n50 VR.n51 0.982975
R752 VR.n52 VR.n53 0.982975
R753 VR.n46 VR.n47 0.982975
R754 VR.n48 VR.n49 0.982975
R755 VR.n42 VR.n43 0.982975
R756 VR.n44 VR.n45 0.982975
R757 VR.n330 VR.n72 1.56281
R758 VR.n330 VR.n74 1.56281
R759 VR.n326 VR.n75 1.56281
R760 VR.n326 VR.n77 1.56281
R761 VR.n568 VR.n78 1.56281
R762 VR.n568 VR.n80 1.56281
R763 VR.n564 VR.n81 1.56281
R764 VR.n564 VR.n83 1.56281
R765 VR.n579 VR.n165 1.56281
R766 VR.n579 VR.n167 1.56281
R767 VR.n575 VR.n168 1.56281
R768 VR.n575 VR.n170 1.56281
R769 VR.n587 VR.n171 1.56281
R770 VR.n587 VR.n173 1.56281
R771 VR.n584 VR.n174 1.56281
R772 VR.n584 VR.n176 1.56281
R773 VR.n560 VR.n553 1.5404
R774 VR.n522 VR.n521 1.5053
R775 VR.n615 VR.n589 1.4423
R776 VR.n420 VR.n419 1.38907
R777 VR.n405 VR.n404 1.38907
R778 VR.n529 VR.n524 1.3514
R779 VR.n329 VR.n72 1.2905
R780 VR.n329 VR.n74 1.2905
R781 VR.n325 VR.n75 1.2905
R782 VR.n325 VR.n77 1.2905
R783 VR.n567 VR.n78 1.2905
R784 VR.n567 VR.n80 1.2905
R785 VR.n563 VR.n81 1.2905
R786 VR.n563 VR.n83 1.2905
R787 VR.n578 VR.n165 1.2905
R788 VR.n578 VR.n167 1.2905
R789 VR.n574 VR.n168 1.2905
R790 VR.n574 VR.n170 1.2905
R791 VR.n586 VR.n171 1.2905
R792 VR.n586 VR.n173 1.2905
R793 VR.n583 VR.n174 1.2905
R794 VR.n583 VR.n176 1.2905
R795 VR.n337 VR.n247 1.27781
R796 VR.n337 VR.n32 1.27781
R797 VR.n376 VR.n249 1.27781
R798 VR.n376 VR.n30 1.27781
R799 VR.n387 VR.n251 1.27781
R800 VR.n387 VR.n28 1.27781
R801 VR.n509 VR.n253 1.27781
R802 VR.n509 VR.n26 1.27781
R803 VR.n515 VR.n255 1.27781
R804 VR.n515 VR.n24 1.27781
R805 VR.n535 VR.n265 1.27781
R806 VR.n535 VR.n22 1.27781
R807 VR.n542 VR.n267 1.27781
R808 VR.n542 VR.n20 1.27781
R809 VR.n559 VR.n269 1.27781
R810 VR.n559 VR.n18 1.27781
R811 VR.n595 VR.n271 1.27781
R812 VR.n595 VR.n16 1.27781
R813 VR.n601 VR.n273 1.27781
R814 VR.n601 VR.n14 1.27781
R815 VR.n613 VR.n275 1.27781
R816 VR.n613 VR.n12 1.27781
R817 VR.n607 VR.n277 1.27781
R818 VR.n607 VR.n10 1.27781
R819 VR.n330 VR.n327 1.2605
R820 VR.n326 VR.n323 1.2605
R821 VR.n568 VR.n565 1.2605
R822 VR.n564 VR.n561 1.2605
R823 VR.n341 VR.n203 1.2605
R824 VR.n221 VR.n340 1.2605
R825 VR.n380 VR.n204 1.2605
R826 VR.n222 VR.n379 1.2605
R827 VR.n502 VR.n279 1.2605
R828 VR.n291 VR.n501 1.2605
R829 VR.n439 VR.n205 1.2605
R830 VR.n224 VR.n223 1.2605
R831 VR.n434 VR.n206 1.2605
R832 VR.n225 VR.n433 1.2605
R833 VR.n448 VR.n280 1.2605
R834 VR.n292 VR.n447 1.2605
R835 VR.n444 VR.n281 1.2605
R836 VR.n293 VR.n443 1.2605
R837 VR.n454 VR.n282 1.2605
R838 VR.n294 VR.n453 1.2605
R839 VR.n463 VR.n283 1.2605
R840 VR.n295 VR.n462 1.2605
R841 VR.n459 VR.n284 1.2605
R842 VR.n296 VR.n458 1.2605
R843 VR.n494 VR.n207 1.2605
R844 VR.n227 VR.n226 1.2605
R845 VR.n489 VR.n208 1.2605
R846 VR.n228 VR.n488 1.2605
R847 VR.n483 VR.n209 1.2605
R848 VR.n230 VR.n229 1.2605
R849 VR.n478 VR.n210 1.2605
R850 VR.n231 VR.n477 1.2605
R851 VR.n473 VR.n285 1.2605
R852 VR.n297 VR.n472 1.2605
R853 VR.n469 VR.n286 1.2605
R854 VR.n298 VR.n468 1.2605
R855 VR.n396 VR.n211 1.2605
R856 VR.n232 VR.n395 1.2605
R857 VR.n391 VR.n212 1.2605
R858 VR.n233 VR.n390 1.2605
R859 VR.n520 VR.n213 1.2605
R860 VR.n234 VR.n519 1.2605
R861 VR.n528 VR.n214 1.2605
R862 VR.n235 VR.n527 1.2605
R863 VR.n547 VR.n215 1.2605
R864 VR.n236 VR.n546 1.2605
R865 VR.n552 VR.n216 1.2605
R866 VR.n237 VR.n551 1.2605
R867 VR.n579 VR.n576 1.2605
R868 VR.n575 VR.n572 1.2605
R869 VR.n587 VR.t24 1.2605
R870 VR.n584 VR.t130 1.2605
R871 VR.n623 VR.n287 1.2605
R872 VR.n299 VR.n622 1.2605
R873 VR.n619 VR.n288 1.2605
R874 VR.n300 VR.n618 1.2605
R875 VR.n634 VR.n217 1.2605
R876 VR.n239 VR.n238 1.2605
R877 VR.n629 VR.n218 1.2605
R878 VR.n240 VR.n628 1.2605
R879 VR.n644 VR.n289 1.2605
R880 VR.n301 VR.n643 1.2605
R881 VR.n640 VR.n290 1.2605
R882 VR.n302 VR.n639 1.2605
R883 VR.n655 VR.n219 1.2605
R884 VR.n242 VR.n241 1.2605
R885 VR.n650 VR.n220 1.2605
R886 VR.n243 VR.n649 1.2605
R887 VR.n290 VR.t71 1.25703
R888 VR.n289 VR.t54 1.25703
R889 VR.n288 VR.t275 1.25703
R890 VR.n287 VR.t266 1.25703
R891 VR.n286 VR.t107 1.25703
R892 VR.n285 VR.t312 1.25703
R893 VR.n284 VR.t238 1.25703
R894 VR.n283 VR.t26 1.25703
R895 VR.n282 VR.t21 1.25703
R896 VR.n281 VR.t143 1.25703
R897 VR.n280 VR.t261 1.25703
R898 VR.n279 VR.t305 1.25703
R899 VR.n302 VR.t71 1.25703
R900 VR.n301 VR.t54 1.25703
R901 VR.n300 VR.t275 1.25703
R902 VR.n299 VR.t266 1.25703
R903 VR.n298 VR.t107 1.25703
R904 VR.n297 VR.t312 1.25703
R905 VR.n296 VR.t238 1.25703
R906 VR.n295 VR.t26 1.25703
R907 VR.n294 VR.t21 1.25703
R908 VR.n293 VR.t143 1.25703
R909 VR.n292 VR.t261 1.25703
R910 VR.n291 VR.t305 1.25703
R911 VR.n220 VR.t69 1.25626
R912 VR.n219 VR.t56 1.25626
R913 VR.n218 VR.t279 1.25626
R914 VR.n217 VR.t268 1.25626
R915 VR.n216 VR.t187 1.25626
R916 VR.n215 VR.t205 1.25626
R917 VR.n214 VR.t151 1.25626
R918 VR.n213 VR.t292 1.25626
R919 VR.n212 VR.t318 1.25626
R920 VR.n211 VR.t231 1.25626
R921 VR.n210 VR.t109 1.25626
R922 VR.n209 VR.t146 1.25626
R923 VR.n208 VR.t87 1.25626
R924 VR.n207 VR.t20 1.25626
R925 VR.n206 VR.t133 1.25626
R926 VR.n205 VR.t263 1.25626
R927 VR.n204 VR.t10 1.25626
R928 VR.n203 VR.t163 1.25626
R929 VR.n243 VR.t69 1.25625
R930 VR.n242 VR.t56 1.25625
R931 VR.n240 VR.t279 1.25625
R932 VR.n239 VR.t268 1.25625
R933 VR.n237 VR.t187 1.25625
R934 VR.n236 VR.t205 1.25625
R935 VR.n235 VR.t151 1.25625
R936 VR.n234 VR.t292 1.25625
R937 VR.n233 VR.t318 1.25625
R938 VR.n232 VR.t231 1.25625
R939 VR.n231 VR.t109 1.25625
R940 VR.n230 VR.t146 1.25625
R941 VR.n228 VR.t87 1.25625
R942 VR.n227 VR.t20 1.25625
R943 VR.n225 VR.t133 1.25625
R944 VR.n224 VR.t263 1.25625
R945 VR.n222 VR.t10 1.25625
R946 VR.n221 VR.t163 1.25625
R947 VR.n524 VR.n342 1.2533
R948 VR.n522 VR.n381 1.2533
R949 VR.n320 VR.n345 1.18438
R950 VR.n318 VR.n348 1.18438
R951 VR.n316 VR.n352 1.18438
R952 VR.n314 VR.n355 1.18438
R953 VR.n312 VR.n359 1.18438
R954 VR.n310 VR.n362 1.18438
R955 VR.n308 VR.n366 1.18438
R956 VR.n306 VR.n369 1.18438
R957 VR.n333 VR.n247 1.08627
R958 VR.n333 VR.n32 1.08627
R959 VR.n372 VR.n249 1.08627
R960 VR.n372 VR.n30 1.08627
R961 VR.n383 VR.n251 1.08627
R962 VR.n383 VR.n28 1.08627
R963 VR.n505 VR.n253 1.08627
R964 VR.n505 VR.n26 1.08627
R965 VR.n511 VR.n255 1.08627
R966 VR.n511 VR.n24 1.08627
R967 VR.n531 VR.n265 1.08627
R968 VR.n531 VR.n22 1.08627
R969 VR.n538 VR.n267 1.08627
R970 VR.n538 VR.n20 1.08627
R971 VR.n555 VR.n269 1.08627
R972 VR.n555 VR.n18 1.08627
R973 VR.n591 VR.n271 1.08627
R974 VR.n591 VR.n16 1.08627
R975 VR.n597 VR.n273 1.08627
R976 VR.n597 VR.n14 1.08627
R977 VR.n609 VR.n275 1.08627
R978 VR.n609 VR.n12 1.08627
R979 VR.n603 VR.n277 1.08627
R980 VR.n603 VR.n10 1.08627
R981 VR.n341 VR.n84 1.07819
R982 VR.n341 VR.n86 1.07819
R983 VR.n380 VR.n87 1.07819
R984 VR.n380 VR.n89 1.07819
R985 VR.n439 VR.n435 1.07819
R986 VR.n439 VR.n438 1.07819
R987 VR.n434 VR.n93 1.07819
R988 VR.n434 VR.n95 1.07819
R989 VR.n494 VR.n490 1.07819
R990 VR.n494 VR.n493 1.07819
R991 VR.n489 VR.n111 1.07819
R992 VR.n489 VR.n113 1.07819
R993 VR.n483 VR.n479 1.07819
R994 VR.n483 VR.n482 1.07819
R995 VR.n478 VR.n114 1.07819
R996 VR.n478 VR.n116 1.07819
R997 VR.n396 VR.n123 1.07819
R998 VR.n396 VR.n125 1.07819
R999 VR.n391 VR.n126 1.07819
R1000 VR.n391 VR.n128 1.07819
R1001 VR.n520 VR.n129 1.07819
R1002 VR.n520 VR.n131 1.07819
R1003 VR.n528 VR.n156 1.07819
R1004 VR.n528 VR.n158 1.07819
R1005 VR.n547 VR.n159 1.07819
R1006 VR.n547 VR.n161 1.07819
R1007 VR.n552 VR.n162 1.07819
R1008 VR.n552 VR.n164 1.07819
R1009 VR.n634 VR.n630 1.07819
R1010 VR.n634 VR.n633 1.07819
R1011 VR.n629 VR.n183 1.07819
R1012 VR.n629 VR.n185 1.07819
R1013 VR.n655 VR.n651 1.07819
R1014 VR.n655 VR.n654 1.07819
R1015 VR.n650 VR.n192 1.07819
R1016 VR.n650 VR.n194 1.07819
R1017 VR.n223 VR.n435 1.07704
R1018 VR.n438 VR.n223 1.07704
R1019 VR.n226 VR.n490 1.07704
R1020 VR.n493 VR.n226 1.07704
R1021 VR.n229 VR.n479 1.07704
R1022 VR.n482 VR.n229 1.07704
R1023 VR.n238 VR.n630 1.07704
R1024 VR.n633 VR.n238 1.07704
R1025 VR.n241 VR.n651 1.07704
R1026 VR.n654 VR.n241 1.07704
R1027 VR.n370 VR.t159 1.0505
R1028 VR.n367 VR.t147 1.0505
R1029 VR.n363 VR.t12 1.0505
R1030 VR.n360 VR.t290 1.0505
R1031 VR.n356 VR.t189 1.0505
R1032 VR.n353 VR.t207 1.0505
R1033 VR.n349 VR.t225 1.0505
R1034 VR.n346 VR.t320 1.0505
R1035 VR.n321 VR.t320 0.969814
R1036 VR.n319 VR.t225 0.969814
R1037 VR.n317 VR.t207 0.969814
R1038 VR.n315 VR.t189 0.969814
R1039 VR.n313 VR.t290 0.969814
R1040 VR.n311 VR.t12 0.969814
R1041 VR.n309 VR.t147 0.969814
R1042 VR.n307 VR.t159 0.969814
R1043 VR.n370 VR.n132 0.958192
R1044 VR.n370 VR.n134 0.958192
R1045 VR.n367 VR.n135 0.958192
R1046 VR.n367 VR.n137 0.958192
R1047 VR.n363 VR.n138 0.958192
R1048 VR.n363 VR.n140 0.958192
R1049 VR.n360 VR.n141 0.958192
R1050 VR.n360 VR.n143 0.958192
R1051 VR.n356 VR.n144 0.958192
R1052 VR.n356 VR.n146 0.958192
R1053 VR.n353 VR.n147 0.958192
R1054 VR.n353 VR.n149 0.958192
R1055 VR.n349 VR.n150 0.958192
R1056 VR.n349 VR.n152 0.958192
R1057 VR.n346 VR.n153 0.958192
R1058 VR.n346 VR.n155 0.958192
R1059 VR.n345 VR.n153 0.957038
R1060 VR.n348 VR.n150 0.957038
R1061 VR.n352 VR.n147 0.957038
R1062 VR.n355 VR.n144 0.957038
R1063 VR.n359 VR.n141 0.957038
R1064 VR.n362 VR.n138 0.957038
R1065 VR.n366 VR.n135 0.957038
R1066 VR.n369 VR.n132 0.957038
R1067 VR.n502 VR.n90 0.916654
R1068 VR.n502 VR.n92 0.916654
R1069 VR.n448 VR.n96 0.916654
R1070 VR.n448 VR.n98 0.916654
R1071 VR.n444 VR.n99 0.916654
R1072 VR.n444 VR.n101 0.916654
R1073 VR.n454 VR.n102 0.916654
R1074 VR.n454 VR.n104 0.916654
R1075 VR.n463 VR.n105 0.916654
R1076 VR.n463 VR.n107 0.916654
R1077 VR.n459 VR.n108 0.916654
R1078 VR.n459 VR.n110 0.916654
R1079 VR.n473 VR.n117 0.916654
R1080 VR.n473 VR.n119 0.916654
R1081 VR.n469 VR.n120 0.916654
R1082 VR.n469 VR.n122 0.916654
R1083 VR.n623 VR.n177 0.916654
R1084 VR.n623 VR.n179 0.916654
R1085 VR.n619 VR.n180 0.916654
R1086 VR.n619 VR.n182 0.916654
R1087 VR.n644 VR.n186 0.916654
R1088 VR.n644 VR.n188 0.916654
R1089 VR.n640 VR.n189 0.916654
R1090 VR.n640 VR.n191 0.916654
R1091 VR.n428 VR.n427 0.872643
R1092 VR.n413 VR.n412 0.872643
R1093 VR.n191 VR.n190 0.844381
R1094 VR.n637 VR.n189 0.844381
R1095 VR.n188 VR.n187 0.844381
R1096 VR.n641 VR.n186 0.844381
R1097 VR.n182 VR.n181 0.844381
R1098 VR.n616 VR.n180 0.844381
R1099 VR.n179 VR.n178 0.844381
R1100 VR.n620 VR.n177 0.844381
R1101 VR.n155 VR.n154 0.844381
R1102 VR.n152 VR.n151 0.844381
R1103 VR.n149 VR.n148 0.844381
R1104 VR.n146 VR.n145 0.844381
R1105 VR.n143 VR.n142 0.844381
R1106 VR.n140 VR.n139 0.844381
R1107 VR.n137 VR.n136 0.844381
R1108 VR.n134 VR.n133 0.844381
R1109 VR.n122 VR.n121 0.844381
R1110 VR.n466 VR.n120 0.844381
R1111 VR.n119 VR.n118 0.844381
R1112 VR.n470 VR.n117 0.844381
R1113 VR.n110 VR.n109 0.844381
R1114 VR.n456 VR.n108 0.844381
R1115 VR.n107 VR.n106 0.844381
R1116 VR.n460 VR.n105 0.844381
R1117 VR.n104 VR.n103 0.844381
R1118 VR.n451 VR.n102 0.844381
R1119 VR.n101 VR.n100 0.844381
R1120 VR.n441 VR.n99 0.844381
R1121 VR.n98 VR.n97 0.844381
R1122 VR.n445 VR.n96 0.844381
R1123 VR.n92 VR.n91 0.844381
R1124 VR.n499 VR.n90 0.844381
R1125 VR.n503 VR.n498 0.822492
R1126 VR.n340 VR.n84 0.805885
R1127 VR.n340 VR.n86 0.805885
R1128 VR.n379 VR.n87 0.805885
R1129 VR.n379 VR.n89 0.805885
R1130 VR.n433 VR.n93 0.805885
R1131 VR.n433 VR.n95 0.805885
R1132 VR.n488 VR.n111 0.805885
R1133 VR.n488 VR.n113 0.805885
R1134 VR.n477 VR.n114 0.805885
R1135 VR.n477 VR.n116 0.805885
R1136 VR.n395 VR.n123 0.805885
R1137 VR.n395 VR.n125 0.805885
R1138 VR.n390 VR.n126 0.805885
R1139 VR.n390 VR.n128 0.805885
R1140 VR.n519 VR.n129 0.805885
R1141 VR.n519 VR.n131 0.805885
R1142 VR.n527 VR.n156 0.805885
R1143 VR.n527 VR.n158 0.805885
R1144 VR.n546 VR.n159 0.805885
R1145 VR.n546 VR.n161 0.805885
R1146 VR.n551 VR.n162 0.805885
R1147 VR.n551 VR.n164 0.805885
R1148 VR.n628 VR.n183 0.805885
R1149 VR.n628 VR.n185 0.805885
R1150 VR.n649 VR.n192 0.805885
R1151 VR.n649 VR.n194 0.805885
R1152 VR.n197 VR.n196 0.781571
R1153 VR.n63 VR.n62 0.781571
R1154 VR.n571 VR.n570 0.7505
R1155 VR.n498 VR.n497 0.7505
R1156 VR.n245 VR.n195 0.748625
R1157 VR.n194 VR.n193 0.721654
R1158 VR.n647 VR.n192 0.721654
R1159 VR.n185 VR.n184 0.721654
R1160 VR.n626 VR.n183 0.721654
R1161 VR.n164 VR.n163 0.721654
R1162 VR.n549 VR.n162 0.721654
R1163 VR.n161 VR.n160 0.721654
R1164 VR.n544 VR.n159 0.721654
R1165 VR.n158 VR.n157 0.721654
R1166 VR.n525 VR.n156 0.721654
R1167 VR.n131 VR.n130 0.721654
R1168 VR.n517 VR.n129 0.721654
R1169 VR.n128 VR.n127 0.721654
R1170 VR.n388 VR.n126 0.721654
R1171 VR.n125 VR.n124 0.721654
R1172 VR.n393 VR.n123 0.721654
R1173 VR.n116 VR.n115 0.721654
R1174 VR.n475 VR.n114 0.721654
R1175 VR.n113 VR.n112 0.721654
R1176 VR.n486 VR.n111 0.721654
R1177 VR.n95 VR.n94 0.721654
R1178 VR.n431 VR.n93 0.721654
R1179 VR.n89 VR.n88 0.721654
R1180 VR.n377 VR.n87 0.721654
R1181 VR.n86 VR.n85 0.721654
R1182 VR.n338 VR.n84 0.721654
R1183 VR.n10 VR.n278 0.715885
R1184 VR.n605 VR.n277 0.715885
R1185 VR.n12 VR.n276 0.715885
R1186 VR.n611 VR.n275 0.715885
R1187 VR.n14 VR.n274 0.715885
R1188 VR.n599 VR.n273 0.715885
R1189 VR.n16 VR.n272 0.715885
R1190 VR.n593 VR.n271 0.715885
R1191 VR.n18 VR.n270 0.715885
R1192 VR.n557 VR.n269 0.715885
R1193 VR.n20 VR.n268 0.715885
R1194 VR.n540 VR.n267 0.715885
R1195 VR.n22 VR.n266 0.715885
R1196 VR.n533 VR.n265 0.715885
R1197 VR.n2 VR.n70 0.0130936
R1198 VR.n71 VR.n263 0.0130936
R1199 VR.n4 VR.n68 0.0130936
R1200 VR.n69 VR.n261 0.0130936
R1201 VR.n6 VR.n66 0.0130936
R1202 VR.n67 VR.n259 0.0130936
R1203 VR.n8 VR.n64 0.0130936
R1204 VR.n65 VR.n257 0.0130936
R1205 VR.n24 VR.n256 0.715885
R1206 VR.n513 VR.n255 0.715885
R1207 VR.n26 VR.n254 0.715885
R1208 VR.n507 VR.n253 0.715885
R1209 VR.n28 VR.n252 0.715885
R1210 VR.n385 VR.n251 0.715885
R1211 VR.n30 VR.n250 0.715885
R1212 VR.n374 VR.n249 0.715885
R1213 VR.n32 VR.n248 0.715885
R1214 VR.n335 VR.n247 0.715885
R1215 VR.n423 VR.n422 0.694786
R1216 VR.n424 VR.n423 0.694786
R1217 VR.n425 VR.n424 0.694786
R1218 VR.n426 VR.n425 0.694786
R1219 VR.n427 VR.n426 0.694786
R1220 VR.n419 VR.n418 0.694786
R1221 VR.n418 VR.n417 0.694786
R1222 VR.n417 VR.n416 0.694786
R1223 VR.n416 VR.n415 0.694786
R1224 VR.n415 VR.n414 0.694786
R1225 VR.n408 VR.n407 0.694786
R1226 VR.n409 VR.n408 0.694786
R1227 VR.n410 VR.n409 0.694786
R1228 VR.n411 VR.n410 0.694786
R1229 VR.n412 VR.n411 0.694786
R1230 VR.n404 VR.n403 0.694786
R1231 VR.n403 VR.n402 0.694786
R1232 VR.n402 VR.n401 0.694786
R1233 VR.n401 VR.n400 0.694786
R1234 VR.n400 VR.n399 0.694786
R1235 VR.n369 VR.n134 0.685885
R1236 VR.n366 VR.n137 0.685885
R1237 VR.n362 VR.n140 0.685885
R1238 VR.n359 VR.n143 0.685885
R1239 VR.n355 VR.n146 0.685885
R1240 VR.n352 VR.n149 0.685885
R1241 VR.n348 VR.n152 0.685885
R1242 VR.n345 VR.n155 0.685885
R1243 VR.n501 VR.n90 0.644346
R1244 VR.n501 VR.n92 0.644346
R1245 VR.n447 VR.n96 0.644346
R1246 VR.n447 VR.n98 0.644346
R1247 VR.n443 VR.n99 0.644346
R1248 VR.n443 VR.n101 0.644346
R1249 VR.n453 VR.n102 0.644346
R1250 VR.n453 VR.n104 0.644346
R1251 VR.n462 VR.n105 0.644346
R1252 VR.n462 VR.n107 0.644346
R1253 VR.n458 VR.n108 0.644346
R1254 VR.n458 VR.n110 0.644346
R1255 VR.n472 VR.n117 0.644346
R1256 VR.n472 VR.n119 0.644346
R1257 VR.n468 VR.n120 0.644346
R1258 VR.n468 VR.n122 0.644346
R1259 VR.n622 VR.n177 0.644346
R1260 VR.n622 VR.n179 0.644346
R1261 VR.n618 VR.n180 0.644346
R1262 VR.n618 VR.n182 0.644346
R1263 VR.n643 VR.n186 0.644346
R1264 VR.n643 VR.n188 0.644346
R1265 VR.n639 VR.n189 0.644346
R1266 VR.n639 VR.n191 0.644346
R1267 VR.n336 VR.n332 0.6305
R1268 VR.n337 VR.n332 0.6305
R1269 VR.n336 VR.n334 0.6305
R1270 VR.n334 VR.n333 0.6305
R1271 VR.n375 VR.n371 0.6305
R1272 VR.n376 VR.n371 0.6305
R1273 VR.n375 VR.n373 0.6305
R1274 VR.n373 VR.n372 0.6305
R1275 VR.n386 VR.n382 0.6305
R1276 VR.n387 VR.n382 0.6305
R1277 VR.n386 VR.n384 0.6305
R1278 VR.n384 VR.n383 0.6305
R1279 VR.n508 VR.n504 0.6305
R1280 VR.n509 VR.n504 0.6305
R1281 VR.n508 VR.n506 0.6305
R1282 VR.n506 VR.n505 0.6305
R1283 VR.n514 VR.n510 0.6305
R1284 VR.n515 VR.n510 0.6305
R1285 VR.n514 VR.n512 0.6305
R1286 VR.n512 VR.n511 0.6305
R1287 VR.n534 VR.n530 0.6305
R1288 VR.n535 VR.n530 0.6305
R1289 VR.n534 VR.n532 0.6305
R1290 VR.n532 VR.n531 0.6305
R1291 VR.n541 VR.n537 0.6305
R1292 VR.n542 VR.n537 0.6305
R1293 VR.n541 VR.n539 0.6305
R1294 VR.n539 VR.n538 0.6305
R1295 VR.n558 VR.n554 0.6305
R1296 VR.n559 VR.n554 0.6305
R1297 VR.n558 VR.n556 0.6305
R1298 VR.n556 VR.n555 0.6305
R1299 VR.n594 VR.n590 0.6305
R1300 VR.n595 VR.n590 0.6305
R1301 VR.n594 VR.n592 0.6305
R1302 VR.n592 VR.n591 0.6305
R1303 VR.n600 VR.n596 0.6305
R1304 VR.n601 VR.n596 0.6305
R1305 VR.n600 VR.n598 0.6305
R1306 VR.n598 VR.n597 0.6305
R1307 VR.n612 VR.n608 0.6305
R1308 VR.n613 VR.n608 0.6305
R1309 VR.n612 VR.n610 0.6305
R1310 VR.n610 VR.n609 0.6305
R1311 VR.n606 VR.n602 0.6305
R1312 VR.n607 VR.n602 0.6305
R1313 VR.n606 VR.n604 0.6305
R1314 VR.n604 VR.n603 0.6305
R1315 VR.t272 VR.t270 0.618833
R1316 VR.t84 VR.t82 0.618833
R1317 VR.t140 VR.t138 0.618833
R1318 VR.t258 VR.t256 0.618833
R1319 VR.t102 VR.t104 0.618833
R1320 VR.t17 VR.t15 0.618833
R1321 VR.t299 VR.t297 0.618833
R1322 VR.t230 VR.t228 0.618833
R1323 VR.t325 VR.t323 0.618833
R1324 VR.t168 VR.t166 0.618833
R1325 VR.t156 VR.t154 0.618833
R1326 VR.t214 VR.t212 0.618833
R1327 VR.t196 VR.t194 0.618833
R1328 VR.t284 VR.t282 0.618833
R1329 VR.t62 VR.t60 0.618833
R1330 VR.t68 VR.t74 0.618833
R1331 VR.t248 VR.t246 0.618833
R1332 VR.t44 VR.t42 0.618833
R1333 VR.t5 VR.t3 0.618833
R1334 VR.t36 VR.t34 0.618833
R1335 VR.n588 VR.n202 0.600537
R1336 VR.n580 VR.n201 0.600537
R1337 VR.n569 VR.n200 0.600537
R1338 VR.n331 VR.n199 0.600537
R1339 VR.t329 VR.t328 0.581451
R1340 VR.n430 VR.n429 0.5603
R1341 VR.n176 VR.n175 0.545567
R1342 VR.n173 VR.n172 0.545567
R1343 VR.n170 VR.n169 0.545567
R1344 VR.n167 VR.n166 0.545567
R1345 VR.n83 VR.n82 0.545567
R1346 VR.n80 VR.n79 0.545567
R1347 VR.n77 VR.n76 0.545567
R1348 VR.n74 VR.n73 0.545567
R1349 VR.n198 VR.n197 0.521214
R1350 VR.n428 VR.n421 0.516929
R1351 VR.n413 VR.n406 0.516929
R1352 VR.n246 VR.n198 0.488268
R1353 VR.n436 VR.n435 0.4505
R1354 VR.n438 VR.n437 0.4505
R1355 VR.n491 VR.n490 0.4505
R1356 VR.n493 VR.n492 0.4505
R1357 VR.n480 VR.n479 0.4505
R1358 VR.n482 VR.n481 0.4505
R1359 VR.n631 VR.n630 0.4505
R1360 VR.n633 VR.n632 0.4505
R1361 VR.n652 VR.n651 0.4505
R1362 VR.n654 VR.n653 0.4505
R1363 VR.t97 VR.n331 5.14998
R1364 VR.t310 VR.n199 3.52086
R1365 VR.t29 VR.n327 0.434144
R1366 VR.t50 VR.n323 0.434144
R1367 VR.t145 VR.n569 5.14998
R1368 VR.t111 VR.n200 3.52086
R1369 VR.t314 VR.n565 0.434144
R1370 VR.t48 VR.n561 0.434144
R1371 VR.t23 VR.n580 5.14998
R1372 VR.t240 VR.n201 3.52086
R1373 VR.t203 VR.n576 0.434144
R1374 VR.t288 VR.n572 0.434144
R1375 VR.t202 VR.n588 5.14998
R1376 VR.t28 VR.n202 3.52086
R1377 VR.n196 VR.t123 3.14483
R1378 VR.n195 VR.t96 3.08809
R1379 VR.n62 VR.t78 3.08809
R1380 VR.n246 VR.t132 3.0476
R1381 VR.n246 VR.t220 3.01465
R1382 VR.n246 VR.t219 3.01465
R1383 VR.n198 VR.t311 3.01465
R1384 VR.n198 VR.t53 3.01465
R1385 VR.n198 VR.t52 3.01465
R1386 VR.n198 VR.t178 3.01465
R1387 VR.n197 VR.t237 3.01465
R1388 VR.n197 VR.t114 3.01465
R1389 VR.n197 VR.t113 3.01465
R1390 VR.n197 VR.t185 3.01465
R1391 VR.n196 VR.t119 3.01465
R1392 VR.n196 VR.t118 3.01465
R1393 VR.n196 VR.t175 3.01465
R1394 VR.n196 VR.t124 3.01465
R1395 VR.n245 VR.t89 2.99086
R1396 VR.n322 VR.t242 2.99086
R1397 VR.n245 VR.t90 2.95791
R1398 VR.n245 VR.t91 2.95791
R1399 VR.n195 VR.t92 2.95791
R1400 VR.n195 VR.t93 2.95791
R1401 VR.n195 VR.t94 2.95791
R1402 VR.n195 VR.t95 2.95791
R1403 VR.n322 VR.t241 2.95791
R1404 VR.n63 VR.t251 2.95791
R1405 VR.n63 VR.t252 2.95791
R1406 VR.n63 VR.t172 2.95791
R1407 VR.n63 VR.t171 2.95791
R1408 VR.n63 VR.t217 2.95791
R1409 VR.n63 VR.t177 2.95791
R1410 VR.n63 VR.t176 2.95791
R1411 VR.n63 VR.t201 2.95791
R1412 VR.n63 VR.t200 2.95791
R1413 VR.n62 VR.t218 2.95791
R1414 VR.n62 VR.t115 2.95791
R1415 VR.n62 VR.t235 2.95791
R1416 VR.n62 VR.t47 2.95791
R1417 VR.n58 VR.n9 1.88621
R1418 VR.n59 VR.n7 1.88621
R1419 VR.n60 VR.n5 1.88621
R1420 VR.n61 VR.n3 1.88621
R1421 VR.n56 VR.n583 1.69393
R1422 VR.n54 VR.n586 1.69393
R1423 VR.n52 VR.n574 1.69393
R1424 VR.n50 VR.n578 1.69393
R1425 VR.n48 VR.n563 1.69393
R1426 VR.n46 VR.n567 1.69393
R1427 VR.n44 VR.n325 1.69393
R1428 VR.n42 VR.n329 1.69393
R1429 VR.n244 VR.n0 1.52322
R1430 VR.n0 VR.n1 1.50732
R1431 VR.n41 VR.n40 1.09615
R1432 VR.n39 VR.n38 1.09615
R1433 VR.n37 VR.n36 1.09615
R1434 VR.n35 VR.n34 1.09615
R1435 VR.n57 VR.t130 1.0743
R1436 VR.n55 VR.t24 1.0743
R1437 VR.n322 VR.n63 1.00898
R1438 a_18109_11960.n14 a_18109_11960.n13 32.0765
R1439 a_18109_11960.n13 a_18109_11960.n1 6.5765
R1440 a_18109_11960.t16 a_18109_11960.n14 6.3665
R1441 a_18109_11960.n4 a_18109_11960.t56 5.74913
R1442 a_18109_11960.n6 a_18109_11960.t4 5.74913
R1443 a_18109_11960.t0 a_18109_11960.t7 5.71479
R1444 a_18109_11960.n4 a_18109_11960.t22 5.05484
R1445 a_18109_11960.n5 a_18109_11960.t34 5.05484
R1446 a_18109_11960.n5 a_18109_11960.t46 5.05484
R1447 a_18109_11960.n5 a_18109_11960.t8 5.05484
R1448 a_18109_11960.n8 a_18109_11960.t21 5.05484
R1449 a_18109_11960.n12 a_18109_11960.t54 5.05484
R1450 a_18109_11960.n9 a_18109_11960.t33 5.05484
R1451 a_18109_11960.n9 a_18109_11960.t55 5.05484
R1452 a_18109_11960.n11 a_18109_11960.t36 5.05484
R1453 a_18109_11960.n10 a_18109_11960.t41 5.05484
R1454 a_18109_11960.n7 a_18109_11960.t27 5.05484
R1455 a_18109_11960.n7 a_18109_11960.t45 5.05484
R1456 a_18109_11960.n6 a_18109_11960.t19 5.05484
R1457 a_18109_11960.n6 a_18109_11960.t44 5.05484
R1458 a_18109_11960.n14 a_18109_11960.n5 4.6865
R1459 a_18109_11960.n13 a_18109_11960.n3 4.5005
R1460 a_18109_11960.n0 a_18109_11960.t5 3.45909
R1461 a_18109_11960.n2 a_18109_11960.t17 3.40313
R1462 a_18109_11960.n1 a_18109_11960.t49 3.3707
R1463 a_18109_11960.n3 a_18109_11960.t24 3.31473
R1464 a_18109_11960.n1 a_18109_11960.t48 2.95791
R1465 a_18109_11960.n1 a_18109_11960.t51 2.95791
R1466 a_18109_11960.n1 a_18109_11960.t50 2.95791
R1467 a_18109_11960.n1 a_18109_11960.t52 2.95791
R1468 a_18109_11960.n1 a_18109_11960.t26 2.95791
R1469 a_18109_11960.n1 a_18109_11960.t25 2.95791
R1470 a_18109_11960.n1 a_18109_11960.t40 2.95791
R1471 a_18109_11960.n1 a_18109_11960.t30 2.95791
R1472 a_18109_11960.n1 a_18109_11960.t29 2.95791
R1473 a_18109_11960.n0 a_18109_11960.t39 2.95791
R1474 a_18109_11960.n0 a_18109_11960.t42 2.95791
R1475 a_18109_11960.n0 a_18109_11960.t11 2.95791
R1476 a_18109_11960.n0 a_18109_11960.t53 2.95791
R1477 a_18109_11960.n0 a_18109_11960.t1 2.95791
R1478 a_18109_11960.n0 a_18109_11960.t20 2.95791
R1479 a_18109_11960.n3 a_18109_11960.t23 2.90195
R1480 a_18109_11960.n3 a_18109_11960.t43 2.90195
R1481 a_18109_11960.n3 a_18109_11960.t58 2.90195
R1482 a_18109_11960.n3 a_18109_11960.t3 2.90195
R1483 a_18109_11960.n3 a_18109_11960.t2 2.90195
R1484 a_18109_11960.n3 a_18109_11960.t32 2.90195
R1485 a_18109_11960.n3 a_18109_11960.t31 2.90195
R1486 a_18109_11960.n3 a_18109_11960.t47 2.90195
R1487 a_18109_11960.n3 a_18109_11960.t10 2.90195
R1488 a_18109_11960.n2 a_18109_11960.t9 2.90195
R1489 a_18109_11960.n2 a_18109_11960.t37 2.90195
R1490 a_18109_11960.n2 a_18109_11960.t15 2.90195
R1491 a_18109_11960.n2 a_18109_11960.t14 2.90195
R1492 a_18109_11960.n2 a_18109_11960.t28 2.90195
R1493 a_18109_11960.n2 a_18109_11960.t18 2.90195
R1494 a_18109_11960.n3 a_18109_11960.n2 1.91139
R1495 a_18109_11960.n1 a_18109_11960.n0 1.91139
R1496 a_18109_11960.n12 a_18109_11960.n9 1.73621
R1497 a_18109_11960.t57 a_18109_11960.t6 1.73621
R1498 a_18109_11960.t6 a_18109_11960.t35 1.38907
R1499 a_18109_11960.n9 a_18109_11960.n11 1.38907
R1500 a_18109_11960.t7 a_18109_11960.t12 1.38907
R1501 a_18109_11960.t12 a_18109_11960.t38 1.38907
R1502 a_18109_11960.n5 a_18109_11960.n8 1.38907
R1503 a_18109_11960.n7 a_18109_11960.n6 1.38907
R1504 a_18109_11960.n10 a_18109_11960.n7 1.38907
R1505 a_18109_11960.n5 a_18109_11960.n4 1.38907
R1506 a_18109_11960.t35 a_18109_11960.t13 1.04193
R1507 a_18109_11960.t38 a_18109_11960.t57 1.04193
R1508 a_18109_11960.n8 a_18109_11960.n12 1.04193
R1509 a_18109_11960.n11 a_18109_11960.n10 1.04193
R1510 a_18109_11960.t13 a_18109_11960.t16 1.03121
R1511 a_17709_13109.n0 a_17709_13109.t85 99.9768
R1512 a_17709_13109.n37 a_17709_13109.t156 99.9768
R1513 a_17709_13109.n76 a_17709_13109.t13 96.1964
R1514 a_17709_13109.n113 a_17709_13109.t84 96.1964
R1515 a_17709_13109.n0 a_17709_13109.t86 88.3826
R1516 a_17709_13109.n1 a_17709_13109.t87 88.3826
R1517 a_17709_13109.n2 a_17709_13109.t88 88.3826
R1518 a_17709_13109.n3 a_17709_13109.t89 88.3826
R1519 a_17709_13109.n4 a_17709_13109.t90 88.3826
R1520 a_17709_13109.n5 a_17709_13109.t91 88.3826
R1521 a_17709_13109.n6 a_17709_13109.t92 88.3826
R1522 a_17709_13109.n7 a_17709_13109.t93 88.3826
R1523 a_17709_13109.n8 a_17709_13109.t94 88.3826
R1524 a_17709_13109.n9 a_17709_13109.t95 88.3826
R1525 a_17709_13109.n10 a_17709_13109.t96 88.3826
R1526 a_17709_13109.n11 a_17709_13109.t97 88.3826
R1527 a_17709_13109.n12 a_17709_13109.t98 88.3826
R1528 a_17709_13109.n13 a_17709_13109.t99 88.3826
R1529 a_17709_13109.n14 a_17709_13109.t100 88.3826
R1530 a_17709_13109.n15 a_17709_13109.t101 88.3826
R1531 a_17709_13109.n16 a_17709_13109.t102 88.3826
R1532 a_17709_13109.n17 a_17709_13109.t103 88.3826
R1533 a_17709_13109.n18 a_17709_13109.t104 88.3826
R1534 a_17709_13109.n19 a_17709_13109.t105 88.3826
R1535 a_17709_13109.n20 a_17709_13109.t106 88.3826
R1536 a_17709_13109.n21 a_17709_13109.t107 88.3826
R1537 a_17709_13109.n22 a_17709_13109.t108 88.3826
R1538 a_17709_13109.n23 a_17709_13109.t109 88.3826
R1539 a_17709_13109.n24 a_17709_13109.t110 88.3826
R1540 a_17709_13109.n25 a_17709_13109.t111 88.3826
R1541 a_17709_13109.n26 a_17709_13109.t112 88.3826
R1542 a_17709_13109.n27 a_17709_13109.t113 88.3826
R1543 a_17709_13109.n28 a_17709_13109.t114 88.3826
R1544 a_17709_13109.n29 a_17709_13109.t4 88.3826
R1545 a_17709_13109.n30 a_17709_13109.t3 88.3826
R1546 a_17709_13109.n31 a_17709_13109.t115 88.3826
R1547 a_17709_13109.n32 a_17709_13109.t116 88.3826
R1548 a_17709_13109.n33 a_17709_13109.t117 88.3826
R1549 a_17709_13109.n34 a_17709_13109.t118 88.3826
R1550 a_17709_13109.n35 a_17709_13109.t119 88.3826
R1551 a_17709_13109.n36 a_17709_13109.t120 88.3826
R1552 a_17709_13109.n73 a_17709_13109.t121 88.3826
R1553 a_17709_13109.n72 a_17709_13109.t122 88.3826
R1554 a_17709_13109.n71 a_17709_13109.t123 88.3826
R1555 a_17709_13109.n70 a_17709_13109.t124 88.3826
R1556 a_17709_13109.n69 a_17709_13109.t125 88.3826
R1557 a_17709_13109.n68 a_17709_13109.t126 88.3826
R1558 a_17709_13109.n67 a_17709_13109.t2 88.3826
R1559 a_17709_13109.n66 a_17709_13109.t0 88.3826
R1560 a_17709_13109.n65 a_17709_13109.t127 88.3826
R1561 a_17709_13109.n64 a_17709_13109.t128 88.3826
R1562 a_17709_13109.n63 a_17709_13109.t129 88.3826
R1563 a_17709_13109.n62 a_17709_13109.t130 88.3826
R1564 a_17709_13109.n61 a_17709_13109.t131 88.3826
R1565 a_17709_13109.n60 a_17709_13109.t132 88.3826
R1566 a_17709_13109.n59 a_17709_13109.t133 88.3826
R1567 a_17709_13109.n58 a_17709_13109.t134 88.3826
R1568 a_17709_13109.n57 a_17709_13109.t135 88.3826
R1569 a_17709_13109.n56 a_17709_13109.t136 88.3826
R1570 a_17709_13109.n55 a_17709_13109.t137 88.3826
R1571 a_17709_13109.n54 a_17709_13109.t138 88.3826
R1572 a_17709_13109.n53 a_17709_13109.t139 88.3826
R1573 a_17709_13109.n52 a_17709_13109.t140 88.3826
R1574 a_17709_13109.n51 a_17709_13109.t141 88.3826
R1575 a_17709_13109.n50 a_17709_13109.t142 88.3826
R1576 a_17709_13109.n49 a_17709_13109.t143 88.3826
R1577 a_17709_13109.n48 a_17709_13109.t144 88.3826
R1578 a_17709_13109.n47 a_17709_13109.t145 88.3826
R1579 a_17709_13109.n46 a_17709_13109.t146 88.3826
R1580 a_17709_13109.n45 a_17709_13109.t147 88.3826
R1581 a_17709_13109.n44 a_17709_13109.t148 88.3826
R1582 a_17709_13109.n43 a_17709_13109.t149 88.3826
R1583 a_17709_13109.n42 a_17709_13109.t150 88.3826
R1584 a_17709_13109.n41 a_17709_13109.t151 88.3826
R1585 a_17709_13109.n40 a_17709_13109.t152 88.3826
R1586 a_17709_13109.n39 a_17709_13109.t153 88.3826
R1587 a_17709_13109.n38 a_17709_13109.t154 88.3826
R1588 a_17709_13109.n37 a_17709_13109.t155 88.3826
R1589 a_17709_13109.n76 a_17709_13109.t14 84.6023
R1590 a_17709_13109.n77 a_17709_13109.t15 84.6023
R1591 a_17709_13109.n78 a_17709_13109.t16 84.6023
R1592 a_17709_13109.n79 a_17709_13109.t17 84.6023
R1593 a_17709_13109.n80 a_17709_13109.t18 84.6023
R1594 a_17709_13109.n81 a_17709_13109.t19 84.6023
R1595 a_17709_13109.n82 a_17709_13109.t20 84.6023
R1596 a_17709_13109.n83 a_17709_13109.t21 84.6023
R1597 a_17709_13109.n84 a_17709_13109.t22 84.6023
R1598 a_17709_13109.n85 a_17709_13109.t23 84.6023
R1599 a_17709_13109.n86 a_17709_13109.t24 84.6023
R1600 a_17709_13109.n87 a_17709_13109.t25 84.6023
R1601 a_17709_13109.n88 a_17709_13109.t26 84.6023
R1602 a_17709_13109.n89 a_17709_13109.t27 84.6023
R1603 a_17709_13109.n90 a_17709_13109.t28 84.6023
R1604 a_17709_13109.n91 a_17709_13109.t29 84.6023
R1605 a_17709_13109.n92 a_17709_13109.t30 84.6023
R1606 a_17709_13109.n93 a_17709_13109.t31 84.6023
R1607 a_17709_13109.n94 a_17709_13109.t32 84.6023
R1608 a_17709_13109.n95 a_17709_13109.t33 84.6023
R1609 a_17709_13109.n96 a_17709_13109.t34 84.6023
R1610 a_17709_13109.n97 a_17709_13109.t35 84.6023
R1611 a_17709_13109.n98 a_17709_13109.t36 84.6023
R1612 a_17709_13109.n99 a_17709_13109.t37 84.6023
R1613 a_17709_13109.n100 a_17709_13109.t38 84.6023
R1614 a_17709_13109.n101 a_17709_13109.t39 84.6023
R1615 a_17709_13109.n102 a_17709_13109.t40 84.6023
R1616 a_17709_13109.n103 a_17709_13109.t41 84.6023
R1617 a_17709_13109.n104 a_17709_13109.t42 84.6023
R1618 a_17709_13109.n105 a_17709_13109.t10 84.6023
R1619 a_17709_13109.n106 a_17709_13109.t8 84.6023
R1620 a_17709_13109.n107 a_17709_13109.t43 84.6023
R1621 a_17709_13109.n108 a_17709_13109.t44 84.6023
R1622 a_17709_13109.n109 a_17709_13109.t45 84.6023
R1623 a_17709_13109.n110 a_17709_13109.t46 84.6023
R1624 a_17709_13109.n111 a_17709_13109.t47 84.6023
R1625 a_17709_13109.n112 a_17709_13109.t48 84.6023
R1626 a_17709_13109.n149 a_17709_13109.t49 84.6023
R1627 a_17709_13109.n148 a_17709_13109.t50 84.6023
R1628 a_17709_13109.n147 a_17709_13109.t51 84.6023
R1629 a_17709_13109.n146 a_17709_13109.t52 84.6023
R1630 a_17709_13109.n145 a_17709_13109.t53 84.6023
R1631 a_17709_13109.n144 a_17709_13109.t54 84.6023
R1632 a_17709_13109.n143 a_17709_13109.t7 84.6023
R1633 a_17709_13109.n142 a_17709_13109.t5 84.6023
R1634 a_17709_13109.n141 a_17709_13109.t55 84.6023
R1635 a_17709_13109.n140 a_17709_13109.t56 84.6023
R1636 a_17709_13109.n139 a_17709_13109.t57 84.6023
R1637 a_17709_13109.n138 a_17709_13109.t58 84.6023
R1638 a_17709_13109.n137 a_17709_13109.t59 84.6023
R1639 a_17709_13109.n136 a_17709_13109.t60 84.6023
R1640 a_17709_13109.n135 a_17709_13109.t61 84.6023
R1641 a_17709_13109.n134 a_17709_13109.t62 84.6023
R1642 a_17709_13109.n133 a_17709_13109.t63 84.6023
R1643 a_17709_13109.n132 a_17709_13109.t64 84.6023
R1644 a_17709_13109.n131 a_17709_13109.t65 84.6023
R1645 a_17709_13109.n130 a_17709_13109.t66 84.6023
R1646 a_17709_13109.n129 a_17709_13109.t67 84.6023
R1647 a_17709_13109.n128 a_17709_13109.t68 84.6023
R1648 a_17709_13109.n127 a_17709_13109.t69 84.6023
R1649 a_17709_13109.n126 a_17709_13109.t70 84.6023
R1650 a_17709_13109.n125 a_17709_13109.t71 84.6023
R1651 a_17709_13109.n124 a_17709_13109.t72 84.6023
R1652 a_17709_13109.n123 a_17709_13109.t73 84.6023
R1653 a_17709_13109.n122 a_17709_13109.t74 84.6023
R1654 a_17709_13109.n121 a_17709_13109.t75 84.6023
R1655 a_17709_13109.n120 a_17709_13109.t76 84.6023
R1656 a_17709_13109.n119 a_17709_13109.t77 84.6023
R1657 a_17709_13109.n118 a_17709_13109.t78 84.6023
R1658 a_17709_13109.n117 a_17709_13109.t79 84.6023
R1659 a_17709_13109.n116 a_17709_13109.t80 84.6023
R1660 a_17709_13109.n115 a_17709_13109.t81 84.6023
R1661 a_17709_13109.n114 a_17709_13109.t82 84.6023
R1662 a_17709_13109.n113 a_17709_13109.t83 84.6023
R1663 a_17709_13109.n151 a_17709_13109.n75 38.6525
R1664 a_17709_13109.t1 a_17709_13109.n152 16.3265
R1665 a_17709_13109.n152 a_17709_13109.n74 12.2976
R1666 a_17709_13109.n151 a_17709_13109.n150 11.6916
R1667 a_17709_13109.n114 a_17709_13109.n113 11.5946
R1668 a_17709_13109.n115 a_17709_13109.n114 11.5946
R1669 a_17709_13109.n116 a_17709_13109.n115 11.5946
R1670 a_17709_13109.n117 a_17709_13109.n116 11.5946
R1671 a_17709_13109.n118 a_17709_13109.n117 11.5946
R1672 a_17709_13109.n119 a_17709_13109.n118 11.5946
R1673 a_17709_13109.n120 a_17709_13109.n119 11.5946
R1674 a_17709_13109.n121 a_17709_13109.n120 11.5946
R1675 a_17709_13109.n122 a_17709_13109.n121 11.5946
R1676 a_17709_13109.n123 a_17709_13109.n122 11.5946
R1677 a_17709_13109.n124 a_17709_13109.n123 11.5946
R1678 a_17709_13109.n125 a_17709_13109.n124 11.5946
R1679 a_17709_13109.n126 a_17709_13109.n125 11.5946
R1680 a_17709_13109.n127 a_17709_13109.n126 11.5946
R1681 a_17709_13109.n128 a_17709_13109.n127 11.5946
R1682 a_17709_13109.n129 a_17709_13109.n128 11.5946
R1683 a_17709_13109.n130 a_17709_13109.n129 11.5946
R1684 a_17709_13109.n131 a_17709_13109.n130 11.5946
R1685 a_17709_13109.n132 a_17709_13109.n131 11.5946
R1686 a_17709_13109.n133 a_17709_13109.n132 11.5946
R1687 a_17709_13109.n134 a_17709_13109.n133 11.5946
R1688 a_17709_13109.n135 a_17709_13109.n134 11.5946
R1689 a_17709_13109.n136 a_17709_13109.n135 11.5946
R1690 a_17709_13109.n137 a_17709_13109.n136 11.5946
R1691 a_17709_13109.n138 a_17709_13109.n137 11.5946
R1692 a_17709_13109.n139 a_17709_13109.n138 11.5946
R1693 a_17709_13109.n140 a_17709_13109.n139 11.5946
R1694 a_17709_13109.n141 a_17709_13109.n140 11.5946
R1695 a_17709_13109.n142 a_17709_13109.n141 11.5946
R1696 a_17709_13109.n143 a_17709_13109.n142 11.5946
R1697 a_17709_13109.n144 a_17709_13109.n143 11.5946
R1698 a_17709_13109.n145 a_17709_13109.n144 11.5946
R1699 a_17709_13109.n146 a_17709_13109.n145 11.5946
R1700 a_17709_13109.n147 a_17709_13109.n146 11.5946
R1701 a_17709_13109.n148 a_17709_13109.n147 11.5946
R1702 a_17709_13109.n149 a_17709_13109.n148 11.5946
R1703 a_17709_13109.n112 a_17709_13109.n111 11.5946
R1704 a_17709_13109.n111 a_17709_13109.n110 11.5946
R1705 a_17709_13109.n110 a_17709_13109.n109 11.5946
R1706 a_17709_13109.n109 a_17709_13109.n108 11.5946
R1707 a_17709_13109.n108 a_17709_13109.n107 11.5946
R1708 a_17709_13109.n107 a_17709_13109.n106 11.5946
R1709 a_17709_13109.n106 a_17709_13109.n105 11.5946
R1710 a_17709_13109.n105 a_17709_13109.n104 11.5946
R1711 a_17709_13109.n104 a_17709_13109.n103 11.5946
R1712 a_17709_13109.n103 a_17709_13109.n102 11.5946
R1713 a_17709_13109.n102 a_17709_13109.n101 11.5946
R1714 a_17709_13109.n101 a_17709_13109.n100 11.5946
R1715 a_17709_13109.n100 a_17709_13109.n99 11.5946
R1716 a_17709_13109.n99 a_17709_13109.n98 11.5946
R1717 a_17709_13109.n98 a_17709_13109.n97 11.5946
R1718 a_17709_13109.n97 a_17709_13109.n96 11.5946
R1719 a_17709_13109.n96 a_17709_13109.n95 11.5946
R1720 a_17709_13109.n95 a_17709_13109.n94 11.5946
R1721 a_17709_13109.n94 a_17709_13109.n93 11.5946
R1722 a_17709_13109.n93 a_17709_13109.n92 11.5946
R1723 a_17709_13109.n92 a_17709_13109.n91 11.5946
R1724 a_17709_13109.n91 a_17709_13109.n90 11.5946
R1725 a_17709_13109.n90 a_17709_13109.n89 11.5946
R1726 a_17709_13109.n89 a_17709_13109.n88 11.5946
R1727 a_17709_13109.n88 a_17709_13109.n87 11.5946
R1728 a_17709_13109.n87 a_17709_13109.n86 11.5946
R1729 a_17709_13109.n86 a_17709_13109.n85 11.5946
R1730 a_17709_13109.n85 a_17709_13109.n84 11.5946
R1731 a_17709_13109.n84 a_17709_13109.n83 11.5946
R1732 a_17709_13109.n83 a_17709_13109.n82 11.5946
R1733 a_17709_13109.n82 a_17709_13109.n81 11.5946
R1734 a_17709_13109.n81 a_17709_13109.n80 11.5946
R1735 a_17709_13109.n80 a_17709_13109.n79 11.5946
R1736 a_17709_13109.n79 a_17709_13109.n78 11.5946
R1737 a_17709_13109.n78 a_17709_13109.n77 11.5946
R1738 a_17709_13109.n77 a_17709_13109.n76 11.5946
R1739 a_17709_13109.n38 a_17709_13109.n37 11.5946
R1740 a_17709_13109.n39 a_17709_13109.n38 11.5946
R1741 a_17709_13109.n40 a_17709_13109.n39 11.5946
R1742 a_17709_13109.n41 a_17709_13109.n40 11.5946
R1743 a_17709_13109.n42 a_17709_13109.n41 11.5946
R1744 a_17709_13109.n43 a_17709_13109.n42 11.5946
R1745 a_17709_13109.n44 a_17709_13109.n43 11.5946
R1746 a_17709_13109.n45 a_17709_13109.n44 11.5946
R1747 a_17709_13109.n46 a_17709_13109.n45 11.5946
R1748 a_17709_13109.n47 a_17709_13109.n46 11.5946
R1749 a_17709_13109.n48 a_17709_13109.n47 11.5946
R1750 a_17709_13109.n49 a_17709_13109.n48 11.5946
R1751 a_17709_13109.n50 a_17709_13109.n49 11.5946
R1752 a_17709_13109.n51 a_17709_13109.n50 11.5946
R1753 a_17709_13109.n52 a_17709_13109.n51 11.5946
R1754 a_17709_13109.n53 a_17709_13109.n52 11.5946
R1755 a_17709_13109.n54 a_17709_13109.n53 11.5946
R1756 a_17709_13109.n55 a_17709_13109.n54 11.5946
R1757 a_17709_13109.n56 a_17709_13109.n55 11.5946
R1758 a_17709_13109.n57 a_17709_13109.n56 11.5946
R1759 a_17709_13109.n58 a_17709_13109.n57 11.5946
R1760 a_17709_13109.n59 a_17709_13109.n58 11.5946
R1761 a_17709_13109.n60 a_17709_13109.n59 11.5946
R1762 a_17709_13109.n61 a_17709_13109.n60 11.5946
R1763 a_17709_13109.n62 a_17709_13109.n61 11.5946
R1764 a_17709_13109.n63 a_17709_13109.n62 11.5946
R1765 a_17709_13109.n64 a_17709_13109.n63 11.5946
R1766 a_17709_13109.n65 a_17709_13109.n64 11.5946
R1767 a_17709_13109.n66 a_17709_13109.n65 11.5946
R1768 a_17709_13109.n67 a_17709_13109.n66 11.5946
R1769 a_17709_13109.n68 a_17709_13109.n67 11.5946
R1770 a_17709_13109.n69 a_17709_13109.n68 11.5946
R1771 a_17709_13109.n70 a_17709_13109.n69 11.5946
R1772 a_17709_13109.n71 a_17709_13109.n70 11.5946
R1773 a_17709_13109.n72 a_17709_13109.n71 11.5946
R1774 a_17709_13109.n73 a_17709_13109.n72 11.5946
R1775 a_17709_13109.n36 a_17709_13109.n35 11.5946
R1776 a_17709_13109.n35 a_17709_13109.n34 11.5946
R1777 a_17709_13109.n34 a_17709_13109.n33 11.5946
R1778 a_17709_13109.n33 a_17709_13109.n32 11.5946
R1779 a_17709_13109.n32 a_17709_13109.n31 11.5946
R1780 a_17709_13109.n31 a_17709_13109.n30 11.5946
R1781 a_17709_13109.n30 a_17709_13109.n29 11.5946
R1782 a_17709_13109.n29 a_17709_13109.n28 11.5946
R1783 a_17709_13109.n28 a_17709_13109.n27 11.5946
R1784 a_17709_13109.n27 a_17709_13109.n26 11.5946
R1785 a_17709_13109.n26 a_17709_13109.n25 11.5946
R1786 a_17709_13109.n25 a_17709_13109.n24 11.5946
R1787 a_17709_13109.n24 a_17709_13109.n23 11.5946
R1788 a_17709_13109.n23 a_17709_13109.n22 11.5946
R1789 a_17709_13109.n22 a_17709_13109.n21 11.5946
R1790 a_17709_13109.n21 a_17709_13109.n20 11.5946
R1791 a_17709_13109.n20 a_17709_13109.n19 11.5946
R1792 a_17709_13109.n19 a_17709_13109.n18 11.5946
R1793 a_17709_13109.n18 a_17709_13109.n17 11.5946
R1794 a_17709_13109.n17 a_17709_13109.n16 11.5946
R1795 a_17709_13109.n16 a_17709_13109.n15 11.5946
R1796 a_17709_13109.n15 a_17709_13109.n14 11.5946
R1797 a_17709_13109.n14 a_17709_13109.n13 11.5946
R1798 a_17709_13109.n13 a_17709_13109.n12 11.5946
R1799 a_17709_13109.n12 a_17709_13109.n11 11.5946
R1800 a_17709_13109.n11 a_17709_13109.n10 11.5946
R1801 a_17709_13109.n10 a_17709_13109.n9 11.5946
R1802 a_17709_13109.n9 a_17709_13109.n8 11.5946
R1803 a_17709_13109.n8 a_17709_13109.n7 11.5946
R1804 a_17709_13109.n7 a_17709_13109.n6 11.5946
R1805 a_17709_13109.n6 a_17709_13109.n5 11.5946
R1806 a_17709_13109.n5 a_17709_13109.n4 11.5946
R1807 a_17709_13109.n4 a_17709_13109.n3 11.5946
R1808 a_17709_13109.n3 a_17709_13109.n2 11.5946
R1809 a_17709_13109.n2 a_17709_13109.n1 11.5946
R1810 a_17709_13109.n1 a_17709_13109.n0 11.5946
R1811 a_17709_13109.t6 a_17709_13109.t1 6.5765
R1812 a_17709_13109.n150 a_17709_13109.n149 5.79756
R1813 a_17709_13109.n150 a_17709_13109.n112 5.79756
R1814 a_17709_13109.n74 a_17709_13109.n73 5.79756
R1815 a_17709_13109.n74 a_17709_13109.n36 5.79756
R1816 a_17709_13109.t9 a_17709_13109.t6 5.58517
R1817 a_17709_13109.n75 a_17709_13109.t12 3.21818
R1818 a_17709_13109.n75 a_17709_13109.t11 3.08318
R1819 a_17709_13109.n152 a_17709_13109.n151 1.4465
R1820 a_35769_13109.n31 a_35769_13109.t34 99.9768
R1821 a_35769_13109.n46 a_35769_13109.t65 99.9768
R1822 a_35769_13109.n0 a_35769_13109.t2 96.1964
R1823 a_35769_13109.n15 a_35769_13109.t33 96.1964
R1824 a_35769_13109.n31 a_35769_13109.t35 88.3826
R1825 a_35769_13109.n32 a_35769_13109.t36 88.3826
R1826 a_35769_13109.n33 a_35769_13109.t37 88.3826
R1827 a_35769_13109.n34 a_35769_13109.t38 88.3826
R1828 a_35769_13109.n35 a_35769_13109.t39 88.3826
R1829 a_35769_13109.n36 a_35769_13109.t40 88.3826
R1830 a_35769_13109.n37 a_35769_13109.t41 88.3826
R1831 a_35769_13109.n38 a_35769_13109.t42 88.3826
R1832 a_35769_13109.n39 a_35769_13109.t43 88.3826
R1833 a_35769_13109.n40 a_35769_13109.t44 88.3826
R1834 a_35769_13109.n41 a_35769_13109.t45 88.3826
R1835 a_35769_13109.n42 a_35769_13109.t46 88.3826
R1836 a_35769_13109.n43 a_35769_13109.t47 88.3826
R1837 a_35769_13109.n44 a_35769_13109.t48 88.3826
R1838 a_35769_13109.n45 a_35769_13109.t49 88.3826
R1839 a_35769_13109.n60 a_35769_13109.t50 88.3826
R1840 a_35769_13109.n59 a_35769_13109.t51 88.3826
R1841 a_35769_13109.n58 a_35769_13109.t52 88.3826
R1842 a_35769_13109.n57 a_35769_13109.t53 88.3826
R1843 a_35769_13109.n56 a_35769_13109.t54 88.3826
R1844 a_35769_13109.n55 a_35769_13109.t55 88.3826
R1845 a_35769_13109.n54 a_35769_13109.t56 88.3826
R1846 a_35769_13109.n53 a_35769_13109.t57 88.3826
R1847 a_35769_13109.n52 a_35769_13109.t58 88.3826
R1848 a_35769_13109.n51 a_35769_13109.t59 88.3826
R1849 a_35769_13109.n50 a_35769_13109.t60 88.3826
R1850 a_35769_13109.n49 a_35769_13109.t61 88.3826
R1851 a_35769_13109.n48 a_35769_13109.t62 88.3826
R1852 a_35769_13109.n47 a_35769_13109.t63 88.3826
R1853 a_35769_13109.n46 a_35769_13109.t64 88.3826
R1854 a_35769_13109.n0 a_35769_13109.t3 84.6023
R1855 a_35769_13109.n1 a_35769_13109.t4 84.6023
R1856 a_35769_13109.n2 a_35769_13109.t5 84.6023
R1857 a_35769_13109.n3 a_35769_13109.t6 84.6023
R1858 a_35769_13109.n4 a_35769_13109.t7 84.6023
R1859 a_35769_13109.n5 a_35769_13109.t8 84.6023
R1860 a_35769_13109.n6 a_35769_13109.t9 84.6023
R1861 a_35769_13109.n7 a_35769_13109.t10 84.6023
R1862 a_35769_13109.n8 a_35769_13109.t11 84.6023
R1863 a_35769_13109.n9 a_35769_13109.t12 84.6023
R1864 a_35769_13109.n10 a_35769_13109.t13 84.6023
R1865 a_35769_13109.n11 a_35769_13109.t14 84.6023
R1866 a_35769_13109.n12 a_35769_13109.t15 84.6023
R1867 a_35769_13109.n13 a_35769_13109.t16 84.6023
R1868 a_35769_13109.n14 a_35769_13109.t17 84.6023
R1869 a_35769_13109.n29 a_35769_13109.t18 84.6023
R1870 a_35769_13109.n28 a_35769_13109.t19 84.6023
R1871 a_35769_13109.n27 a_35769_13109.t20 84.6023
R1872 a_35769_13109.n26 a_35769_13109.t21 84.6023
R1873 a_35769_13109.n25 a_35769_13109.t22 84.6023
R1874 a_35769_13109.n24 a_35769_13109.t23 84.6023
R1875 a_35769_13109.n23 a_35769_13109.t24 84.6023
R1876 a_35769_13109.n22 a_35769_13109.t25 84.6023
R1877 a_35769_13109.n21 a_35769_13109.t26 84.6023
R1878 a_35769_13109.n20 a_35769_13109.t27 84.6023
R1879 a_35769_13109.n19 a_35769_13109.t28 84.6023
R1880 a_35769_13109.n18 a_35769_13109.t29 84.6023
R1881 a_35769_13109.n17 a_35769_13109.t30 84.6023
R1882 a_35769_13109.n16 a_35769_13109.t31 84.6023
R1883 a_35769_13109.n15 a_35769_13109.t32 84.6023
R1884 a_35769_13109.t1 a_35769_13109.n62 36.2525
R1885 a_35769_13109.t0 a_35769_13109.t1 17.4124
R1886 a_35769_13109.n16 a_35769_13109.n15 11.5946
R1887 a_35769_13109.n17 a_35769_13109.n16 11.5946
R1888 a_35769_13109.n18 a_35769_13109.n17 11.5946
R1889 a_35769_13109.n19 a_35769_13109.n18 11.5946
R1890 a_35769_13109.n20 a_35769_13109.n19 11.5946
R1891 a_35769_13109.n21 a_35769_13109.n20 11.5946
R1892 a_35769_13109.n22 a_35769_13109.n21 11.5946
R1893 a_35769_13109.n23 a_35769_13109.n22 11.5946
R1894 a_35769_13109.n24 a_35769_13109.n23 11.5946
R1895 a_35769_13109.n25 a_35769_13109.n24 11.5946
R1896 a_35769_13109.n26 a_35769_13109.n25 11.5946
R1897 a_35769_13109.n27 a_35769_13109.n26 11.5946
R1898 a_35769_13109.n28 a_35769_13109.n27 11.5946
R1899 a_35769_13109.n29 a_35769_13109.n28 11.5946
R1900 a_35769_13109.n14 a_35769_13109.n13 11.5946
R1901 a_35769_13109.n13 a_35769_13109.n12 11.5946
R1902 a_35769_13109.n12 a_35769_13109.n11 11.5946
R1903 a_35769_13109.n11 a_35769_13109.n10 11.5946
R1904 a_35769_13109.n10 a_35769_13109.n9 11.5946
R1905 a_35769_13109.n9 a_35769_13109.n8 11.5946
R1906 a_35769_13109.n8 a_35769_13109.n7 11.5946
R1907 a_35769_13109.n7 a_35769_13109.n6 11.5946
R1908 a_35769_13109.n6 a_35769_13109.n5 11.5946
R1909 a_35769_13109.n5 a_35769_13109.n4 11.5946
R1910 a_35769_13109.n4 a_35769_13109.n3 11.5946
R1911 a_35769_13109.n3 a_35769_13109.n2 11.5946
R1912 a_35769_13109.n2 a_35769_13109.n1 11.5946
R1913 a_35769_13109.n1 a_35769_13109.n0 11.5946
R1914 a_35769_13109.n47 a_35769_13109.n46 11.5946
R1915 a_35769_13109.n48 a_35769_13109.n47 11.5946
R1916 a_35769_13109.n49 a_35769_13109.n48 11.5946
R1917 a_35769_13109.n50 a_35769_13109.n49 11.5946
R1918 a_35769_13109.n51 a_35769_13109.n50 11.5946
R1919 a_35769_13109.n52 a_35769_13109.n51 11.5946
R1920 a_35769_13109.n53 a_35769_13109.n52 11.5946
R1921 a_35769_13109.n54 a_35769_13109.n53 11.5946
R1922 a_35769_13109.n55 a_35769_13109.n54 11.5946
R1923 a_35769_13109.n56 a_35769_13109.n55 11.5946
R1924 a_35769_13109.n57 a_35769_13109.n56 11.5946
R1925 a_35769_13109.n58 a_35769_13109.n57 11.5946
R1926 a_35769_13109.n59 a_35769_13109.n58 11.5946
R1927 a_35769_13109.n60 a_35769_13109.n59 11.5946
R1928 a_35769_13109.n45 a_35769_13109.n44 11.5946
R1929 a_35769_13109.n44 a_35769_13109.n43 11.5946
R1930 a_35769_13109.n43 a_35769_13109.n42 11.5946
R1931 a_35769_13109.n42 a_35769_13109.n41 11.5946
R1932 a_35769_13109.n41 a_35769_13109.n40 11.5946
R1933 a_35769_13109.n40 a_35769_13109.n39 11.5946
R1934 a_35769_13109.n39 a_35769_13109.n38 11.5946
R1935 a_35769_13109.n38 a_35769_13109.n37 11.5946
R1936 a_35769_13109.n37 a_35769_13109.n36 11.5946
R1937 a_35769_13109.n36 a_35769_13109.n35 11.5946
R1938 a_35769_13109.n35 a_35769_13109.n34 11.5946
R1939 a_35769_13109.n34 a_35769_13109.n33 11.5946
R1940 a_35769_13109.n33 a_35769_13109.n32 11.5946
R1941 a_35769_13109.n32 a_35769_13109.n31 11.5946
R1942 a_35769_13109.n62 a_35769_13109.n30 8.60227
R1943 a_35769_13109.n62 a_35769_13109.n61 6.52627
R1944 a_35769_13109.n30 a_35769_13109.n29 5.79756
R1945 a_35769_13109.n30 a_35769_13109.n14 5.79756
R1946 a_35769_13109.n61 a_35769_13109.n60 5.79756
R1947 a_35769_13109.n61 a_35769_13109.n45 5.79756
R1948 a_10387_27249.t5 a_10387_27249.t2 85.1825
R1949 a_10387_27249.n0 a_10387_27249.t3 70.611
R1950 a_10387_27249.n0 a_10387_27249.t4 67.041
R1951 a_10387_27249.t2 a_10387_27249.n0 31.3955
R1952 a_10387_27249.t0 a_10387_27249.t1 14.1179
R1953 a_10387_27249.t1 a_10387_27249.t5 13.8725
R1954 a_26067_78209.t2 a_26067_78209.n2 135.621
R1955 a_26067_78209.n0 a_26067_78209.t5 134.617
R1956 a_26067_78209.n1 a_26067_78209.t6 134.617
R1957 a_26067_78209.n0 a_26067_78209.t3 89.4396
R1958 a_26067_78209.n1 a_26067_78209.t4 89.4396
R1959 a_26067_78209.n2 a_26067_78209.n1 41.5655
R1960 a_26067_78209.n2 a_26067_78209.n0 18.3095
R1961 a_26067_78209.t0 a_26067_78209.t2 7.6265
R1962 a_26067_78209.t1 a_26067_78209.t0 5.56141
R1963 a_22707_78209.n0 a_22707_78209.t5 153.089
R1964 a_22707_78209.n1 a_22707_78209.t6 153.089
R1965 a_22707_78209.t2 a_22707_78209.n2 94.4615
R1966 a_22707_78209.n0 a_22707_78209.t3 72.4755
R1967 a_22707_78209.n1 a_22707_78209.t4 72.4755
R1968 a_22707_78209.n2 a_22707_78209.n1 31.9085
R1969 a_22707_78209.n2 a_22707_78209.n0 17.6285
R1970 a_22707_78209.t0 a_22707_78209.t2 7.6265
R1971 a_22707_78209.t1 a_22707_78209.t0 5.56141
R1972 a_7027_78209.n0 a_7027_78209.t6 134.617
R1973 a_7027_78209.n1 a_7027_78209.t5 134.617
R1974 a_7027_78209.t2 a_7027_78209.n2 125.962
R1975 a_7027_78209.n0 a_7027_78209.t4 89.4396
R1976 a_7027_78209.n1 a_7027_78209.t3 89.4396
R1977 a_7027_78209.n2 a_7027_78209.n0 41.5415
R1978 a_7027_78209.n2 a_7027_78209.n1 17.9135
R1979 a_7027_78209.t0 a_7027_78209.t2 7.6265
R1980 a_7027_78209.t1 a_7027_78209.t0 5.56141
R1981 a_5347_78209.n0 a_5347_78209.t5 146.764
R1982 a_5347_78209.n1 a_5347_78209.t6 136.297
R1983 a_5347_78209.t2 a_5347_78209.n2 128.508
R1984 a_5347_78209.n0 a_5347_78209.t3 89.4315
R1985 a_5347_78209.n1 a_5347_78209.t4 89.0196
R1986 a_5347_78209.n2 a_5347_78209.n0 40.4285
R1987 a_5347_78209.n2 a_5347_78209.n1 17.7695
R1988 a_5347_78209.t0 a_5347_78209.t2 7.6265
R1989 a_5347_78209.t1 a_5347_78209.t0 5.56141
R1990 a_3667_82549.n0 a_3667_82549.t5 136.297
R1991 a_3667_82549.t2 a_3667_82549.t3 92.3615
R1992 a_3667_82549.n0 a_3667_82549.t4 89.0196
R1993 a_3667_82549.t3 a_3667_82549.n0 47.8415
R1994 a_3667_82549.t0 a_3667_82549.t2 7.6265
R1995 a_3667_82549.t1 a_3667_82549.t0 5.56141
C856 VCTRL VSS 19.4948f
C857 B1 VSS 44.04254f
C858 B0 VSS 27.2121f
C859 LOQP VSS 24.3366f
C860 LOQN VSS 22.624f
C861 LOIN VSS 37.98361f
C862 LOIP VSS 45.51481f
C863 VDD VSS 0.55972p
C864 VR VSS 1.04633p
C865 a_46940_3486# VSS 0.88455f ; **FLOATING
C866 a_46520_3486# VSS 0.85051f ; **FLOATING
C867 a_46100_1364# VSS 0.84806f ; **FLOATING
C868 a_45680_1364# VSS 0.85293f ; **FLOATING
C869 a_45260_3486# VSS 0.85871f ; **FLOATING
C870 a_44840_3486# VSS 0.85051f ; **FLOATING
C871 a_44420_1364# VSS 0.8637f ; **FLOATING
C872 a_44000_1364# VSS 0.85197f ; **FLOATING
C873 a_43580_3486# VSS 0.85871f ; **FLOATING
C874 a_43160_3486# VSS 0.85051f ; **FLOATING
C875 a_42740_1364# VSS 0.86578f ; **FLOATING
C876 a_42320_1364# VSS 0.851f ; **FLOATING
C877 a_41900_3486# VSS 0.85871f ; **FLOATING
C878 a_41480_3486# VSS 0.85051f ; **FLOATING
C879 a_41060_1364# VSS 0.86484f ; **FLOATING
C880 a_40640_1364# VSS 0.85048f ; **FLOATING
C881 a_40220_3486# VSS 0.85871f ; **FLOATING
C882 a_39800_3486# VSS 0.8665f ; **FLOATING
C883 a_35956_1120# VSS 1.02722f
C884 a_35000_1180# VSS 1.78228f ; **FLOATING
C885 a_34840_1120# VSS 1.029f
C886 a_51114_14482# VSS 0.24128f ; **FLOATING
C887 a_50704_14482# VSS 0.25327f ; **FLOATING
C888 a_44954_14482# VSS 0.24128f
C889 a_44544_14482# VSS 0.25327f ; **FLOATING
C890 a_41016_11900# VSS 0.12095f
C891 a_35584_11900# VSS 0.12095f
C892 a_41016_13271# VSS 0.1189f
C893 a_35584_13271# VSS 0.1189f
C894 a_34224_11900# VSS 0.12306f
C895 a_31384_11900# VSS 0.12306f
C896 a_30084_11900# VSS 0.12095f
C897 a_17524_11900# VSS 0.12095f
C898 a_30084_13271# VSS 0.1189f
C899 a_21997_11960# VSS 1.57637f ; **FLOATING
C900 a_17524_13271# VSS 0.1189f
C901 a_51114_18340# VSS 0.04368f
C902 a_50704_18340# VSS 0.04368f
C903 a_44954_18340# VSS 0.04368f
C904 a_31569_13109# VSS 7.38114f ; **FLOATING
C905 a_44544_18340# VSS 0.04368f
C906 a_62174_26942# VSS 0.24358f
C907 a_61764_26942# VSS 0.2518f ; **FLOATING
C908 a_60494_26942# VSS 0.24128f
C909 a_60084_26942# VSS 0.25327f ; **FLOATING
C910 a_54334_26600# VSS 0.39521f
C911 a_53924_26600# VSS 0.4082f ; **FLOATING
C912 a_52654_26600# VSS 0.38483f
C913 a_52360_26660# VSS 1.15362f ; **FLOATING
C914 a_52244_26600# VSS 0.38539f
C915 a_46494_26942# VSS 0.24128f
C916 a_46084_26942# VSS 0.25327f ; **FLOATING
C917 a_40334_26600# VSS 0.39521f
C918 a_39924_26600# VSS 0.4082f ; **FLOATING
C919 a_38654_26600# VSS 0.38483f
C920 a_38360_26660# VSS 1.15362f ; **FLOATING
C921 a_38244_26600# VSS 0.38539f
C922 a_32494_26942# VSS 0.24128f
C923 a_32084_26942# VSS 0.25327f ; **FLOATING
C924 a_26334_26942# VSS 0.24358f
C925 a_25924_26942# VSS 0.2518f ; **FLOATING
C926 a_24654_26942# VSS 0.24128f
C927 a_24244_26942# VSS 0.25327f ; **FLOATING
C928 a_18494_26942# VSS 0.24358f
C929 a_18084_26942# VSS 0.2518f ; **FLOATING
C930 a_16814_26942# VSS 0.24128f
C931 a_16404_26942# VSS 0.25327f ; **FLOATING
C932 a_10654_26600# VSS 0.39521f
C933 a_10244_26600# VSS 0.4082f ; **FLOATING
C934 a_8974_26600# VSS 0.38483f
C935 a_8680_26660# VSS 1.15362f ; **FLOATING
C936 a_8564_26600# VSS 0.38539f
C937 a_62174_30800# VSS 0.07326f
C938 a_60345_27002# VSS 3.20709f ; **FLOATING
C939 a_61764_30800# VSS 0.07326f
C940 a_60494_30800# VSS 0.07326f
C941 a_60345_30860# VSS 0.53402f ; **FLOATING
C942 a_60084_30800# VSS 0.07326f
C943 a_54334_30660# VSS 0.04368f
C944 a_53924_30660# VSS 0.04368f
C945 a_52654_30660# VSS 0.04368f
C946 a_52505_26660# VSS 2.85213f ; **FLOATING
C947 a_52244_30660# VSS 0.04368f
C948 a_46494_30800# VSS 0.04368f
C949 a_46084_30800# VSS 0.04368f
C950 a_40334_30660# VSS 0.04368f
C951 a_39924_30660# VSS 0.04368f
C952 a_40067_27249# VSS 15.1385f ; **FLOATING
C953 a_38654_30660# VSS 0.04368f
C954 a_38505_26660# VSS 7.11369f ; **FLOATING
C955 a_38244_30660# VSS 0.04368f
C956 a_32494_30800# VSS 0.04368f
C957 a_32345_27002# VSS 3.25077f ; **FLOATING
C958 a_32084_30800# VSS 0.04368f
C959 a_26334_30800# VSS 0.07326f
C960 a_25924_30800# VSS 0.07326f
C961 a_26067_27389# VSS 18.95f ; **FLOATING
C962 a_24654_30800# VSS 0.07326f
C963 a_24505_30860# VSS 0.53402f ; **FLOATING
C964 a_24244_30800# VSS 0.07326f
C965 a_18494_30800# VSS 0.07326f
C966 a_16665_27002# VSS 23.5916f ; **FLOATING
C967 a_18084_30800# VSS 0.07326f
C968 a_16814_30800# VSS 0.07326f
C969 a_16665_30860# VSS 0.53402f ; **FLOATING
C970 a_16404_30800# VSS 0.07326f
C971 a_10654_30660# VSS 0.04368f
C972 a_10244_30660# VSS 0.04368f
C973 a_8974_30660# VSS 0.04368f
C974 a_8825_26660# VSS 25.8461f ; **FLOATING
C975 a_8564_30660# VSS 0.04368f
C976 a_57996_39340# VSS 0.58425f ; **FLOATING
C977 a_57424_39340# VSS 0.58298f ; **FLOATING
C978 a_51674_39340# VSS 0.39203f ; **FLOATING
C979 a_51264_39340# VSS 0.41056f ; **FLOATING
C980 a_45514_39340# VSS 0.39203f
C981 a_45104_39340# VSS 0.41056f ; **FLOATING
C982 a_38956_39340# VSS 0.58425f ; **FLOATING
C983 a_38384_39340# VSS 0.58298f ; **FLOATING
C984 a_32236_39340# VSS 0.58425f ; **FLOATING
C985 a_31664_39340# VSS 0.58298f ; **FLOATING
C986 a_25914_39340# VSS 0.39203f
C987 a_25504_39340# VSS 0.41056f ; **FLOATING
C988 a_19754_39340# VSS 0.39203f
C989 a_19344_39340# VSS 0.41056f ; **FLOATING
C990 a_13196_39340# VSS 0.58425f ; **FLOATING
C991 a_12624_39340# VSS 0.58298f ; **FLOATING
C992 a_58320_43540# VSS 0.07989f
C993 a_57424_43540# VSS 0.07989f
C994 a_51674_43400# VSS 0.07326f
C995 a_51264_43400# VSS 0.07326f
C996 a_45514_43400# VSS 0.07326f
C997 a_45104_43400# VSS 0.07326f
C998 a_39280_43540# VSS 0.07989f
C999 a_38384_43540# VSS 0.07989f
C1000 a_8707_27249# VSS 32.4482f ; **FLOATING
C1001 a_32560_43540# VSS 0.07989f
C1002 a_31664_43540# VSS 0.07989f
C1003 a_25914_43400# VSS 0.07326f
C1004 a_25765_39400# VSS 23.3482f ; **FLOATING
C1005 a_25504_43400# VSS 0.07326f
C1006 a_19754_43400# VSS 0.07326f
C1007 a_19344_43400# VSS 0.07326f
C1008 a_13520_43540# VSS 0.07989f
C1009 a_12624_43540# VSS 0.07989f
C1010 a_12809_40129# VSS 36.0884f ; **FLOATING
C1011 a_48198_52282# VSS 0.28324f
C1012 a_47740_52282# VSS 0.29517f
C1013 a_46658_52282# VSS 0.28234f
C1014 a_46200_52282# VSS 0.29512f
C1015 a_45136_51940# VSS 0.85008f
C1016 a_44492_51940# VSS 0.84595f
C1017 a_43848_51940# VSS 0.83464f
C1018 a_43204_51940# VSS 0.82278f
C1019 a_42560_51940# VSS 0.84915f
C1020 a_41478_52282# VSS 0.28324f
C1021 a_41020_52282# VSS 0.29578f
C1022 a_39938_52282# VSS 0.28324f
C1023 a_39480_52282# VSS 0.29578f
C1024 a_38416_51940# VSS 0.85282f
C1025 a_37772_51940# VSS 0.82939f
C1026 a_37128_51940# VSS 0.83003f
C1027 a_36484_51940# VSS 0.8233f
C1028 a_35840_51940# VSS 0.85127f ; **FLOATING
C1029 a_37337_52869# VSS 16.9104f ; **FLOATING
C1030 a_34758_52282# VSS 0.28373f
C1031 a_34300_52282# VSS 0.29606f
C1032 a_33218_52282# VSS 0.2833f
C1033 a_32760_52282# VSS 0.29584f
C1034 a_31696_51940# VSS 0.85269f
C1035 a_31052_51940# VSS 0.83373f
C1036 a_30408_51940# VSS 0.8335f
C1037 a_29764_51940# VSS 0.8261f
C1038 a_29120_51940# VSS 0.8456f
C1039 a_28038_52282# VSS 0.2833f
C1040 a_27580_52282# VSS 0.29584f
C1041 a_26498_52282# VSS 0.2833f
C1042 a_26040_52282# VSS 0.29584f
C1043 a_24976_51940# VSS 0.85942f
C1044 a_24332_51940# VSS 0.83082f
C1045 a_23688_51940# VSS 0.8248f
C1046 a_23044_51940# VSS 0.82482f
C1047 a_22400_51940# VSS 0.84894f ; **FLOATING
C1048 a_23897_52869# VSS 17.0702f ; **FLOATING
C1049 a_46518_56280# VSS 0.04627f
C1050 a_46060_56280# VSS 0.04627f
C1051 a_44978_56280# VSS 0.04627f
C1052 a_44520_56280# VSS 0.04627f
C1053 a_43332_56280# VSS 0.08258f
C1054 a_42316_56280# VSS 0.05202f
C1055 a_41300_56280# VSS 0.08258f
C1056 a_40218_56280# VSS 0.04627f
C1057 a_39760_56280# VSS 0.04627f
C1058 a_38678_56280# VSS 0.04627f
C1059 a_38220_56280# VSS 0.04627f
C1060 a_37032_56280# VSS 0.08258f
C1061 a_36325_56340# VSS 15.5977f ; **FLOATING
C1062 a_36016_56280# VSS 0.05202f
C1063 a_35309_56340# VSS 16.8971f ; **FLOATING
C1064 a_35000_56280# VSS 0.08258f
C1065 a_33918_56280# VSS 0.04627f
C1066 a_33460_56280# VSS 0.04627f
C1067 a_32378_56280# VSS 0.04627f
C1068 a_31920_56280# VSS 0.04627f
C1069 a_30732_56280# VSS 0.08258f
C1070 a_29716_56280# VSS 0.05202f
C1071 a_28700_56280# VSS 0.08258f
C1072 a_27618_56280# VSS 0.04627f
C1073 a_27160_56280# VSS 0.04627f
C1074 a_26078_56280# VSS 0.04627f
C1075 a_25620_56280# VSS 0.04627f
C1076 a_24432_56280# VSS 0.08258f
C1077 a_19487_39989# VSS 21.1711f ; **FLOATING
C1078 a_23416_56280# VSS 0.05202f
C1079 a_22709_52000# VSS 20.7506f ; **FLOATING
C1080 a_22400_56280# VSS 0.08258f
C1081 a_57996_64680# VSS 0.58425f ; **FLOATING
C1082 a_57424_64680# VSS 0.58298f ; **FLOATING
C1083 a_51674_64680# VSS 0.39203f
C1084 a_51264_64680# VSS 0.41056f ; **FLOATING
C1085 a_45514_64680# VSS 0.39203f
C1086 a_45104_64680# VSS 0.41056f ; **FLOATING
C1087 a_38956_64680# VSS 0.58425f ; **FLOATING
C1088 a_38384_64680# VSS 0.58298f ; **FLOATING
C1089 a_32236_64680# VSS 0.58425f ; **FLOATING
C1090 a_31664_64680# VSS 0.58298f ; **FLOATING
C1091 a_25914_64680# VSS 0.39203f
C1092 a_25504_64680# VSS 0.41056f ; **FLOATING
C1093 a_19754_64680# VSS 0.39203f
C1094 a_19344_64680# VSS 0.41056f ; **FLOATING
C1095 a_13196_64680# VSS 0.58425f ; **FLOATING
C1096 a_12624_64680# VSS 0.58298f ; **FLOATING
C1097 a_58320_68880# VSS 0.07989f
C1098 a_57424_68880# VSS 0.07989f
C1099 a_51674_68740# VSS 0.07326f
C1100 a_51264_68740# VSS 0.07326f
C1101 a_29925_57069# VSS 18.7368f ; **FLOATING
C1102 a_45514_68740# VSS 0.07326f
C1103 a_45104_68740# VSS 0.07326f
C1104 a_28909_57069# VSS 22.1345f ; **FLOATING
C1105 a_39280_68880# VSS 0.07989f
C1106 a_38384_68880# VSS 0.07989f
C1107 a_32560_68880# VSS 0.07989f
C1108 a_31664_68880# VSS 0.07989f
C1109 a_25914_68740# VSS 0.07326f
C1110 a_25504_68740# VSS 0.07326f
C1111 a_23253_52869# VSS 19.8664f ; **FLOATING
C1112 a_19754_68740# VSS 0.07326f
C1113 a_19344_68740# VSS 0.07326f
C1114 a_19487_65329# VSS 19.191f ; **FLOATING
C1115 a_13520_68880# VSS 0.07989f
C1116 a_12624_68880# VSS 0.07989f
C1117 a_67214_77622# VSS 0.24358f
C1118 a_66804_77622# VSS 0.2518f ; **FLOATING
C1119 a_65534_77622# VSS 0.24128f
C1120 a_65124_77622# VSS 0.25327f ; **FLOATING
C1121 a_59374_77280# VSS 0.39521f
C1122 a_58964_77280# VSS 0.4082f ; **FLOATING
C1123 a_57694_77280# VSS 0.38483f
C1124 a_57400_77340# VSS 1.15362f ; **FLOATING
C1125 a_57284_77280# VSS 0.38539f
C1126 a_51534_77622# VSS 0.24358f
C1127 a_51124_77622# VSS 0.2518f ; **FLOATING
C1128 a_49854_77622# VSS 0.24128f
C1129 a_49444_77622# VSS 0.25327f ; **FLOATING
C1130 a_43694_77280# VSS 0.39521f
C1131 a_43284_77280# VSS 0.4082f ; **FLOATING
C1132 a_42014_77280# VSS 0.38483f
C1133 a_41720_77340# VSS 1.15362f ; **FLOATING
C1134 a_41604_77280# VSS 0.38539f
C1135 a_35854_77280# VSS 0.65977f
C1136 a_35444_77280# VSS 0.65883f
C1137 a_34174_77280# VSS 0.67777f
C1138 a_33764_77280# VSS 0.70598f
C1139 a_32494_77280# VSS 0.65883f
C1140 a_32200_77340# VSS 1.31911f ; **FLOATING
C1141 a_32084_77280# VSS 0.65774f
C1142 a_26334_77280# VSS 0.65977f
C1143 a_25924_77280# VSS 0.65883f
C1144 a_24654_77280# VSS 0.67777f
C1145 a_24244_77280# VSS 0.70598f
C1146 a_22974_77280# VSS 0.65883f
C1147 a_22680_77340# VSS 1.31911f ; **FLOATING
C1148 a_22564_77280# VSS 0.65774f
C1149 a_16814_77280# VSS 0.65977f
C1150 a_16404_77280# VSS 0.65883f
C1151 a_15134_77280# VSS 0.67777f
C1152 a_14724_77280# VSS 0.70598f
C1153 a_13454_77280# VSS 0.65883f
C1154 a_13160_77340# VSS 1.31911f ; **FLOATING
C1155 a_13044_77280# VSS 0.65774f
C1156 a_7294_77280# VSS 0.65977f
C1157 a_6884_77280# VSS 0.65883f
C1158 a_5614_77280# VSS 0.67777f
C1159 a_5204_77280# VSS 0.70598f
C1160 a_3934_77280# VSS 0.65883f
C1161 a_3640_77340# VSS 1.31911f ; **FLOATING
C1162 a_3524_77280# VSS 0.65774f
C1163 a_67214_81480# VSS 0.07326f
C1164 a_65385_77682# VSS 3.20709f ; **FLOATING
C1165 a_66804_81480# VSS 0.07326f
C1166 a_65534_81480# VSS 0.07326f
C1167 a_65385_81540# VSS 0.53402f ; **FLOATING
C1168 a_65124_81480# VSS 0.07326f
C1169 a_59374_81340# VSS 0.04368f
C1170 a_58964_81340# VSS 0.04368f
C1171 a_25765_64740# VSS 28.5412f ; **FLOATING
C1172 a_57694_81340# VSS 0.04368f
C1173 a_57545_77340# VSS 2.84828f ; **FLOATING
C1174 a_57284_81340# VSS 0.04368f
C1175 a_12809_65469# VSS 33.227f ; **FLOATING
C1176 a_51534_81480# VSS 0.07326f
C1177 a_49705_77682# VSS 3.1976f ; **FLOATING
C1178 a_51124_81480# VSS 0.07326f
C1179 a_49854_81480# VSS 0.07326f
C1180 a_49705_81540# VSS 0.53402f ; **FLOATING
C1181 a_49444_81480# VSS 0.07326f
C1182 a_43694_81340# VSS 0.04368f
C1183 a_43284_81340# VSS 0.04368f
C1184 a_43427_77929# VSS 21.7087f ; **FLOATING
C1185 a_42014_81340# VSS 0.04368f
C1186 a_41865_77340# VSS 2.31739f ; **FLOATING
C1187 a_41604_81340# VSS 0.04368f
C1188 a_38569_65469# VSS 22.8189f ; **FLOATING
C1189 a_32494_81620# VSS 0.67521f
C1190 a_32345_81680# VSS 3.03738f ; **FLOATING
C1191 a_32084_81620# VSS 0.71057f
C1192 a_22974_81620# VSS 0.67521f
C1193 a_22825_81680# VSS 3.6619f ; **FLOATING
C1194 a_22564_81620# VSS 0.71057f
C1195 a_13454_81620# VSS 0.67521f
C1196 a_13305_81680# VSS 3.47304f ; **FLOATING
C1197 a_13044_81620# VSS 0.71057f
C1198 a_3934_81620# VSS 0.67521f
C1199 a_3785_81680# VSS 3.6619f ; **FLOATING
C1200 a_3524_81620# VSS 0.71057f
C1201 a_35854_85960# VSS 0.13083f
C1202 a_35444_85960# VSS 0.13083f
C1203 a_34174_85960# VSS 0.13083f
C1204 a_33764_85960# VSS 0.13083f
C1205 a_32494_85960# VSS 0.13083f
C1206 a_32084_85960# VSS 0.13083f
C1207 a_26334_85960# VSS 0.13083f
C1208 a_25924_85960# VSS 0.13083f
C1209 a_24654_85960# VSS 0.13083f
C1210 a_24244_85960# VSS 0.13083f
C1211 a_22974_85960# VSS 0.13083f
C1212 a_22564_85960# VSS 0.13083f
C1213 a_16814_85960# VSS 0.13083f
C1214 a_16404_85960# VSS 0.13083f
C1215 a_15134_85960# VSS 0.13083f
C1216 a_14724_85960# VSS 0.13083f
C1217 a_13454_85960# VSS 0.13083f
C1218 a_13044_85960# VSS 0.13083f
C1219 a_7294_85960# VSS 0.13083f
C1220 a_6884_85960# VSS 0.13083f
C1221 a_5614_85960# VSS 0.13083f
C1222 a_5204_85960# VSS 0.13083f
C1223 a_3934_85960# VSS 0.13083f
C1224 a_3524_85960# VSS 0.13083f
C1225 a_3667_78209# VSS 29.4922f ; **FLOATING
C1226 a_32494_91140# VSS 0.13083f
C1227 a_32200_91200# VSS 2.799f ; **FLOATING
C1228 a_32084_91140# VSS 0.13083f
C1229 a_24387_78209# VSS 23.3849f ; **FLOATING
C1230 a_22974_91140# VSS 0.13083f
C1231 a_22680_91200# VSS 2.81297f ; **FLOATING
C1232 a_22564_91140# VSS 0.13083f
C1233 a_12885_64740# VSS 22.7049f ; **FLOATING
C1234 a_13454_91140# VSS 0.13083f
C1235 a_13160_91200# VSS 2.80782f ; **FLOATING
C1236 a_13044_91140# VSS 0.13083f
C1237 a_3934_91140# VSS 0.13083f
C1238 a_3640_91200# VSS 2.59837f ; **FLOATING
C1239 a_3524_91140# VSS 0.13083f
C1240 a_45676_100520# VSS 0.58425f ; **FLOATING
C1241 a_45104_100520# VSS 0.58298f ; **FLOATING
C1242 a_38956_100520# VSS 0.58425f ; **FLOATING
C1243 a_38384_100520# VSS 0.58298f ; **FLOATING
C1244 a_32236_100520# VSS 0.58425f ; **FLOATING
C1245 a_31664_100520# VSS 0.58298f ; **FLOATING
C1246 a_25516_100520# VSS 0.58425f ; **FLOATING
C1247 a_24944_100520# VSS 0.58298f ; **FLOATING
C1248 a_46000_104720# VSS 0.07989f
C1249 a_45104_104720# VSS 0.07989f
C1250 a_32345_77340# VSS 17.6284f ; **FLOATING
C1251 a_39280_104720# VSS 0.07989f
C1252 a_38384_104720# VSS 0.07989f
C1253 a_22825_77340# VSS 21.0134f ; **FLOATING
C1254 a_32560_104720# VSS 0.07989f
C1255 a_31664_104720# VSS 0.07989f
C1256 a_13305_77340# VSS 20.9286f ; **FLOATING
C1257 a_25840_104720# VSS 0.07989f
C1258 a_24944_104720# VSS 0.07989f
C1259 a_3785_77340# VSS 21.9561f ; **FLOATING
C1260 a_3667_82549.t1 VSS 0.15271f ; **FLOATING
C1261 a_3667_82549.t5 VSS 0.14111f ; **FLOATING
C1262 a_3667_82549.t4 VSS 0.157f ; **FLOATING
C1263 a_3667_82549.n0 VSS 2.08307f ; **FLOATING
C1264 a_3667_82549.t3 VSS 6.13148f ; **FLOATING
C1265 a_3667_82549.t2 VSS 3.02984f ; **FLOATING
C1266 a_3667_82549.t0 VSS 0.27369f ; **FLOATING
C1267 a_5347_78209.t1 VSS 0.13894f ; **FLOATING
C1268 a_5347_78209.t5 VSS 0.16549f ; **FLOATING
C1269 a_5347_78209.t3 VSS 0.14507f ; **FLOATING
C1270 a_5347_78209.n0 VSS 2.17f ; **FLOATING
C1271 a_5347_78209.t6 VSS 0.12839f ; **FLOATING
C1272 a_5347_78209.t4 VSS 0.14284f ; **FLOATING
C1273 a_5347_78209.n1 VSS 1.28734f ; **FLOATING
C1274 a_5347_78209.n2 VSS 5.10635f ; **FLOATING
C1275 a_5347_78209.t2 VSS 3.94352f ; **FLOATING
C1276 a_5347_78209.t0 VSS 0.24901f ; **FLOATING
C1277 a_7027_78209.t1 VSS 0.15067f ; **FLOATING
C1278 a_7027_78209.t6 VSS 0.13628f ; **FLOATING
C1279 a_7027_78209.t4 VSS 0.15911f ; **FLOATING
C1280 a_7027_78209.n0 VSS 1.90987f ; **FLOATING
C1281 a_7027_78209.t5 VSS 0.13628f ; **FLOATING
C1282 a_7027_78209.t3 VSS 0.15911f ; **FLOATING
C1283 a_7027_78209.n1 VSS 1.4154f ; **FLOATING
C1284 a_7027_78209.n2 VSS 5.26394f ; **FLOATING
C1285 a_7027_78209.t2 VSS 4.0047f ; **FLOATING
C1286 a_7027_78209.t0 VSS 0.27002f ; **FLOATING
C1287 a_22707_78209.t1 VSS 0.1667f ; **FLOATING
C1288 a_22707_78209.t3 VSS 0.08381f ; **FLOATING
C1289 a_22707_78209.t5 VSS 0.25598f ; **FLOATING
C1290 a_22707_78209.n0 VSS 1.58861f ; **FLOATING
C1291 a_22707_78209.t4 VSS 0.08381f ; **FLOATING
C1292 a_22707_78209.t6 VSS 0.25598f ; **FLOATING
C1293 a_22707_78209.n1 VSS 2.06696f ; **FLOATING
C1294 a_22707_78209.n2 VSS 4.16457f ; **FLOATING
C1295 a_22707_78209.t2 VSS 3.27487f ; **FLOATING
C1296 a_22707_78209.t0 VSS 0.29875f ; **FLOATING
C1297 a_26067_78209.t1 VSS 0.16629f ; **FLOATING
C1298 a_26067_78209.t5 VSS 0.15041f ; **FLOATING
C1299 a_26067_78209.t3 VSS 0.17561f ; **FLOATING
C1300 a_26067_78209.n0 VSS 1.57108f ; **FLOATING
C1301 a_26067_78209.t6 VSS 0.15041f ; **FLOATING
C1302 a_26067_78209.t4 VSS 0.17561f ; **FLOATING
C1303 a_26067_78209.n1 VSS 2.11174f ; **FLOATING
C1304 a_26067_78209.n2 VSS 6.00562f ; **FLOATING
C1305 a_26067_78209.t2 VSS 4.96657f ; **FLOATING
C1306 a_26067_78209.t0 VSS 0.29803f ; **FLOATING
C1307 a_10387_27249.t4 VSS 0.07486f ; **FLOATING
C1308 a_10387_27249.t3 VSS 0.09275f ; **FLOATING
C1309 a_10387_27249.n0 VSS 1.35072f ; **FLOATING
C1310 a_10387_27249.t2 VSS 5.47782f ; **FLOATING
C1311 a_10387_27249.t5 VSS 6.02334f ; **FLOATING
C1312 a_10387_27249.t1 VSS 1.14365f ; **FLOATING
C1313 a_10387_27249.t0 VSS 0.45807f ; **FLOATING
C1314 a_35769_13109.t17 VSS 0.16895f ; **FLOATING
C1315 a_35769_13109.t16 VSS 0.16895f ; **FLOATING
C1316 a_35769_13109.t15 VSS 0.16895f ; **FLOATING
C1317 a_35769_13109.t14 VSS 0.16895f ; **FLOATING
C1318 a_35769_13109.t13 VSS 0.16895f ; **FLOATING
C1319 a_35769_13109.t12 VSS 0.16895f ; **FLOATING
C1320 a_35769_13109.t11 VSS 0.16895f ; **FLOATING
C1321 a_35769_13109.t10 VSS 0.16895f ; **FLOATING
C1322 a_35769_13109.t9 VSS 0.16895f ; **FLOATING
C1323 a_35769_13109.t8 VSS 0.16895f ; **FLOATING
C1324 a_35769_13109.t7 VSS 0.16895f ; **FLOATING
C1325 a_35769_13109.t6 VSS 0.16895f ; **FLOATING
C1326 a_35769_13109.t5 VSS 0.16895f ; **FLOATING
C1327 a_35769_13109.t4 VSS 0.16895f ; **FLOATING
C1328 a_35769_13109.t3 VSS 0.16895f ; **FLOATING
C1329 a_35769_13109.t2 VSS 0.18183f ; **FLOATING
C1330 a_35769_13109.n0 VSS 0.21234f ; **FLOATING
C1331 a_35769_13109.n1 VSS 0.11835f ; **FLOATING
C1332 a_35769_13109.n2 VSS 0.11835f ; **FLOATING
C1333 a_35769_13109.n3 VSS 0.11835f ; **FLOATING
C1334 a_35769_13109.n4 VSS 0.11835f ; **FLOATING
C1335 a_35769_13109.n5 VSS 0.11835f ; **FLOATING
C1336 a_35769_13109.n6 VSS 0.11835f ; **FLOATING
C1337 a_35769_13109.n7 VSS 0.11835f ; **FLOATING
C1338 a_35769_13109.n8 VSS 0.11835f ; **FLOATING
C1339 a_35769_13109.n9 VSS 0.11835f ; **FLOATING
C1340 a_35769_13109.n10 VSS 0.11835f ; **FLOATING
C1341 a_35769_13109.n11 VSS 0.11835f ; **FLOATING
C1342 a_35769_13109.n12 VSS 0.11835f ; **FLOATING
C1343 a_35769_13109.n13 VSS 0.11835f ; **FLOATING
C1344 a_35769_13109.n14 VSS 0.10426f ; **FLOATING
C1345 a_35769_13109.t18 VSS 0.16895f ; **FLOATING
C1346 a_35769_13109.t19 VSS 0.16895f ; **FLOATING
C1347 a_35769_13109.t20 VSS 0.16895f ; **FLOATING
C1348 a_35769_13109.t21 VSS 0.16895f ; **FLOATING
C1349 a_35769_13109.t22 VSS 0.16895f ; **FLOATING
C1350 a_35769_13109.t23 VSS 0.16895f ; **FLOATING
C1351 a_35769_13109.t24 VSS 0.16895f ; **FLOATING
C1352 a_35769_13109.t25 VSS 0.16895f ; **FLOATING
C1353 a_35769_13109.t26 VSS 0.16895f ; **FLOATING
C1354 a_35769_13109.t27 VSS 0.16895f ; **FLOATING
C1355 a_35769_13109.t28 VSS 0.16895f ; **FLOATING
C1356 a_35769_13109.t29 VSS 0.16895f ; **FLOATING
C1357 a_35769_13109.t30 VSS 0.16895f ; **FLOATING
C1358 a_35769_13109.t31 VSS 0.16895f ; **FLOATING
C1359 a_35769_13109.t32 VSS 0.16895f ; **FLOATING
C1360 a_35769_13109.t33 VSS 0.18183f ; **FLOATING
C1361 a_35769_13109.n15 VSS 0.21234f ; **FLOATING
C1362 a_35769_13109.n16 VSS 0.11835f ; **FLOATING
C1363 a_35769_13109.n17 VSS 0.11835f ; **FLOATING
C1364 a_35769_13109.n18 VSS 0.11835f ; **FLOATING
C1365 a_35769_13109.n19 VSS 0.11835f ; **FLOATING
C1366 a_35769_13109.n20 VSS 0.11835f ; **FLOATING
C1367 a_35769_13109.n21 VSS 0.11835f ; **FLOATING
C1368 a_35769_13109.n22 VSS 0.11835f ; **FLOATING
C1369 a_35769_13109.n23 VSS 0.11835f ; **FLOATING
C1370 a_35769_13109.n24 VSS 0.11835f ; **FLOATING
C1371 a_35769_13109.n25 VSS 0.11835f ; **FLOATING
C1372 a_35769_13109.n26 VSS 0.11835f ; **FLOATING
C1373 a_35769_13109.n27 VSS 0.11835f ; **FLOATING
C1374 a_35769_13109.n28 VSS 0.11835f ; **FLOATING
C1375 a_35769_13109.n29 VSS 0.10426f ; **FLOATING
C1376 a_35769_13109.n30 VSS 2.5553f ; **FLOATING
C1377 a_35769_13109.t49 VSS 0.17172f ; **FLOATING
C1378 a_35769_13109.t48 VSS 0.17172f ; **FLOATING
C1379 a_35769_13109.t47 VSS 0.17172f ; **FLOATING
C1380 a_35769_13109.t46 VSS 0.17172f ; **FLOATING
C1381 a_35769_13109.t45 VSS 0.17172f ; **FLOATING
C1382 a_35769_13109.t44 VSS 0.17172f ; **FLOATING
C1383 a_35769_13109.t43 VSS 0.17172f ; **FLOATING
C1384 a_35769_13109.t42 VSS 0.17172f ; **FLOATING
C1385 a_35769_13109.t41 VSS 0.17172f ; **FLOATING
C1386 a_35769_13109.t40 VSS 0.17172f ; **FLOATING
C1387 a_35769_13109.t39 VSS 0.17172f ; **FLOATING
C1388 a_35769_13109.t38 VSS 0.17172f ; **FLOATING
C1389 a_35769_13109.t37 VSS 0.17172f ; **FLOATING
C1390 a_35769_13109.t36 VSS 0.17172f ; **FLOATING
C1391 a_35769_13109.t35 VSS 0.17172f ; **FLOATING
C1392 a_35769_13109.t34 VSS 0.18444f ; **FLOATING
C1393 a_35769_13109.n31 VSS 0.21804f ; **FLOATING
C1394 a_35769_13109.n32 VSS 0.12112f ; **FLOATING
C1395 a_35769_13109.n33 VSS 0.12112f ; **FLOATING
C1396 a_35769_13109.n34 VSS 0.12112f ; **FLOATING
C1397 a_35769_13109.n35 VSS 0.12112f ; **FLOATING
C1398 a_35769_13109.n36 VSS 0.12112f ; **FLOATING
C1399 a_35769_13109.n37 VSS 0.12112f ; **FLOATING
C1400 a_35769_13109.n38 VSS 0.12112f ; **FLOATING
C1401 a_35769_13109.n39 VSS 0.12112f ; **FLOATING
C1402 a_35769_13109.n40 VSS 0.12112f ; **FLOATING
C1403 a_35769_13109.n41 VSS 0.12112f ; **FLOATING
C1404 a_35769_13109.n42 VSS 0.12112f ; **FLOATING
C1405 a_35769_13109.n43 VSS 0.12112f ; **FLOATING
C1406 a_35769_13109.n44 VSS 0.12112f ; **FLOATING
C1407 a_35769_13109.n45 VSS 0.10703f ; **FLOATING
C1408 a_35769_13109.t50 VSS 0.17172f ; **FLOATING
C1409 a_35769_13109.t51 VSS 0.17172f ; **FLOATING
C1410 a_35769_13109.t52 VSS 0.17172f ; **FLOATING
C1411 a_35769_13109.t53 VSS 0.17172f ; **FLOATING
C1412 a_35769_13109.t54 VSS 0.17172f ; **FLOATING
C1413 a_35769_13109.t55 VSS 0.17172f ; **FLOATING
C1414 a_35769_13109.t56 VSS 0.17172f ; **FLOATING
C1415 a_35769_13109.t57 VSS 0.17172f ; **FLOATING
C1416 a_35769_13109.t58 VSS 0.17172f ; **FLOATING
C1417 a_35769_13109.t59 VSS 0.17172f ; **FLOATING
C1418 a_35769_13109.t60 VSS 0.17172f ; **FLOATING
C1419 a_35769_13109.t61 VSS 0.17172f ; **FLOATING
C1420 a_35769_13109.t62 VSS 0.17172f ; **FLOATING
C1421 a_35769_13109.t63 VSS 0.17172f ; **FLOATING
C1422 a_35769_13109.t64 VSS 0.17172f ; **FLOATING
C1423 a_35769_13109.t65 VSS 0.18444f ; **FLOATING
C1424 a_35769_13109.n46 VSS 0.21804f ; **FLOATING
C1425 a_35769_13109.n47 VSS 0.12112f ; **FLOATING
C1426 a_35769_13109.n48 VSS 0.12112f ; **FLOATING
C1427 a_35769_13109.n49 VSS 0.12112f ; **FLOATING
C1428 a_35769_13109.n50 VSS 0.12112f ; **FLOATING
C1429 a_35769_13109.n51 VSS 0.12112f ; **FLOATING
C1430 a_35769_13109.n52 VSS 0.12112f ; **FLOATING
C1431 a_35769_13109.n53 VSS 0.12112f ; **FLOATING
C1432 a_35769_13109.n54 VSS 0.12112f ; **FLOATING
C1433 a_35769_13109.n55 VSS 0.12112f ; **FLOATING
C1434 a_35769_13109.n56 VSS 0.12112f ; **FLOATING
C1435 a_35769_13109.n57 VSS 0.12112f ; **FLOATING
C1436 a_35769_13109.n58 VSS 0.12112f ; **FLOATING
C1437 a_35769_13109.n59 VSS 0.12112f ; **FLOATING
C1438 a_35769_13109.n60 VSS 0.10703f ; **FLOATING
C1439 a_35769_13109.n61 VSS 2.46818f ; **FLOATING
C1440 a_35769_13109.n62 VSS 2.56212f ; **FLOATING
C1441 a_35769_13109.t1 VSS 3.66588f ; **FLOATING
C1442 a_35769_13109.t0 VSS 0.45881f ; **FLOATING
C1443 a_17709_13109.t9 VSS 0.57869f ; **FLOATING
C1444 a_17709_13109.t12 VSS 0.58265f ; **FLOATING
C1445 a_17709_13109.t11 VSS 0.57169f ; **FLOATING
C1446 a_17709_13109.t120 VSS 0.19671f ; **FLOATING
C1447 a_17709_13109.t119 VSS 0.19671f ; **FLOATING
C1448 a_17709_13109.t118 VSS 0.19671f ; **FLOATING
C1449 a_17709_13109.t117 VSS 0.19671f ; **FLOATING
C1450 a_17709_13109.t116 VSS 0.19671f ; **FLOATING
C1451 a_17709_13109.t115 VSS 0.19671f ; **FLOATING
C1452 a_17709_13109.t3 VSS 0.19671f ; **FLOATING
C1453 a_17709_13109.t4 VSS 0.19671f ; **FLOATING
C1454 a_17709_13109.t114 VSS 0.19671f ; **FLOATING
C1455 a_17709_13109.t113 VSS 0.19671f ; **FLOATING
C1456 a_17709_13109.t112 VSS 0.19671f ; **FLOATING
C1457 a_17709_13109.t111 VSS 0.19671f ; **FLOATING
C1458 a_17709_13109.t110 VSS 0.19671f ; **FLOATING
C1459 a_17709_13109.t109 VSS 0.19671f ; **FLOATING
C1460 a_17709_13109.t108 VSS 0.19671f ; **FLOATING
C1461 a_17709_13109.t107 VSS 0.19671f ; **FLOATING
C1462 a_17709_13109.t106 VSS 0.19671f ; **FLOATING
C1463 a_17709_13109.t105 VSS 0.19671f ; **FLOATING
C1464 a_17709_13109.t104 VSS 0.19671f ; **FLOATING
C1465 a_17709_13109.t103 VSS 0.19671f ; **FLOATING
C1466 a_17709_13109.t102 VSS 0.19671f ; **FLOATING
C1467 a_17709_13109.t101 VSS 0.19671f ; **FLOATING
C1468 a_17709_13109.t100 VSS 0.19671f ; **FLOATING
C1469 a_17709_13109.t99 VSS 0.19671f ; **FLOATING
C1470 a_17709_13109.t98 VSS 0.19671f ; **FLOATING
C1471 a_17709_13109.t97 VSS 0.19671f ; **FLOATING
C1472 a_17709_13109.t96 VSS 0.19671f ; **FLOATING
C1473 a_17709_13109.t95 VSS 0.19671f ; **FLOATING
C1474 a_17709_13109.t94 VSS 0.19671f ; **FLOATING
C1475 a_17709_13109.t93 VSS 0.19671f ; **FLOATING
C1476 a_17709_13109.t92 VSS 0.19671f ; **FLOATING
C1477 a_17709_13109.t91 VSS 0.19671f ; **FLOATING
C1478 a_17709_13109.t90 VSS 0.19671f ; **FLOATING
C1479 a_17709_13109.t89 VSS 0.19671f ; **FLOATING
C1480 a_17709_13109.t88 VSS 0.19671f ; **FLOATING
C1481 a_17709_13109.t87 VSS 0.19671f ; **FLOATING
C1482 a_17709_13109.t86 VSS 0.19671f ; **FLOATING
C1483 a_17709_13109.t85 VSS 0.21128f ; **FLOATING
C1484 a_17709_13109.n0 VSS 0.24977f ; **FLOATING
C1485 a_17709_13109.n1 VSS 0.13874f ; **FLOATING
C1486 a_17709_13109.n2 VSS 0.13874f ; **FLOATING
C1487 a_17709_13109.n3 VSS 0.13874f ; **FLOATING
C1488 a_17709_13109.n4 VSS 0.13874f ; **FLOATING
C1489 a_17709_13109.n5 VSS 0.13874f ; **FLOATING
C1490 a_17709_13109.n6 VSS 0.13874f ; **FLOATING
C1491 a_17709_13109.n7 VSS 0.13874f ; **FLOATING
C1492 a_17709_13109.n8 VSS 0.13874f ; **FLOATING
C1493 a_17709_13109.n9 VSS 0.13874f ; **FLOATING
C1494 a_17709_13109.n10 VSS 0.13874f ; **FLOATING
C1495 a_17709_13109.n11 VSS 0.13874f ; **FLOATING
C1496 a_17709_13109.n12 VSS 0.13874f ; **FLOATING
C1497 a_17709_13109.n13 VSS 0.13874f ; **FLOATING
C1498 a_17709_13109.n14 VSS 0.13874f ; **FLOATING
C1499 a_17709_13109.n15 VSS 0.13874f ; **FLOATING
C1500 a_17709_13109.n16 VSS 0.13874f ; **FLOATING
C1501 a_17709_13109.n17 VSS 0.13874f ; **FLOATING
C1502 a_17709_13109.n18 VSS 0.13874f ; **FLOATING
C1503 a_17709_13109.n19 VSS 0.13874f ; **FLOATING
C1504 a_17709_13109.n20 VSS 0.13874f ; **FLOATING
C1505 a_17709_13109.n21 VSS 0.13874f ; **FLOATING
C1506 a_17709_13109.n22 VSS 0.13874f ; **FLOATING
C1507 a_17709_13109.n23 VSS 0.13874f ; **FLOATING
C1508 a_17709_13109.n24 VSS 0.13874f ; **FLOATING
C1509 a_17709_13109.n25 VSS 0.13874f ; **FLOATING
C1510 a_17709_13109.n26 VSS 0.13874f ; **FLOATING
C1511 a_17709_13109.n27 VSS 0.13874f ; **FLOATING
C1512 a_17709_13109.n28 VSS 0.13874f ; **FLOATING
C1513 a_17709_13109.n29 VSS 0.13874f ; **FLOATING
C1514 a_17709_13109.n30 VSS 0.13874f ; **FLOATING
C1515 a_17709_13109.n31 VSS 0.13874f ; **FLOATING
C1516 a_17709_13109.n32 VSS 0.13874f ; **FLOATING
C1517 a_17709_13109.n33 VSS 0.13874f ; **FLOATING
C1518 a_17709_13109.n34 VSS 0.13874f ; **FLOATING
C1519 a_17709_13109.n35 VSS 0.13874f ; **FLOATING
C1520 a_17709_13109.n36 VSS 0.1226f ; **FLOATING
C1521 a_17709_13109.t121 VSS 0.19671f ; **FLOATING
C1522 a_17709_13109.t122 VSS 0.19671f ; **FLOATING
C1523 a_17709_13109.t123 VSS 0.19671f ; **FLOATING
C1524 a_17709_13109.t124 VSS 0.19671f ; **FLOATING
C1525 a_17709_13109.t125 VSS 0.19671f ; **FLOATING
C1526 a_17709_13109.t126 VSS 0.19671f ; **FLOATING
C1527 a_17709_13109.t2 VSS 0.19671f ; **FLOATING
C1528 a_17709_13109.t0 VSS 0.19671f ; **FLOATING
C1529 a_17709_13109.t127 VSS 0.19671f ; **FLOATING
C1530 a_17709_13109.t128 VSS 0.19671f ; **FLOATING
C1531 a_17709_13109.t129 VSS 0.19671f ; **FLOATING
C1532 a_17709_13109.t130 VSS 0.19671f ; **FLOATING
C1533 a_17709_13109.t131 VSS 0.19671f ; **FLOATING
C1534 a_17709_13109.t132 VSS 0.19671f ; **FLOATING
C1535 a_17709_13109.t133 VSS 0.19671f ; **FLOATING
C1536 a_17709_13109.t134 VSS 0.19671f ; **FLOATING
C1537 a_17709_13109.t135 VSS 0.19671f ; **FLOATING
C1538 a_17709_13109.t136 VSS 0.19671f ; **FLOATING
C1539 a_17709_13109.t137 VSS 0.19671f ; **FLOATING
C1540 a_17709_13109.t138 VSS 0.19671f ; **FLOATING
C1541 a_17709_13109.t139 VSS 0.19671f ; **FLOATING
C1542 a_17709_13109.t140 VSS 0.19671f ; **FLOATING
C1543 a_17709_13109.t141 VSS 0.19671f ; **FLOATING
C1544 a_17709_13109.t142 VSS 0.19671f ; **FLOATING
C1545 a_17709_13109.t143 VSS 0.19671f ; **FLOATING
C1546 a_17709_13109.t144 VSS 0.19671f ; **FLOATING
C1547 a_17709_13109.t145 VSS 0.19671f ; **FLOATING
C1548 a_17709_13109.t146 VSS 0.19671f ; **FLOATING
C1549 a_17709_13109.t147 VSS 0.19671f ; **FLOATING
C1550 a_17709_13109.t148 VSS 0.19671f ; **FLOATING
C1551 a_17709_13109.t149 VSS 0.19671f ; **FLOATING
C1552 a_17709_13109.t150 VSS 0.19671f ; **FLOATING
C1553 a_17709_13109.t151 VSS 0.19671f ; **FLOATING
C1554 a_17709_13109.t152 VSS 0.19671f ; **FLOATING
C1555 a_17709_13109.t153 VSS 0.19671f ; **FLOATING
C1556 a_17709_13109.t154 VSS 0.19671f ; **FLOATING
C1557 a_17709_13109.t155 VSS 0.19671f ; **FLOATING
C1558 a_17709_13109.t156 VSS 0.21128f ; **FLOATING
C1559 a_17709_13109.n37 VSS 0.24977f ; **FLOATING
C1560 a_17709_13109.n38 VSS 0.13874f ; **FLOATING
C1561 a_17709_13109.n39 VSS 0.13874f ; **FLOATING
C1562 a_17709_13109.n40 VSS 0.13874f ; **FLOATING
C1563 a_17709_13109.n41 VSS 0.13874f ; **FLOATING
C1564 a_17709_13109.n42 VSS 0.13874f ; **FLOATING
C1565 a_17709_13109.n43 VSS 0.13874f ; **FLOATING
C1566 a_17709_13109.n44 VSS 0.13874f ; **FLOATING
C1567 a_17709_13109.n45 VSS 0.13874f ; **FLOATING
C1568 a_17709_13109.n46 VSS 0.13874f ; **FLOATING
C1569 a_17709_13109.n47 VSS 0.13874f ; **FLOATING
C1570 a_17709_13109.n48 VSS 0.13874f ; **FLOATING
C1571 a_17709_13109.n49 VSS 0.13874f ; **FLOATING
C1572 a_17709_13109.n50 VSS 0.13874f ; **FLOATING
C1573 a_17709_13109.n51 VSS 0.13874f ; **FLOATING
C1574 a_17709_13109.n52 VSS 0.13874f ; **FLOATING
C1575 a_17709_13109.n53 VSS 0.13874f ; **FLOATING
C1576 a_17709_13109.n54 VSS 0.13874f ; **FLOATING
C1577 a_17709_13109.n55 VSS 0.13874f ; **FLOATING
C1578 a_17709_13109.n56 VSS 0.13874f ; **FLOATING
C1579 a_17709_13109.n57 VSS 0.13874f ; **FLOATING
C1580 a_17709_13109.n58 VSS 0.13874f ; **FLOATING
C1581 a_17709_13109.n59 VSS 0.13874f ; **FLOATING
C1582 a_17709_13109.n60 VSS 0.13874f ; **FLOATING
C1583 a_17709_13109.n61 VSS 0.13874f ; **FLOATING
C1584 a_17709_13109.n62 VSS 0.13874f ; **FLOATING
C1585 a_17709_13109.n63 VSS 0.13874f ; **FLOATING
C1586 a_17709_13109.n64 VSS 0.13874f ; **FLOATING
C1587 a_17709_13109.n65 VSS 0.13874f ; **FLOATING
C1588 a_17709_13109.n66 VSS 0.13874f ; **FLOATING
C1589 a_17709_13109.n67 VSS 0.13874f ; **FLOATING
C1590 a_17709_13109.n68 VSS 0.13874f ; **FLOATING
C1591 a_17709_13109.n69 VSS 0.13874f ; **FLOATING
C1592 a_17709_13109.n70 VSS 0.13874f ; **FLOATING
C1593 a_17709_13109.n71 VSS 0.13874f ; **FLOATING
C1594 a_17709_13109.n72 VSS 0.13874f ; **FLOATING
C1595 a_17709_13109.n73 VSS 0.1226f ; **FLOATING
C1596 a_17709_13109.n74 VSS 6.7183f ; **FLOATING
C1597 a_17709_13109.n75 VSS 2.58502f ; **FLOATING
C1598 a_17709_13109.t48 VSS 0.19354f ; **FLOATING
C1599 a_17709_13109.t47 VSS 0.19354f ; **FLOATING
C1600 a_17709_13109.t46 VSS 0.19354f ; **FLOATING
C1601 a_17709_13109.t45 VSS 0.19354f ; **FLOATING
C1602 a_17709_13109.t44 VSS 0.19354f ; **FLOATING
C1603 a_17709_13109.t43 VSS 0.19354f ; **FLOATING
C1604 a_17709_13109.t8 VSS 0.19354f ; **FLOATING
C1605 a_17709_13109.t10 VSS 0.19354f ; **FLOATING
C1606 a_17709_13109.t42 VSS 0.19354f ; **FLOATING
C1607 a_17709_13109.t41 VSS 0.19354f ; **FLOATING
C1608 a_17709_13109.t40 VSS 0.19354f ; **FLOATING
C1609 a_17709_13109.t39 VSS 0.19354f ; **FLOATING
C1610 a_17709_13109.t38 VSS 0.19354f ; **FLOATING
C1611 a_17709_13109.t37 VSS 0.19354f ; **FLOATING
C1612 a_17709_13109.t36 VSS 0.19354f ; **FLOATING
C1613 a_17709_13109.t35 VSS 0.19354f ; **FLOATING
C1614 a_17709_13109.t34 VSS 0.19354f ; **FLOATING
C1615 a_17709_13109.t33 VSS 0.19354f ; **FLOATING
C1616 a_17709_13109.t32 VSS 0.19354f ; **FLOATING
C1617 a_17709_13109.t31 VSS 0.19354f ; **FLOATING
C1618 a_17709_13109.t30 VSS 0.19354f ; **FLOATING
C1619 a_17709_13109.t29 VSS 0.19354f ; **FLOATING
C1620 a_17709_13109.t28 VSS 0.19354f ; **FLOATING
C1621 a_17709_13109.t27 VSS 0.19354f ; **FLOATING
C1622 a_17709_13109.t26 VSS 0.19354f ; **FLOATING
C1623 a_17709_13109.t25 VSS 0.19354f ; **FLOATING
C1624 a_17709_13109.t24 VSS 0.19354f ; **FLOATING
C1625 a_17709_13109.t23 VSS 0.19354f ; **FLOATING
C1626 a_17709_13109.t22 VSS 0.19354f ; **FLOATING
C1627 a_17709_13109.t21 VSS 0.19354f ; **FLOATING
C1628 a_17709_13109.t20 VSS 0.19354f ; **FLOATING
C1629 a_17709_13109.t19 VSS 0.19354f ; **FLOATING
C1630 a_17709_13109.t18 VSS 0.19354f ; **FLOATING
C1631 a_17709_13109.t17 VSS 0.19354f ; **FLOATING
C1632 a_17709_13109.t16 VSS 0.19354f ; **FLOATING
C1633 a_17709_13109.t15 VSS 0.19354f ; **FLOATING
C1634 a_17709_13109.t14 VSS 0.19354f ; **FLOATING
C1635 a_17709_13109.t13 VSS 0.20829f ; **FLOATING
C1636 a_17709_13109.n76 VSS 0.24323f ; **FLOATING
C1637 a_17709_13109.n77 VSS 0.13557f ; **FLOATING
C1638 a_17709_13109.n78 VSS 0.13557f ; **FLOATING
C1639 a_17709_13109.n79 VSS 0.13557f ; **FLOATING
C1640 a_17709_13109.n80 VSS 0.13557f ; **FLOATING
C1641 a_17709_13109.n81 VSS 0.13557f ; **FLOATING
C1642 a_17709_13109.n82 VSS 0.13557f ; **FLOATING
C1643 a_17709_13109.n83 VSS 0.13557f ; **FLOATING
C1644 a_17709_13109.n84 VSS 0.13557f ; **FLOATING
C1645 a_17709_13109.n85 VSS 0.13557f ; **FLOATING
C1646 a_17709_13109.n86 VSS 0.13557f ; **FLOATING
C1647 a_17709_13109.n87 VSS 0.13557f ; **FLOATING
C1648 a_17709_13109.n88 VSS 0.13557f ; **FLOATING
C1649 a_17709_13109.n89 VSS 0.13557f ; **FLOATING
C1650 a_17709_13109.n90 VSS 0.13557f ; **FLOATING
C1651 a_17709_13109.n91 VSS 0.13557f ; **FLOATING
C1652 a_17709_13109.n92 VSS 0.13557f ; **FLOATING
C1653 a_17709_13109.n93 VSS 0.13557f ; **FLOATING
C1654 a_17709_13109.n94 VSS 0.13557f ; **FLOATING
C1655 a_17709_13109.n95 VSS 0.13557f ; **FLOATING
C1656 a_17709_13109.n96 VSS 0.13557f ; **FLOATING
C1657 a_17709_13109.n97 VSS 0.13557f ; **FLOATING
C1658 a_17709_13109.n98 VSS 0.13557f ; **FLOATING
C1659 a_17709_13109.n99 VSS 0.13557f ; **FLOATING
C1660 a_17709_13109.n100 VSS 0.13557f ; **FLOATING
C1661 a_17709_13109.n101 VSS 0.13557f ; **FLOATING
C1662 a_17709_13109.n102 VSS 0.13557f ; **FLOATING
C1663 a_17709_13109.n103 VSS 0.13557f ; **FLOATING
C1664 a_17709_13109.n104 VSS 0.13557f ; **FLOATING
C1665 a_17709_13109.n105 VSS 0.13557f ; **FLOATING
C1666 a_17709_13109.n106 VSS 0.13557f ; **FLOATING
C1667 a_17709_13109.n107 VSS 0.13557f ; **FLOATING
C1668 a_17709_13109.n108 VSS 0.13557f ; **FLOATING
C1669 a_17709_13109.n109 VSS 0.13557f ; **FLOATING
C1670 a_17709_13109.n110 VSS 0.13557f ; **FLOATING
C1671 a_17709_13109.n111 VSS 0.13557f ; **FLOATING
C1672 a_17709_13109.n112 VSS 0.11943f ; **FLOATING
C1673 a_17709_13109.t49 VSS 0.19354f ; **FLOATING
C1674 a_17709_13109.t50 VSS 0.19354f ; **FLOATING
C1675 a_17709_13109.t51 VSS 0.19354f ; **FLOATING
C1676 a_17709_13109.t52 VSS 0.19354f ; **FLOATING
C1677 a_17709_13109.t53 VSS 0.19354f ; **FLOATING
C1678 a_17709_13109.t54 VSS 0.19354f ; **FLOATING
C1679 a_17709_13109.t7 VSS 0.19354f ; **FLOATING
C1680 a_17709_13109.t5 VSS 0.19354f ; **FLOATING
C1681 a_17709_13109.t55 VSS 0.19354f ; **FLOATING
C1682 a_17709_13109.t56 VSS 0.19354f ; **FLOATING
C1683 a_17709_13109.t57 VSS 0.19354f ; **FLOATING
C1684 a_17709_13109.t58 VSS 0.19354f ; **FLOATING
C1685 a_17709_13109.t59 VSS 0.19354f ; **FLOATING
C1686 a_17709_13109.t60 VSS 0.19354f ; **FLOATING
C1687 a_17709_13109.t61 VSS 0.19354f ; **FLOATING
C1688 a_17709_13109.t62 VSS 0.19354f ; **FLOATING
C1689 a_17709_13109.t63 VSS 0.19354f ; **FLOATING
C1690 a_17709_13109.t64 VSS 0.19354f ; **FLOATING
C1691 a_17709_13109.t65 VSS 0.19354f ; **FLOATING
C1692 a_17709_13109.t66 VSS 0.19354f ; **FLOATING
C1693 a_17709_13109.t67 VSS 0.19354f ; **FLOATING
C1694 a_17709_13109.t68 VSS 0.19354f ; **FLOATING
C1695 a_17709_13109.t69 VSS 0.19354f ; **FLOATING
C1696 a_17709_13109.t70 VSS 0.19354f ; **FLOATING
C1697 a_17709_13109.t71 VSS 0.19354f ; **FLOATING
C1698 a_17709_13109.t72 VSS 0.19354f ; **FLOATING
C1699 a_17709_13109.t73 VSS 0.19354f ; **FLOATING
C1700 a_17709_13109.t74 VSS 0.19354f ; **FLOATING
C1701 a_17709_13109.t75 VSS 0.19354f ; **FLOATING
C1702 a_17709_13109.t76 VSS 0.19354f ; **FLOATING
C1703 a_17709_13109.t77 VSS 0.19354f ; **FLOATING
C1704 a_17709_13109.t78 VSS 0.19354f ; **FLOATING
C1705 a_17709_13109.t79 VSS 0.19354f ; **FLOATING
C1706 a_17709_13109.t80 VSS 0.19354f ; **FLOATING
C1707 a_17709_13109.t81 VSS 0.19354f ; **FLOATING
C1708 a_17709_13109.t82 VSS 0.19354f ; **FLOATING
C1709 a_17709_13109.t83 VSS 0.19354f ; **FLOATING
C1710 a_17709_13109.t84 VSS 0.20829f ; **FLOATING
C1711 a_17709_13109.n113 VSS 0.24323f ; **FLOATING
C1712 a_17709_13109.n114 VSS 0.13557f ; **FLOATING
C1713 a_17709_13109.n115 VSS 0.13557f ; **FLOATING
C1714 a_17709_13109.n116 VSS 0.13557f ; **FLOATING
C1715 a_17709_13109.n117 VSS 0.13557f ; **FLOATING
C1716 a_17709_13109.n118 VSS 0.13557f ; **FLOATING
C1717 a_17709_13109.n119 VSS 0.13557f ; **FLOATING
C1718 a_17709_13109.n120 VSS 0.13557f ; **FLOATING
C1719 a_17709_13109.n121 VSS 0.13557f ; **FLOATING
C1720 a_17709_13109.n122 VSS 0.13557f ; **FLOATING
C1721 a_17709_13109.n123 VSS 0.13557f ; **FLOATING
C1722 a_17709_13109.n124 VSS 0.13557f ; **FLOATING
C1723 a_17709_13109.n125 VSS 0.13557f ; **FLOATING
C1724 a_17709_13109.n126 VSS 0.13557f ; **FLOATING
C1725 a_17709_13109.n127 VSS 0.13557f ; **FLOATING
C1726 a_17709_13109.n128 VSS 0.13557f ; **FLOATING
C1727 a_17709_13109.n129 VSS 0.13557f ; **FLOATING
C1728 a_17709_13109.n130 VSS 0.13557f ; **FLOATING
C1729 a_17709_13109.n131 VSS 0.13557f ; **FLOATING
C1730 a_17709_13109.n132 VSS 0.13557f ; **FLOATING
C1731 a_17709_13109.n133 VSS 0.13557f ; **FLOATING
C1732 a_17709_13109.n134 VSS 0.13557f ; **FLOATING
C1733 a_17709_13109.n135 VSS 0.13557f ; **FLOATING
C1734 a_17709_13109.n136 VSS 0.13557f ; **FLOATING
C1735 a_17709_13109.n137 VSS 0.13557f ; **FLOATING
C1736 a_17709_13109.n138 VSS 0.13557f ; **FLOATING
C1737 a_17709_13109.n139 VSS 0.13557f ; **FLOATING
C1738 a_17709_13109.n140 VSS 0.13557f ; **FLOATING
C1739 a_17709_13109.n141 VSS 0.13557f ; **FLOATING
C1740 a_17709_13109.n142 VSS 0.13557f ; **FLOATING
C1741 a_17709_13109.n143 VSS 0.13557f ; **FLOATING
C1742 a_17709_13109.n144 VSS 0.13557f ; **FLOATING
C1743 a_17709_13109.n145 VSS 0.13557f ; **FLOATING
C1744 a_17709_13109.n146 VSS 0.13557f ; **FLOATING
C1745 a_17709_13109.n147 VSS 0.13557f ; **FLOATING
C1746 a_17709_13109.n148 VSS 0.13557f ; **FLOATING
C1747 a_17709_13109.n149 VSS 0.11943f ; **FLOATING
C1748 a_17709_13109.n150 VSS 6.68507f ; **FLOATING
C1749 a_17709_13109.n151 VSS 2.65988f ; **FLOATING
C1750 a_17709_13109.n152 VSS 1.39798f ; **FLOATING
C1751 a_17709_13109.t1 VSS 2.86289f ; **FLOATING
C1752 a_17709_13109.t6 VSS 1.45287f ; **FLOATING
C1753 a_18109_11960.n0 VSS 2.46935f ; **FLOATING
C1754 a_18109_11960.n1 VSS 3.63414f ; **FLOATING
C1755 a_18109_11960.n2 VSS 2.46136f ; **FLOATING
C1756 a_18109_11960.n3 VSS 3.55975f ; **FLOATING
C1757 a_18109_11960.n4 VSS 0.3967f ; **FLOATING
C1758 a_18109_11960.n5 VSS 0.78192f ; **FLOATING
C1759 a_18109_11960.n6 VSS 0.6569f ; **FLOATING
C1760 a_18109_11960.n7 VSS 0.52039f ; **FLOATING
C1761 a_18109_11960.n8 VSS 0.31964f ; **FLOATING
C1762 a_18109_11960.t0 VSS 0.67108f ; **FLOATING
C1763 a_18109_11960.t4 VSS 0.67047f ; **FLOATING
C1764 a_18109_11960.t44 VSS 0.65172f ; **FLOATING
C1765 a_18109_11960.t19 VSS 0.65172f ; **FLOATING
C1766 a_18109_11960.t45 VSS 0.65172f ; **FLOATING
C1767 a_18109_11960.t27 VSS 0.65172f ; **FLOATING
C1768 a_18109_11960.t41 VSS 0.65172f ; **FLOATING
C1769 a_18109_11960.t36 VSS 0.65172f ; **FLOATING
C1770 a_18109_11960.t55 VSS 0.65172f ; **FLOATING
C1771 a_18109_11960.t33 VSS 0.65172f ; **FLOATING
C1772 a_18109_11960.t54 VSS 0.65172f ; **FLOATING
C1773 a_18109_11960.t21 VSS 0.65172f ; **FLOATING
C1774 a_18109_11960.t8 VSS 0.65172f ; **FLOATING
C1775 a_18109_11960.t46 VSS 0.65172f ; **FLOATING
C1776 a_18109_11960.t34 VSS 0.65172f ; **FLOATING
C1777 a_18109_11960.t22 VSS 0.65172f ; **FLOATING
C1778 a_18109_11960.t56 VSS 0.67047f ; **FLOATING
C1779 a_18109_11960.t20 VSS 0.64509f ; **FLOATING
C1780 a_18109_11960.t1 VSS 0.64509f ; **FLOATING
C1781 a_18109_11960.t53 VSS 0.64509f ; **FLOATING
C1782 a_18109_11960.t11 VSS 0.64509f ; **FLOATING
C1783 a_18109_11960.t42 VSS 0.64509f ; **FLOATING
C1784 a_18109_11960.t39 VSS 0.64509f ; **FLOATING
C1785 a_18109_11960.t29 VSS 0.64509f ; **FLOATING
C1786 a_18109_11960.t30 VSS 0.64509f ; **FLOATING
C1787 a_18109_11960.t40 VSS 0.64509f ; **FLOATING
C1788 a_18109_11960.t25 VSS 0.64509f ; **FLOATING
C1789 a_18109_11960.t26 VSS 0.64509f ; **FLOATING
C1790 a_18109_11960.t52 VSS 0.64509f ; **FLOATING
C1791 a_18109_11960.t50 VSS 0.64509f ; **FLOATING
C1792 a_18109_11960.t51 VSS 0.64509f ; **FLOATING
C1793 a_18109_11960.t48 VSS 0.64509f ; **FLOATING
C1794 a_18109_11960.t18 VSS 0.64635f ; **FLOATING
C1795 a_18109_11960.t28 VSS 0.64635f ; **FLOATING
C1796 a_18109_11960.t14 VSS 0.64635f ; **FLOATING
C1797 a_18109_11960.t15 VSS 0.64635f ; **FLOATING
C1798 a_18109_11960.t37 VSS 0.64635f ; **FLOATING
C1799 a_18109_11960.t9 VSS 0.64635f ; **FLOATING
C1800 a_18109_11960.t10 VSS 0.64635f ; **FLOATING
C1801 a_18109_11960.t47 VSS 0.64635f ; **FLOATING
C1802 a_18109_11960.t31 VSS 0.64635f ; **FLOATING
C1803 a_18109_11960.t32 VSS 0.64635f ; **FLOATING
C1804 a_18109_11960.t2 VSS 0.64635f ; **FLOATING
C1805 a_18109_11960.t3 VSS 0.64635f ; **FLOATING
C1806 a_18109_11960.t58 VSS 0.64635f ; **FLOATING
C1807 a_18109_11960.t43 VSS 0.64635f ; **FLOATING
C1808 a_18109_11960.t23 VSS 0.64635f ; **FLOATING
C1809 a_18109_11960.t6 VSS 1.94271f ; **FLOATING
C1810 a_18109_11960.n9 VSS 0.63927f ; **FLOATING
C1811 a_18109_11960.t12 VSS 1.82383f ; **FLOATING
C1812 a_18109_11960.t7 VSS 1.50377f ; **FLOATING
C1813 a_18109_11960.t38 VSS 1.42732f ; **FLOATING
C1814 a_18109_11960.t16 VSS 4.22987f ; **FLOATING
C1815 a_18109_11960.t13 VSS 1.24901f ; **FLOATING
C1816 a_18109_11960.n10 VSS 0.31964f ; **FLOATING
C1817 a_18109_11960.n11 VSS 0.43852f ; **FLOATING
C1818 a_18109_11960.n12 VSS 0.43852f ; **FLOATING
C1819 a_18109_11960.t17 VSS 0.53159f ; **FLOATING
C1820 a_18109_11960.t24 VSS 0.5227f ; **FLOATING
C1821 a_18109_11960.t5 VSS 0.53116f ; **FLOATING
C1822 a_18109_11960.t49 VSS 0.52241f ; **FLOATING
C1823 a_18109_11960.n13 VSS 2.36805f ; **FLOATING
C1824 a_18109_11960.n14 VSS 2.38189f ; **FLOATING
C1825 a_18109_11960.t35 VSS 1.09024f ; **FLOATING
C1826 a_18109_11960.t57 VSS 1.09024f ; **FLOATING
C1827 VR.n0 VSS 5.66559f ; **FLOATING
C1828 VR.n1 VSS 2.75852f ; **FLOATING
C1829 VR.n2 VSS 0.0707f ; **FLOATING
C1830 VR.n3 VSS 0.08213f ; **FLOATING
C1831 VR.n4 VSS 0.0707f ; **FLOATING
C1832 VR.n5 VSS 0.08213f ; **FLOATING
C1833 VR.n6 VSS 0.0707f ; **FLOATING
C1834 VR.n7 VSS 0.08213f ; **FLOATING
C1835 VR.n8 VSS 0.0707f ; **FLOATING
C1836 VR.n9 VSS 0.08213f ; **FLOATING
C1837 VR.n10 VSS 0.04788f ; **FLOATING
C1838 VR.n11 VSS 0.06479f ; **FLOATING
C1839 VR.n12 VSS 0.04788f ; **FLOATING
C1840 VR.n13 VSS 0.06479f ; **FLOATING
C1841 VR.n14 VSS 0.04788f ; **FLOATING
C1842 VR.n15 VSS 0.06479f ; **FLOATING
C1843 VR.n16 VSS 0.04788f ; **FLOATING
C1844 VR.n17 VSS 0.06479f ; **FLOATING
C1845 VR.n18 VSS 0.04788f ; **FLOATING
C1846 VR.n19 VSS 0.06479f ; **FLOATING
C1847 VR.n20 VSS 0.04788f ; **FLOATING
C1848 VR.n21 VSS 0.06479f ; **FLOATING
C1849 VR.n22 VSS 0.04788f ; **FLOATING
C1850 VR.n23 VSS 0.06479f ; **FLOATING
C1851 VR.n24 VSS 0.04788f ; **FLOATING
C1852 VR.n25 VSS 0.06479f ; **FLOATING
C1853 VR.n26 VSS 0.04788f ; **FLOATING
C1854 VR.n27 VSS 0.06479f ; **FLOATING
C1855 VR.n28 VSS 0.04788f ; **FLOATING
C1856 VR.n29 VSS 0.06479f ; **FLOATING
C1857 VR.n30 VSS 0.04788f ; **FLOATING
C1858 VR.n31 VSS 0.06479f ; **FLOATING
C1859 VR.n32 VSS 0.04788f ; **FLOATING
C1860 VR.n33 VSS 0.06479f ; **FLOATING
C1861 VR.n34 VSS 0.23941f ; **FLOATING
C1862 VR.n35 VSS 0.54913f ; **FLOATING
C1863 VR.n36 VSS 0.23941f ; **FLOATING
C1864 VR.n37 VSS 0.39142f ; **FLOATING
C1865 VR.n38 VSS 0.23941f ; **FLOATING
C1866 VR.n39 VSS 0.39142f ; **FLOATING
C1867 VR.n40 VSS 0.23941f ; **FLOATING
C1868 VR.n41 VSS 0.39142f ; **FLOATING
C1869 VR.t24 VSS 0.26433f ; **FLOATING
C1870 VR.t130 VSS 0.26433f ; **FLOATING
C1871 VR.n42 VSS 0.26423f ; **FLOATING
C1872 VR.n44 VSS 0.26423f ; **FLOATING
C1873 VR.n46 VSS 0.26423f ; **FLOATING
C1874 VR.n48 VSS 0.26423f ; **FLOATING
C1875 VR.n50 VSS 0.26423f ; **FLOATING
C1876 VR.n52 VSS 0.26423f ; **FLOATING
C1877 VR.n54 VSS 0.26423f ; **FLOATING
C1878 VR.n56 VSS 0.26423f ; **FLOATING
C1879 VR.n58 VSS 0.04426f ; **FLOATING
C1880 VR.n59 VSS 0.04426f ; **FLOATING
C1881 VR.n60 VSS 0.04426f ; **FLOATING
C1882 VR.n61 VSS 0.04426f ; **FLOATING
C1883 VR.n62 VSS 0.19081f ; **FLOATING
C1884 VR.n63 VSS 0.99794f ; **FLOATING
C1885 VR.t123 VSS 0.07382f ; **FLOATING
C1886 VR.t124 VSS 0.07268f ; **FLOATING
C1887 VR.t175 VSS 0.07268f ; **FLOATING
C1888 VR.t118 VSS 0.07268f ; **FLOATING
C1889 VR.t119 VSS 0.07268f ; **FLOATING
C1890 VR.t185 VSS 0.07268f ; **FLOATING
C1891 VR.t113 VSS 0.07268f ; **FLOATING
C1892 VR.t114 VSS 0.07268f ; **FLOATING
C1893 VR.t237 VSS 0.07268f ; **FLOATING
C1894 VR.t178 VSS 0.07268f ; **FLOATING
C1895 VR.t52 VSS 0.07268f ; **FLOATING
C1896 VR.t53 VSS 0.07268f ; **FLOATING
C1897 VR.t311 VSS 0.07268f ; **FLOATING
C1898 VR.t219 VSS 0.07268f ; **FLOATING
C1899 VR.t220 VSS 0.07268f ; **FLOATING
C1900 VR.t132 VSS 0.07284f ; **FLOATING
C1901 VR.t78 VSS 0.07397f ; **FLOATING
C1902 VR.t47 VSS 0.07281f ; **FLOATING
C1903 VR.t235 VSS 0.07281f ; **FLOATING
C1904 VR.t115 VSS 0.07281f ; **FLOATING
C1905 VR.t218 VSS 0.07281f ; **FLOATING
C1906 VR.t200 VSS 0.07281f ; **FLOATING
C1907 VR.t201 VSS 0.07281f ; **FLOATING
C1908 VR.t176 VSS 0.07281f ; **FLOATING
C1909 VR.t177 VSS 0.07281f ; **FLOATING
C1910 VR.t217 VSS 0.07281f ; **FLOATING
C1911 VR.t171 VSS 0.07281f ; **FLOATING
C1912 VR.t172 VSS 0.07281f ; **FLOATING
C1913 VR.t252 VSS 0.07281f ; **FLOATING
C1914 VR.t251 VSS 0.07281f ; **FLOATING
C1915 VR.t241 VSS 0.07281f ; **FLOATING
C1916 VR.t242 VSS 0.07297f ; **FLOATING
C1917 VR.t181 VSS 0.07531f ; **FLOATING
C1918 VR.t121 VSS 0.07323f ; **FLOATING
C1919 VR.t186 VSS 0.07323f ; **FLOATING
C1920 VR.t116 VSS 0.07323f ; **FLOATING
C1921 VR.t199 VSS 0.07323f ; **FLOATING
C1922 VR.t302 VSS 0.07323f ; **FLOATING
C1923 VR.t98 VSS 0.07323f ; **FLOATING
C1924 VR.t307 VSS 0.07323f ; **FLOATING
C1925 VR.t183 VSS 0.07323f ; **FLOATING
C1926 VR.t126 VSS 0.07323f ; **FLOATING
C1927 VR.t117 VSS 0.07323f ; **FLOATING
C1928 VR.t179 VSS 0.07323f ; **FLOATING
C1929 VR.t174 VSS 0.07323f ; **FLOATING
C1930 VR.t125 VSS 0.07323f ; **FLOATING
C1931 VR.t122 VSS 0.07323f ; **FLOATING
C1932 VR.t180 VSS 0.07531f ; **FLOATING
C1933 VR.t77 VSS 0.0754f ; **FLOATING
C1934 VR.t221 VSS 0.07331f ; **FLOATING
C1935 VR.t303 VSS 0.07331f ; **FLOATING
C1936 VR.t127 VSS 0.07331f ; **FLOATING
C1937 VR.t173 VSS 0.07331f ; **FLOATING
C1938 VR.t287 VSS 0.07331f ; **FLOATING
C1939 VR.t120 VSS 0.07331f ; **FLOATING
C1940 VR.t184 VSS 0.07331f ; **FLOATING
C1941 VR.t308 VSS 0.07331f ; **FLOATING
C1942 VR.t304 VSS 0.07331f ; **FLOATING
C1943 VR.t128 VSS 0.07331f ; **FLOATING
C1944 VR.t112 VSS 0.07331f ; **FLOATING
C1945 VR.t236 VSS 0.07331f ; **FLOATING
C1946 VR.t182 VSS 0.07331f ; **FLOATING
C1947 VR.t129 VSS 0.07331f ; **FLOATING
C1948 VR.t222 VSS 0.0754f ; **FLOATING
C1949 VR.t96 VSS 0.07397f ; **FLOATING
C1950 VR.t95 VSS 0.07281f ; **FLOATING
C1951 VR.t94 VSS 0.07281f ; **FLOATING
C1952 VR.t93 VSS 0.07281f ; **FLOATING
C1953 VR.t92 VSS 0.07281f ; **FLOATING
C1954 VR.t91 VSS 0.07281f ; **FLOATING
C1955 VR.t90 VSS 0.07281f ; **FLOATING
C1956 VR.t89 VSS 0.07297f ; **FLOATING
C1957 VR.n72 VSS 0.39845f ; **FLOATING
C1958 VR.n73 VSS 0.34491f ; **FLOATING
C1959 VR.n74 VSS 0.05826f ; **FLOATING
C1960 VR.n75 VSS 0.39845f ; **FLOATING
C1961 VR.n76 VSS 0.34491f ; **FLOATING
C1962 VR.n77 VSS 0.05826f ; **FLOATING
C1963 VR.n78 VSS 0.39845f ; **FLOATING
C1964 VR.n79 VSS 0.34491f ; **FLOATING
C1965 VR.n80 VSS 0.05826f ; **FLOATING
C1966 VR.n81 VSS 0.39845f ; **FLOATING
C1967 VR.n82 VSS 0.34491f ; **FLOATING
C1968 VR.n83 VSS 0.05826f ; **FLOATING
C1969 VR.n84 VSS 0.04368f ; **FLOATING
C1970 VR.n85 VSS 0.22126f ; **FLOATING
C1971 VR.n86 VSS 0.04256f ; **FLOATING
C1972 VR.n87 VSS 0.04368f ; **FLOATING
C1973 VR.n88 VSS 0.22126f ; **FLOATING
C1974 VR.n89 VSS 0.04256f ; **FLOATING
C1975 VR.n90 VSS 0.03757f ; **FLOATING
C1976 VR.n91 VSS 0.18019f ; **FLOATING
C1977 VR.n92 VSS 0.03703f ; **FLOATING
C1978 VR.n93 VSS 0.04368f ; **FLOATING
C1979 VR.n94 VSS 0.22126f ; **FLOATING
C1980 VR.n95 VSS 0.04256f ; **FLOATING
C1981 VR.n96 VSS 0.03757f ; **FLOATING
C1982 VR.n97 VSS 0.18019f ; **FLOATING
C1983 VR.n98 VSS 0.03703f ; **FLOATING
C1984 VR.n99 VSS 0.03757f ; **FLOATING
C1985 VR.n100 VSS 0.18019f ; **FLOATING
C1986 VR.n101 VSS 0.03703f ; **FLOATING
C1987 VR.n102 VSS 0.03757f ; **FLOATING
C1988 VR.n103 VSS 0.18019f ; **FLOATING
C1989 VR.n104 VSS 0.03703f ; **FLOATING
C1990 VR.n105 VSS 0.03757f ; **FLOATING
C1991 VR.n106 VSS 0.18019f ; **FLOATING
C1992 VR.n107 VSS 0.03703f ; **FLOATING
C1993 VR.n108 VSS 0.03757f ; **FLOATING
C1994 VR.n109 VSS 0.18019f ; **FLOATING
C1995 VR.n110 VSS 0.03703f ; **FLOATING
C1996 VR.n111 VSS 0.04368f ; **FLOATING
C1997 VR.n112 VSS 0.22126f ; **FLOATING
C1998 VR.n113 VSS 0.04256f ; **FLOATING
C1999 VR.n114 VSS 0.04368f ; **FLOATING
C2000 VR.n115 VSS 0.22126f ; **FLOATING
C2001 VR.n116 VSS 0.04256f ; **FLOATING
C2002 VR.n117 VSS 0.03757f ; **FLOATING
C2003 VR.n118 VSS 0.18019f ; **FLOATING
C2004 VR.n119 VSS 0.03703f ; **FLOATING
C2005 VR.n120 VSS 0.03757f ; **FLOATING
C2006 VR.n121 VSS 0.18019f ; **FLOATING
C2007 VR.n122 VSS 0.03703f ; **FLOATING
C2008 VR.n123 VSS 0.04368f ; **FLOATING
C2009 VR.n124 VSS 0.22126f ; **FLOATING
C2010 VR.n125 VSS 0.04256f ; **FLOATING
C2011 VR.n126 VSS 0.04368f ; **FLOATING
C2012 VR.n127 VSS 0.22126f ; **FLOATING
C2013 VR.n128 VSS 0.04256f ; **FLOATING
C2014 VR.n129 VSS 0.04368f ; **FLOATING
C2015 VR.n130 VSS 0.22126f ; **FLOATING
C2016 VR.n131 VSS 0.04256f ; **FLOATING
C2017 VR.n132 VSS 0.22665f ; **FLOATING
C2018 VR.n133 VSS 0.19218f ; **FLOATING
C2019 VR.n134 VSS 0.03855f ; **FLOATING
C2020 VR.n135 VSS 0.22665f ; **FLOATING
C2021 VR.n136 VSS 0.19218f ; **FLOATING
C2022 VR.n137 VSS 0.03855f ; **FLOATING
C2023 VR.n138 VSS 0.22665f ; **FLOATING
C2024 VR.n139 VSS 0.19218f ; **FLOATING
C2025 VR.n140 VSS 0.03855f ; **FLOATING
C2026 VR.n141 VSS 0.22665f ; **FLOATING
C2027 VR.n142 VSS 0.19218f ; **FLOATING
C2028 VR.n143 VSS 0.03855f ; **FLOATING
C2029 VR.n144 VSS 0.22665f ; **FLOATING
C2030 VR.n145 VSS 0.19218f ; **FLOATING
C2031 VR.n146 VSS 0.03855f ; **FLOATING
C2032 VR.n147 VSS 0.22665f ; **FLOATING
C2033 VR.n148 VSS 0.19218f ; **FLOATING
C2034 VR.n149 VSS 0.03855f ; **FLOATING
C2035 VR.n150 VSS 0.22665f ; **FLOATING
C2036 VR.n151 VSS 0.19218f ; **FLOATING
C2037 VR.n152 VSS 0.03855f ; **FLOATING
C2038 VR.n153 VSS 0.22665f ; **FLOATING
C2039 VR.n154 VSS 0.19218f ; **FLOATING
C2040 VR.n155 VSS 0.03855f ; **FLOATING
C2041 VR.n156 VSS 0.04368f ; **FLOATING
C2042 VR.n157 VSS 0.22126f ; **FLOATING
C2043 VR.n158 VSS 0.04256f ; **FLOATING
C2044 VR.n159 VSS 0.04368f ; **FLOATING
C2045 VR.n160 VSS 0.22126f ; **FLOATING
C2046 VR.n161 VSS 0.04256f ; **FLOATING
C2047 VR.n162 VSS 0.04368f ; **FLOATING
C2048 VR.n163 VSS 0.22126f ; **FLOATING
C2049 VR.n164 VSS 0.04256f ; **FLOATING
C2050 VR.n165 VSS 0.39845f ; **FLOATING
C2051 VR.n166 VSS 0.34491f ; **FLOATING
C2052 VR.n167 VSS 0.05826f ; **FLOATING
C2053 VR.n168 VSS 0.39845f ; **FLOATING
C2054 VR.n169 VSS 0.34491f ; **FLOATING
C2055 VR.n170 VSS 0.05826f ; **FLOATING
C2056 VR.n171 VSS 0.39845f ; **FLOATING
C2057 VR.n172 VSS 0.34491f ; **FLOATING
C2058 VR.n173 VSS 0.05826f ; **FLOATING
C2059 VR.n174 VSS 0.39845f ; **FLOATING
C2060 VR.n175 VSS 0.34491f ; **FLOATING
C2061 VR.n176 VSS 0.05826f ; **FLOATING
C2062 VR.n177 VSS 0.03757f ; **FLOATING
C2063 VR.n178 VSS 0.18019f ; **FLOATING
C2064 VR.n179 VSS 0.03703f ; **FLOATING
C2065 VR.n180 VSS 0.03757f ; **FLOATING
C2066 VR.n181 VSS 0.18019f ; **FLOATING
C2067 VR.n182 VSS 0.03703f ; **FLOATING
C2068 VR.n183 VSS 0.04368f ; **FLOATING
C2069 VR.n184 VSS 0.22126f ; **FLOATING
C2070 VR.n185 VSS 0.04256f ; **FLOATING
C2071 VR.n186 VSS 0.03757f ; **FLOATING
C2072 VR.n187 VSS 0.18019f ; **FLOATING
C2073 VR.n188 VSS 0.03703f ; **FLOATING
C2074 VR.n189 VSS 0.03757f ; **FLOATING
C2075 VR.n190 VSS 0.18019f ; **FLOATING
C2076 VR.n191 VSS 0.03703f ; **FLOATING
C2077 VR.n192 VSS 0.04368f ; **FLOATING
C2078 VR.n193 VSS 0.22126f ; **FLOATING
C2079 VR.n194 VSS 0.04256f ; **FLOATING
C2080 VR.n195 VSS 0.19081f ; **FLOATING
C2081 VR.n196 VSS 0.19146f ; **FLOATING
C2082 VR.n197 VSS 0.16504f ; **FLOATING
C2083 VR.n198 VSS 0.16504f ; **FLOATING
C2084 VR.n199 VSS 2.5161f ; **FLOATING
C2085 VR.n200 VSS 2.5161f ; **FLOATING
C2086 VR.n201 VSS 2.5161f ; **FLOATING
C2087 VR.n202 VSS 2.5161f ; **FLOATING
C2088 VR.t163 VSS 0.23995f ; **FLOATING
C2089 VR.n203 VSS 0.05056f ; **FLOATING
C2090 VR.t10 VSS 0.23995f ; **FLOATING
C2091 VR.n204 VSS 0.05056f ; **FLOATING
C2092 VR.t263 VSS 0.23995f ; **FLOATING
C2093 VR.n205 VSS 0.05056f ; **FLOATING
C2094 VR.t133 VSS 0.23995f ; **FLOATING
C2095 VR.n206 VSS 0.05056f ; **FLOATING
C2096 VR.t20 VSS 0.23995f ; **FLOATING
C2097 VR.n207 VSS 0.05056f ; **FLOATING
C2098 VR.t87 VSS 0.23995f ; **FLOATING
C2099 VR.n208 VSS 0.05056f ; **FLOATING
C2100 VR.t146 VSS 0.23995f ; **FLOATING
C2101 VR.n209 VSS 0.05056f ; **FLOATING
C2102 VR.t109 VSS 0.23995f ; **FLOATING
C2103 VR.n210 VSS 0.05056f ; **FLOATING
C2104 VR.t231 VSS 0.23995f ; **FLOATING
C2105 VR.n211 VSS 0.05056f ; **FLOATING
C2106 VR.t318 VSS 0.23995f ; **FLOATING
C2107 VR.n212 VSS 0.05056f ; **FLOATING
C2108 VR.t292 VSS 0.23995f ; **FLOATING
C2109 VR.n213 VSS 0.05056f ; **FLOATING
C2110 VR.t151 VSS 0.23995f ; **FLOATING
C2111 VR.n214 VSS 0.05056f ; **FLOATING
C2112 VR.t205 VSS 0.23995f ; **FLOATING
C2113 VR.n215 VSS 0.05056f ; **FLOATING
C2114 VR.t187 VSS 0.23995f ; **FLOATING
C2115 VR.n216 VSS 0.05056f ; **FLOATING
C2116 VR.t268 VSS 0.23995f ; **FLOATING
C2117 VR.n217 VSS 0.05056f ; **FLOATING
C2118 VR.t279 VSS 0.23995f ; **FLOATING
C2119 VR.n218 VSS 0.05056f ; **FLOATING
C2120 VR.t56 VSS 0.23995f ; **FLOATING
C2121 VR.n219 VSS 0.05056f ; **FLOATING
C2122 VR.t69 VSS 0.23995f ; **FLOATING
C2123 VR.n220 VSS 0.05056f ; **FLOATING
C2124 VR.n221 VSS 0.05051f ; **FLOATING
C2125 VR.n222 VSS 0.05051f ; **FLOATING
C2126 VR.n223 VSS 0.0673f ; **FLOATING
C2127 VR.n224 VSS 0.05051f ; **FLOATING
C2128 VR.n225 VSS 0.05051f ; **FLOATING
C2129 VR.n226 VSS 0.0673f ; **FLOATING
C2130 VR.n227 VSS 0.05051f ; **FLOATING
C2131 VR.n228 VSS 0.05051f ; **FLOATING
C2132 VR.n229 VSS 0.0673f ; **FLOATING
C2133 VR.n230 VSS 0.05051f ; **FLOATING
C2134 VR.n231 VSS 0.05051f ; **FLOATING
C2135 VR.n232 VSS 0.05051f ; **FLOATING
C2136 VR.n233 VSS 0.05051f ; **FLOATING
C2137 VR.n234 VSS 0.05051f ; **FLOATING
C2138 VR.n235 VSS 0.05051f ; **FLOATING
C2139 VR.n236 VSS 0.05051f ; **FLOATING
C2140 VR.n237 VSS 0.05051f ; **FLOATING
C2141 VR.n238 VSS 0.0673f ; **FLOATING
C2142 VR.n239 VSS 0.05051f ; **FLOATING
C2143 VR.n240 VSS 0.05051f ; **FLOATING
C2144 VR.n241 VSS 0.0673f ; **FLOATING
C2145 VR.n242 VSS 0.05051f ; **FLOATING
C2146 VR.n243 VSS 0.05051f ; **FLOATING
C2147 VR.n244 VSS 4.90617f ; **FLOATING
C2148 VR.n245 VSS 0.11417f ; **FLOATING
C2149 VR.n246 VSS 0.11954f ; **FLOATING
C2150 VR.n247 VSS 0.04788f ; **FLOATING
C2151 VR.n248 VSS 0.21386f ; **FLOATING
C2152 VR.n249 VSS 0.04788f ; **FLOATING
C2153 VR.n250 VSS 0.21386f ; **FLOATING
C2154 VR.n251 VSS 0.04788f ; **FLOATING
C2155 VR.n252 VSS 0.21386f ; **FLOATING
C2156 VR.n253 VSS 0.04788f ; **FLOATING
C2157 VR.n254 VSS 0.21386f ; **FLOATING
C2158 VR.n255 VSS 0.04788f ; **FLOATING
C2159 VR.n256 VSS 0.21386f ; **FLOATING
C2160 VR.n257 VSS 0.0707f ; **FLOATING
C2161 VR.n258 VSS 0.25571f ; **FLOATING
C2162 VR.n259 VSS 0.0707f ; **FLOATING
C2163 VR.n260 VSS 0.25571f ; **FLOATING
C2164 VR.n261 VSS 0.0707f ; **FLOATING
C2165 VR.n262 VSS 0.25571f ; **FLOATING
C2166 VR.n263 VSS 0.0707f ; **FLOATING
C2167 VR.n264 VSS 0.25571f ; **FLOATING
C2168 VR.n265 VSS 0.04788f ; **FLOATING
C2169 VR.n266 VSS 0.21386f ; **FLOATING
C2170 VR.n267 VSS 0.04788f ; **FLOATING
C2171 VR.n268 VSS 0.21386f ; **FLOATING
C2172 VR.n269 VSS 0.04788f ; **FLOATING
C2173 VR.n270 VSS 0.21386f ; **FLOATING
C2174 VR.n271 VSS 0.04788f ; **FLOATING
C2175 VR.n272 VSS 0.21386f ; **FLOATING
C2176 VR.n273 VSS 0.04788f ; **FLOATING
C2177 VR.n274 VSS 0.21386f ; **FLOATING
C2178 VR.n275 VSS 0.04788f ; **FLOATING
C2179 VR.n276 VSS 0.21386f ; **FLOATING
C2180 VR.n277 VSS 0.04788f ; **FLOATING
C2181 VR.n278 VSS 0.21386f ; **FLOATING
C2182 VR.t305 VSS 0.19221f ; **FLOATING
C2183 VR.n279 VSS 0.04302f ; **FLOATING
C2184 VR.t261 VSS 0.19221f ; **FLOATING
C2185 VR.n280 VSS 0.04302f ; **FLOATING
C2186 VR.t143 VSS 0.19221f ; **FLOATING
C2187 VR.n281 VSS 0.04302f ; **FLOATING
C2188 VR.t21 VSS 0.19221f ; **FLOATING
C2189 VR.n282 VSS 0.04302f ; **FLOATING
C2190 VR.t26 VSS 0.19221f ; **FLOATING
C2191 VR.n283 VSS 0.04302f ; **FLOATING
C2192 VR.t238 VSS 0.19221f ; **FLOATING
C2193 VR.n284 VSS 0.04302f ; **FLOATING
C2194 VR.t312 VSS 0.19221f ; **FLOATING
C2195 VR.n285 VSS 0.04302f ; **FLOATING
C2196 VR.t107 VSS 0.19221f ; **FLOATING
C2197 VR.n286 VSS 0.04302f ; **FLOATING
C2198 VR.t266 VSS 0.19221f ; **FLOATING
C2199 VR.n287 VSS 0.04302f ; **FLOATING
C2200 VR.t275 VSS 0.19221f ; **FLOATING
C2201 VR.n288 VSS 0.04302f ; **FLOATING
C2202 VR.t54 VSS 0.19221f ; **FLOATING
C2203 VR.n289 VSS 0.04302f ; **FLOATING
C2204 VR.t71 VSS 0.19221f ; **FLOATING
C2205 VR.n290 VSS 0.04302f ; **FLOATING
C2206 VR.n291 VSS 0.04297f ; **FLOATING
C2207 VR.n292 VSS 0.04297f ; **FLOATING
C2208 VR.n293 VSS 0.04297f ; **FLOATING
C2209 VR.n294 VSS 0.04297f ; **FLOATING
C2210 VR.n295 VSS 0.04297f ; **FLOATING
C2211 VR.n296 VSS 0.04297f ; **FLOATING
C2212 VR.n297 VSS 0.04297f ; **FLOATING
C2213 VR.n298 VSS 0.04297f ; **FLOATING
C2214 VR.n299 VSS 0.04297f ; **FLOATING
C2215 VR.n300 VSS 0.04297f ; **FLOATING
C2216 VR.n301 VSS 0.04297f ; **FLOATING
C2217 VR.n302 VSS 0.04297f ; **FLOATING
C2218 VR.n303 VSS 3.42823f ; **FLOATING
C2219 VR.n304 VSS 0.87939f ; **FLOATING
C2220 VR.n305 VSS 6.0132f ; **FLOATING
C2221 VR.t159 VSS 0.15084f ; **FLOATING
C2222 VR.t147 VSS 0.15084f ; **FLOATING
C2223 VR.t12 VSS 0.15084f ; **FLOATING
C2224 VR.t290 VSS 0.15084f ; **FLOATING
C2225 VR.t189 VSS 0.15084f ; **FLOATING
C2226 VR.t207 VSS 0.15084f ; **FLOATING
C2227 VR.t225 VSS 0.15084f ; **FLOATING
C2228 VR.t320 VSS 0.15084f ; **FLOATING
C2229 VR.n306 VSS 0.15077f ; **FLOATING
C2230 VR.n308 VSS 0.15077f ; **FLOATING
C2231 VR.n310 VSS 0.15077f ; **FLOATING
C2232 VR.n312 VSS 0.15077f ; **FLOATING
C2233 VR.n314 VSS 0.15077f ; **FLOATING
C2234 VR.n316 VSS 0.15077f ; **FLOATING
C2235 VR.n318 VSS 0.15077f ; **FLOATING
C2236 VR.n320 VSS 0.15077f ; **FLOATING
C2237 VR.t329 VSS 33.64f ; **FLOATING
C2238 VR.t328 VSS 4.27104f ; **FLOATING
C2239 VR.n322 VSS 0.06847f ; **FLOATING
C2240 VR.t97 VSS 1.96379f ; **FLOATING
C2241 VR.n323 VSS 0.07272f ; **FLOATING
C2242 VR.t50 VSS 0.19161f ; **FLOATING
C2243 VR.t51 VSS 0.09742f ; **FLOATING
C2244 VR.n324 VSS 0.09429f ; **FLOATING
C2245 VR.n325 VSS 0.0746f ; **FLOATING
C2246 VR.n326 VSS 0.18601f ; **FLOATING
C2247 VR.n327 VSS 0.07272f ; **FLOATING
C2248 VR.t29 VSS 0.19161f ; **FLOATING
C2249 VR.t30 VSS 0.09742f ; **FLOATING
C2250 VR.n328 VSS 0.09429f ; **FLOATING
C2251 VR.n329 VSS 0.0746f ; **FLOATING
C2252 VR.n330 VSS 0.09854f ; **FLOATING
C2253 VR.t310 VSS 1.18387f ; **FLOATING
C2254 VR.n331 VSS 10.2154f ; **FLOATING
C2255 VR.n332 VSS 0.05856f ; **FLOATING
C2256 VR.t265 VSS 0.03548f ; **FLOATING
C2257 VR.t272 VSS 0.03579f ; **FLOATING
C2258 VR.t274 VSS 0.03548f ; **FLOATING
C2259 VR.n333 VSS 0.08554f ; **FLOATING
C2260 VR.n334 VSS 0.05851f ; **FLOATING
C2261 VR.n335 VSS 0.21386f ; **FLOATING
C2262 VR.t273 VSS 0.15865f ; **FLOATING
C2263 VR.t271 VSS 0.0759f ; **FLOATING
C2264 VR.n336 VSS 0.0506f ; **FLOATING
C2265 VR.t269 VSS 0.0759f ; **FLOATING
C2266 VR.t264 VSS 0.15865f ; **FLOATING
C2267 VR.n337 VSS 3.00147f ; **FLOATING
C2268 VR.n338 VSS 0.22126f ; **FLOATING
C2269 VR.t164 VSS 0.04602f ; **FLOATING
C2270 VR.n339 VSS 0.09245f ; **FLOATING
C2271 VR.n340 VSS 0.05789f ; **FLOATING
C2272 VR.n341 VSS 1.63402f ; **FLOATING
C2273 VR.n342 VSS 4.82131f ; **FLOATING
C2274 VR.t192 VSS 0.03548f ; **FLOATING
C2275 VR.t196 VSS 0.03579f ; **FLOATING
C2276 VR.t198 VSS 0.03548f ; **FLOATING
C2277 VR.t210 VSS 0.03548f ; **FLOATING
C2278 VR.t214 VSS 0.03579f ; **FLOATING
C2279 VR.t216 VSS 0.03548f ; **FLOATING
C2280 VR.n343 VSS 0.25571f ; **FLOATING
C2281 VR.t215 VSS 0.17738f ; **FLOATING
C2282 VR.t213 VSS 0.11619f ; **FLOATING
C2283 VR.t211 VSS 0.11619f ; **FLOATING
C2284 VR.t209 VSS 0.12962f ; **FLOATING
C2285 VR.t197 VSS 0.12962f ; **FLOATING
C2286 VR.t195 VSS 0.11619f ; **FLOATING
C2287 VR.t193 VSS 0.11619f ; **FLOATING
C2288 VR.t191 VSS 0.17738f ; **FLOATING
C2289 VR.t321 VSS 0.02271f ; **FLOATING
C2290 VR.n344 VSS 0.03821f ; **FLOATING
C2291 VR.n345 VSS 0.05622f ; **FLOATING
C2292 VR.n346 VSS 0.08565f ; **FLOATING
C2293 VR.t226 VSS 0.02271f ; **FLOATING
C2294 VR.n347 VSS 0.03821f ; **FLOATING
C2295 VR.n348 VSS 0.05622f ; **FLOATING
C2296 VR.n349 VSS 0.08565f ; **FLOATING
C2297 VR.t150 VSS 0.03548f ; **FLOATING
C2298 VR.t156 VSS 0.03579f ; **FLOATING
C2299 VR.t158 VSS 0.03548f ; **FLOATING
C2300 VR.t162 VSS 0.03548f ; **FLOATING
C2301 VR.t168 VSS 0.03579f ; **FLOATING
C2302 VR.t170 VSS 0.03548f ; **FLOATING
C2303 VR.n350 VSS 0.25571f ; **FLOATING
C2304 VR.t169 VSS 0.17738f ; **FLOATING
C2305 VR.t167 VSS 0.11619f ; **FLOATING
C2306 VR.t165 VSS 0.11619f ; **FLOATING
C2307 VR.t161 VSS 0.12962f ; **FLOATING
C2308 VR.t157 VSS 0.12962f ; **FLOATING
C2309 VR.t155 VSS 0.11619f ; **FLOATING
C2310 VR.t153 VSS 0.11619f ; **FLOATING
C2311 VR.t149 VSS 0.17738f ; **FLOATING
C2312 VR.t208 VSS 0.02271f ; **FLOATING
C2313 VR.n351 VSS 0.03821f ; **FLOATING
C2314 VR.n352 VSS 0.05622f ; **FLOATING
C2315 VR.n353 VSS 0.08565f ; **FLOATING
C2316 VR.t190 VSS 0.02271f ; **FLOATING
C2317 VR.n354 VSS 0.03821f ; **FLOATING
C2318 VR.n355 VSS 0.05622f ; **FLOATING
C2319 VR.n356 VSS 0.08565f ; **FLOATING
C2320 VR.t317 VSS 0.03548f ; **FLOATING
C2321 VR.t325 VSS 0.03579f ; **FLOATING
C2322 VR.t327 VSS 0.03548f ; **FLOATING
C2323 VR.t224 VSS 0.03548f ; **FLOATING
C2324 VR.t230 VSS 0.03579f ; **FLOATING
C2325 VR.t234 VSS 0.03548f ; **FLOATING
C2326 VR.n357 VSS 0.25571f ; **FLOATING
C2327 VR.t233 VSS 0.17738f ; **FLOATING
C2328 VR.t229 VSS 0.11619f ; **FLOATING
C2329 VR.t227 VSS 0.11619f ; **FLOATING
C2330 VR.t223 VSS 0.12962f ; **FLOATING
C2331 VR.t326 VSS 0.12962f ; **FLOATING
C2332 VR.t324 VSS 0.11619f ; **FLOATING
C2333 VR.t322 VSS 0.11619f ; **FLOATING
C2334 VR.t316 VSS 0.17738f ; **FLOATING
C2335 VR.t291 VSS 0.02271f ; **FLOATING
C2336 VR.n358 VSS 0.03821f ; **FLOATING
C2337 VR.n359 VSS 0.05622f ; **FLOATING
C2338 VR.n360 VSS 0.08565f ; **FLOATING
C2339 VR.t13 VSS 0.02271f ; **FLOATING
C2340 VR.n361 VSS 0.03821f ; **FLOATING
C2341 VR.n362 VSS 0.05622f ; **FLOATING
C2342 VR.n363 VSS 0.08565f ; **FLOATING
C2343 VR.t295 VSS 0.03548f ; **FLOATING
C2344 VR.t299 VSS 0.03579f ; **FLOATING
C2345 VR.t301 VSS 0.03548f ; **FLOATING
C2346 VR.t9 VSS 0.03548f ; **FLOATING
C2347 VR.t17 VSS 0.03579f ; **FLOATING
C2348 VR.t19 VSS 0.03548f ; **FLOATING
C2349 VR.n364 VSS 0.25571f ; **FLOATING
C2350 VR.t18 VSS 0.17738f ; **FLOATING
C2351 VR.t16 VSS 0.11619f ; **FLOATING
C2352 VR.t14 VSS 0.11619f ; **FLOATING
C2353 VR.t8 VSS 0.12962f ; **FLOATING
C2354 VR.t300 VSS 0.12962f ; **FLOATING
C2355 VR.t298 VSS 0.11619f ; **FLOATING
C2356 VR.t296 VSS 0.11619f ; **FLOATING
C2357 VR.t294 VSS 0.17738f ; **FLOATING
C2358 VR.t148 VSS 0.02271f ; **FLOATING
C2359 VR.n365 VSS 0.03821f ; **FLOATING
C2360 VR.n366 VSS 0.05622f ; **FLOATING
C2361 VR.n367 VSS 0.08565f ; **FLOATING
C2362 VR.t160 VSS 0.02271f ; **FLOATING
C2363 VR.n368 VSS 0.03821f ; **FLOATING
C2364 VR.n369 VSS 0.05622f ; **FLOATING
C2365 VR.n370 VSS 0.08565f ; **FLOATING
C2366 VR.n371 VSS 0.05856f ; **FLOATING
C2367 VR.t80 VSS 0.03548f ; **FLOATING
C2368 VR.t84 VSS 0.03579f ; **FLOATING
C2369 VR.t86 VSS 0.03548f ; **FLOATING
C2370 VR.n372 VSS 0.08554f ; **FLOATING
C2371 VR.n373 VSS 0.05851f ; **FLOATING
C2372 VR.n374 VSS 0.21386f ; **FLOATING
C2373 VR.t85 VSS 0.15865f ; **FLOATING
C2374 VR.t83 VSS 0.0759f ; **FLOATING
C2375 VR.n375 VSS 0.0506f ; **FLOATING
C2376 VR.t81 VSS 0.0759f ; **FLOATING
C2377 VR.t79 VSS 0.15865f ; **FLOATING
C2378 VR.n376 VSS 3.00147f ; **FLOATING
C2379 VR.n377 VSS 0.22126f ; **FLOATING
C2380 VR.t11 VSS 0.04602f ; **FLOATING
C2381 VR.n378 VSS 0.09245f ; **FLOATING
C2382 VR.n379 VSS 0.05789f ; **FLOATING
C2383 VR.n380 VSS 1.63402f ; **FLOATING
C2384 VR.n381 VSS 4.82131f ; **FLOATING
C2385 VR.n382 VSS 0.05856f ; **FLOATING
C2386 VR.t136 VSS 0.03548f ; **FLOATING
C2387 VR.t140 VSS 0.03579f ; **FLOATING
C2388 VR.t142 VSS 0.03548f ; **FLOATING
C2389 VR.n383 VSS 0.08554f ; **FLOATING
C2390 VR.n384 VSS 0.05851f ; **FLOATING
C2391 VR.n385 VSS 0.21386f ; **FLOATING
C2392 VR.t141 VSS 0.15865f ; **FLOATING
C2393 VR.t139 VSS 0.0759f ; **FLOATING
C2394 VR.n386 VSS 0.0506f ; **FLOATING
C2395 VR.t137 VSS 0.0759f ; **FLOATING
C2396 VR.t135 VSS 0.15865f ; **FLOATING
C2397 VR.n387 VSS 3.4124f ; **FLOATING
C2398 VR.n388 VSS 0.22126f ; **FLOATING
C2399 VR.t319 VSS 0.04602f ; **FLOATING
C2400 VR.n389 VSS 0.09245f ; **FLOATING
C2401 VR.n390 VSS 0.05789f ; **FLOATING
C2402 VR.n391 VSS 2.68329f ; **FLOATING
C2403 VR.n392 VSS 3.46131f ; **FLOATING
C2404 VR.n393 VSS 0.22126f ; **FLOATING
C2405 VR.t232 VSS 0.04602f ; **FLOATING
C2406 VR.n394 VSS 0.09245f ; **FLOATING
C2407 VR.n395 VSS 0.05789f ; **FLOATING
C2408 VR.n396 VSS 2.68329f ; **FLOATING
C2409 VR.n397 VSS 2.08235f ; **FLOATING
C2410 VR.t309 VSS 0.56778f ; **FLOATING
C2411 VR.n398 VSS 0.2357f ; **FLOATING
C2412 VR.n399 VSS 0.0453f ; **FLOATING
C2413 VR.n400 VSS 0.02962f ; **FLOATING
C2414 VR.n401 VSS 0.02962f ; **FLOATING
C2415 VR.n402 VSS 0.02962f ; **FLOATING
C2416 VR.n403 VSS 0.02962f ; **FLOATING
C2417 VR.n404 VSS 0.04304f ; **FLOATING
C2418 VR.n405 VSS 0.06316f ; **FLOATING
C2419 VR.n406 VSS 0.04631f ; **FLOATING
C2420 VR.n407 VSS 0.0453f ; **FLOATING
C2421 VR.n408 VSS 0.02962f ; **FLOATING
C2422 VR.n409 VSS 0.02962f ; **FLOATING
C2423 VR.n410 VSS 0.02962f ; **FLOATING
C2424 VR.n411 VSS 0.02962f ; **FLOATING
C2425 VR.n412 VSS 0.03306f ; **FLOATING
C2426 VR.n413 VSS 0.0333f ; **FLOATING
C2427 VR.n414 VSS 0.04547f ; **FLOATING
C2428 VR.n415 VSS 0.0297f ; **FLOATING
C2429 VR.n416 VSS 0.0297f ; **FLOATING
C2430 VR.n417 VSS 0.0297f ; **FLOATING
C2431 VR.n418 VSS 0.0297f ; **FLOATING
C2432 VR.n419 VSS 0.04312f ; **FLOATING
C2433 VR.n420 VSS 0.06324f ; **FLOATING
C2434 VR.n421 VSS 0.04639f ; **FLOATING
C2435 VR.n422 VSS 0.04547f ; **FLOATING
C2436 VR.n423 VSS 0.0297f ; **FLOATING
C2437 VR.n424 VSS 0.0297f ; **FLOATING
C2438 VR.n425 VSS 0.0297f ; **FLOATING
C2439 VR.n426 VSS 0.0297f ; **FLOATING
C2440 VR.n427 VSS 0.03314f ; **FLOATING
C2441 VR.n428 VSS 0.02684f ; **FLOATING
C2442 VR.n429 VSS 0.63754f ; **FLOATING
C2443 VR.n430 VSS 0.84905f ; **FLOATING
C2444 VR.n431 VSS 0.22126f ; **FLOATING
C2445 VR.t134 VSS 0.04602f ; **FLOATING
C2446 VR.n432 VSS 0.09245f ; **FLOATING
C2447 VR.n433 VSS 0.05789f ; **FLOATING
C2448 VR.n434 VSS 0.16951f ; **FLOATING
C2449 VR.n435 VSS 0.03701f ; **FLOATING
C2450 VR.n436 VSS 0.22126f ; **FLOATING
C2451 VR.n437 VSS 0.22126f ; **FLOATING
C2452 VR.n438 VSS 0.03701f ; **FLOATING
C2453 VR.n439 VSS 0.08205f ; **FLOATING
C2454 VR.n440 VSS 4.90049f ; **FLOATING
C2455 VR.n441 VSS 0.18019f ; **FLOATING
C2456 VR.t144 VSS 0.02271f ; **FLOATING
C2457 VR.n442 VSS 0.03549f ; **FLOATING
C2458 VR.n443 VSS 0.05214f ; **FLOATING
C2459 VR.n444 VSS 0.16393f ; **FLOATING
C2460 VR.n445 VSS 0.18019f ; **FLOATING
C2461 VR.t262 VSS 0.02271f ; **FLOATING
C2462 VR.n446 VSS 0.03549f ; **FLOATING
C2463 VR.n447 VSS 0.05214f ; **FLOATING
C2464 VR.n448 VSS 0.07647f ; **FLOATING
C2465 VR.n449 VSS 3.83487f ; **FLOATING
C2466 VR.n450 VSS 2.74631f ; **FLOATING
C2467 VR.n451 VSS 0.18019f ; **FLOATING
C2468 VR.t22 VSS 0.02271f ; **FLOATING
C2469 VR.n452 VSS 0.03549f ; **FLOATING
C2470 VR.n453 VSS 0.05214f ; **FLOATING
C2471 VR.n454 VSS 1.61552f ; **FLOATING
C2472 VR.n455 VSS 3.19427f ; **FLOATING
C2473 VR.n456 VSS 0.18019f ; **FLOATING
C2474 VR.t239 VSS 0.02271f ; **FLOATING
C2475 VR.n457 VSS 0.03549f ; **FLOATING
C2476 VR.n458 VSS 0.05214f ; **FLOATING
C2477 VR.n459 VSS 0.16393f ; **FLOATING
C2478 VR.n460 VSS 0.18019f ; **FLOATING
C2479 VR.t27 VSS 0.02271f ; **FLOATING
C2480 VR.n461 VSS 0.03549f ; **FLOATING
C2481 VR.n462 VSS 0.05214f ; **FLOATING
C2482 VR.n463 VSS 0.07647f ; **FLOATING
C2483 VR.n464 VSS 3.83487f ; **FLOATING
C2484 VR.n465 VSS 1.95217f ; **FLOATING
C2485 VR.n466 VSS 0.18019f ; **FLOATING
C2486 VR.t108 VSS 0.02271f ; **FLOATING
C2487 VR.n467 VSS 0.03549f ; **FLOATING
C2488 VR.n468 VSS 0.05214f ; **FLOATING
C2489 VR.n469 VSS 0.16393f ; **FLOATING
C2490 VR.n470 VSS 0.18019f ; **FLOATING
C2491 VR.t313 VSS 0.02271f ; **FLOATING
C2492 VR.n471 VSS 0.03549f ; **FLOATING
C2493 VR.n472 VSS 0.05214f ; **FLOATING
C2494 VR.n473 VSS 0.07647f ; **FLOATING
C2495 VR.n474 VSS 4.90996f ; **FLOATING
C2496 VR.n475 VSS 0.22126f ; **FLOATING
C2497 VR.t110 VSS 0.04602f ; **FLOATING
C2498 VR.n476 VSS 0.09245f ; **FLOATING
C2499 VR.n477 VSS 0.05789f ; **FLOATING
C2500 VR.n478 VSS 0.16951f ; **FLOATING
C2501 VR.n479 VSS 0.03701f ; **FLOATING
C2502 VR.n480 VSS 0.22126f ; **FLOATING
C2503 VR.n481 VSS 0.22126f ; **FLOATING
C2504 VR.n482 VSS 0.03701f ; **FLOATING
C2505 VR.n483 VSS 0.08205f ; **FLOATING
C2506 VR.n484 VSS 4.65504f ; **FLOATING
C2507 VR.n485 VSS 1.90644f ; **FLOATING
C2508 VR.n486 VSS 0.22126f ; **FLOATING
C2509 VR.t88 VSS 0.04602f ; **FLOATING
C2510 VR.n487 VSS 0.09245f ; **FLOATING
C2511 VR.n488 VSS 0.05789f ; **FLOATING
C2512 VR.n489 VSS 0.16951f ; **FLOATING
C2513 VR.n490 VSS 0.03701f ; **FLOATING
C2514 VR.n491 VSS 0.22126f ; **FLOATING
C2515 VR.n492 VSS 0.22126f ; **FLOATING
C2516 VR.n493 VSS 0.03701f ; **FLOATING
C2517 VR.n494 VSS 0.08205f ; **FLOATING
C2518 VR.n495 VSS 4.65504f ; **FLOATING
C2519 VR.n496 VSS 1.23031f ; **FLOATING
C2520 VR.n497 VSS 0.67663f ; **FLOATING
C2521 VR.n498 VSS 2.49683f ; **FLOATING
C2522 VR.n499 VSS 0.18019f ; **FLOATING
C2523 VR.t306 VSS 0.02271f ; **FLOATING
C2524 VR.n500 VSS 0.03549f ; **FLOATING
C2525 VR.n501 VSS 0.05214f ; **FLOATING
C2526 VR.n502 VSS 0.19738f ; **FLOATING
C2527 VR.n503 VSS 2.99852f ; **FLOATING
C2528 VR.n504 VSS 0.05856f ; **FLOATING
C2529 VR.t254 VSS 0.03548f ; **FLOATING
C2530 VR.t258 VSS 0.03579f ; **FLOATING
C2531 VR.t260 VSS 0.03548f ; **FLOATING
C2532 VR.n505 VSS 0.08554f ; **FLOATING
C2533 VR.n506 VSS 0.05851f ; **FLOATING
C2534 VR.n507 VSS 0.21386f ; **FLOATING
C2535 VR.t259 VSS 0.15865f ; **FLOATING
C2536 VR.t257 VSS 0.0759f ; **FLOATING
C2537 VR.n508 VSS 0.0506f ; **FLOATING
C2538 VR.t255 VSS 0.0759f ; **FLOATING
C2539 VR.t253 VSS 0.15865f ; **FLOATING
C2540 VR.n509 VSS 1.82605f ; **FLOATING
C2541 VR.n510 VSS 0.05856f ; **FLOATING
C2542 VR.t100 VSS 0.03548f ; **FLOATING
C2543 VR.t102 VSS 0.03579f ; **FLOATING
C2544 VR.t106 VSS 0.03548f ; **FLOATING
C2545 VR.n511 VSS 0.08554f ; **FLOATING
C2546 VR.n512 VSS 0.05851f ; **FLOATING
C2547 VR.n513 VSS 0.21386f ; **FLOATING
C2548 VR.t105 VSS 0.15865f ; **FLOATING
C2549 VR.t101 VSS 0.0759f ; **FLOATING
C2550 VR.n514 VSS 0.0506f ; **FLOATING
C2551 VR.t103 VSS 0.0759f ; **FLOATING
C2552 VR.t99 VSS 0.15865f ; **FLOATING
C2553 VR.n515 VSS 1.82605f ; **FLOATING
C2554 VR.n516 VSS 3.2879f ; **FLOATING
C2555 VR.n517 VSS 0.22126f ; **FLOATING
C2556 VR.t293 VSS 0.04602f ; **FLOATING
C2557 VR.n518 VSS 0.09245f ; **FLOATING
C2558 VR.n519 VSS 0.05789f ; **FLOATING
C2559 VR.n520 VSS 1.63402f ; **FLOATING
C2560 VR.n521 VSS 3.00188f ; **FLOATING
C2561 VR.n522 VSS 0.83298f ; **FLOATING
C2562 VR.n523 VSS 9.43321f ; **FLOATING
C2563 VR.n524 VSS 0.82283f ; **FLOATING
C2564 VR.n525 VSS 0.22126f ; **FLOATING
C2565 VR.t152 VSS 0.04602f ; **FLOATING
C2566 VR.n526 VSS 0.09245f ; **FLOATING
C2567 VR.n527 VSS 0.05789f ; **FLOATING
C2568 VR.n528 VSS 2.68329f ; **FLOATING
C2569 VR.n529 VSS 1.93358f ; **FLOATING
C2570 VR.n530 VSS 0.05856f ; **FLOATING
C2571 VR.t278 VSS 0.03548f ; **FLOATING
C2572 VR.t284 VSS 0.03579f ; **FLOATING
C2573 VR.t286 VSS 0.03548f ; **FLOATING
C2574 VR.n531 VSS 0.08554f ; **FLOATING
C2575 VR.n532 VSS 0.05851f ; **FLOATING
C2576 VR.n533 VSS 0.21386f ; **FLOATING
C2577 VR.t285 VSS 0.15865f ; **FLOATING
C2578 VR.t283 VSS 0.0759f ; **FLOATING
C2579 VR.n534 VSS 0.0506f ; **FLOATING
C2580 VR.t281 VSS 0.0759f ; **FLOATING
C2581 VR.t277 VSS 0.15865f ; **FLOATING
C2582 VR.n535 VSS 2.94024f ; **FLOATING
C2583 VR.n536 VSS 2.1723f ; **FLOATING
C2584 VR.n537 VSS 0.05856f ; **FLOATING
C2585 VR.t58 VSS 0.03548f ; **FLOATING
C2586 VR.t62 VSS 0.03579f ; **FLOATING
C2587 VR.t64 VSS 0.03548f ; **FLOATING
C2588 VR.n538 VSS 0.08554f ; **FLOATING
C2589 VR.n539 VSS 0.05851f ; **FLOATING
C2590 VR.n540 VSS 0.21386f ; **FLOATING
C2591 VR.t63 VSS 0.15865f ; **FLOATING
C2592 VR.t61 VSS 0.0759f ; **FLOATING
C2593 VR.n541 VSS 0.0506f ; **FLOATING
C2594 VR.t59 VSS 0.0759f ; **FLOATING
C2595 VR.t57 VSS 0.15865f ; **FLOATING
C2596 VR.n542 VSS 2.94024f ; **FLOATING
C2597 VR.n543 VSS 2.19991f ; **FLOATING
C2598 VR.n544 VSS 0.22126f ; **FLOATING
C2599 VR.t206 VSS 0.04602f ; **FLOATING
C2600 VR.n545 VSS 0.09245f ; **FLOATING
C2601 VR.n546 VSS 0.05789f ; **FLOATING
C2602 VR.n547 VSS 2.68329f ; **FLOATING
C2603 VR.n548 VSS 2.11686f ; **FLOATING
C2604 VR.n549 VSS 0.22126f ; **FLOATING
C2605 VR.t188 VSS 0.04602f ; **FLOATING
C2606 VR.n550 VSS 0.09245f ; **FLOATING
C2607 VR.n551 VSS 0.05789f ; **FLOATING
C2608 VR.n552 VSS 2.68329f ; **FLOATING
C2609 VR.n553 VSS 1.95429f ; **FLOATING
C2610 VR.n554 VSS 0.05856f ; **FLOATING
C2611 VR.t66 VSS 0.03548f ; **FLOATING
C2612 VR.t68 VSS 0.03579f ; **FLOATING
C2613 VR.t76 VSS 0.03548f ; **FLOATING
C2614 VR.n555 VSS 0.08554f ; **FLOATING
C2615 VR.n556 VSS 0.05851f ; **FLOATING
C2616 VR.n557 VSS 0.21386f ; **FLOATING
C2617 VR.t75 VSS 0.15865f ; **FLOATING
C2618 VR.t67 VSS 0.0759f ; **FLOATING
C2619 VR.n558 VSS 0.0506f ; **FLOATING
C2620 VR.t73 VSS 0.0759f ; **FLOATING
C2621 VR.t65 VSS 0.15865f ; **FLOATING
C2622 VR.n559 VSS 3.16129f ; **FLOATING
C2623 VR.n560 VSS 2.31291f ; **FLOATING
C2624 VR.t145 VSS 1.96379f ; **FLOATING
C2625 VR.n561 VSS 0.07272f ; **FLOATING
C2626 VR.t48 VSS 0.19161f ; **FLOATING
C2627 VR.t49 VSS 0.09742f ; **FLOATING
C2628 VR.n562 VSS 0.09429f ; **FLOATING
C2629 VR.n563 VSS 0.0746f ; **FLOATING
C2630 VR.n564 VSS 0.18601f ; **FLOATING
C2631 VR.n565 VSS 0.07272f ; **FLOATING
C2632 VR.t314 VSS 0.19161f ; **FLOATING
C2633 VR.t315 VSS 0.09742f ; **FLOATING
C2634 VR.n566 VSS 0.09429f ; **FLOATING
C2635 VR.n567 VSS 0.0746f ; **FLOATING
C2636 VR.n568 VSS 0.09854f ; **FLOATING
C2637 VR.t111 VSS 1.18387f ; **FLOATING
C2638 VR.n569 VSS 6.65238f ; **FLOATING
C2639 VR.n570 VSS 4.80054f ; **FLOATING
C2640 VR.n571 VSS 1.9233f ; **FLOATING
C2641 VR.t23 VSS 1.96379f ; **FLOATING
C2642 VR.n572 VSS 0.07272f ; **FLOATING
C2643 VR.t288 VSS 0.19161f ; **FLOATING
C2644 VR.t289 VSS 0.09742f ; **FLOATING
C2645 VR.n573 VSS 0.09429f ; **FLOATING
C2646 VR.n574 VSS 0.0746f ; **FLOATING
C2647 VR.n575 VSS 0.18601f ; **FLOATING
C2648 VR.n576 VSS 0.07272f ; **FLOATING
C2649 VR.t203 VSS 0.19161f ; **FLOATING
C2650 VR.t204 VSS 0.09742f ; **FLOATING
C2651 VR.n577 VSS 0.09429f ; **FLOATING
C2652 VR.n578 VSS 0.0746f ; **FLOATING
C2653 VR.n579 VSS 0.09854f ; **FLOATING
C2654 VR.t240 VSS 1.18387f ; **FLOATING
C2655 VR.n580 VSS 8.21308f ; **FLOATING
C2656 VR.n581 VSS 3.49257f ; **FLOATING
C2657 VR.t202 VSS 1.96379f ; **FLOATING
C2658 VR.t131 VSS 0.09742f ; **FLOATING
C2659 VR.n582 VSS 0.09429f ; **FLOATING
C2660 VR.n583 VSS 0.0746f ; **FLOATING
C2661 VR.n584 VSS 0.18601f ; **FLOATING
C2662 VR.t25 VSS 0.09742f ; **FLOATING
C2663 VR.n585 VSS 0.09429f ; **FLOATING
C2664 VR.n586 VSS 0.0746f ; **FLOATING
C2665 VR.n587 VSS 0.09854f ; **FLOATING
C2666 VR.t28 VSS 1.18387f ; **FLOATING
C2667 VR.n588 VSS 8.21308f ; **FLOATING
C2668 VR.n589 VSS 3.17875f ; **FLOATING
C2669 VR.n590 VSS 0.05856f ; **FLOATING
C2670 VR.t244 VSS 0.03548f ; **FLOATING
C2671 VR.t248 VSS 0.03579f ; **FLOATING
C2672 VR.t250 VSS 0.03548f ; **FLOATING
C2673 VR.n591 VSS 0.08554f ; **FLOATING
C2674 VR.n592 VSS 0.05851f ; **FLOATING
C2675 VR.n593 VSS 0.21386f ; **FLOATING
C2676 VR.t249 VSS 0.15865f ; **FLOATING
C2677 VR.t247 VSS 0.0759f ; **FLOATING
C2678 VR.n594 VSS 0.0506f ; **FLOATING
C2679 VR.t245 VSS 0.0759f ; **FLOATING
C2680 VR.t243 VSS 0.15865f ; **FLOATING
C2681 VR.n595 VSS 3.00147f ; **FLOATING
C2682 VR.n596 VSS 0.05856f ; **FLOATING
C2683 VR.t40 VSS 0.03548f ; **FLOATING
C2684 VR.t44 VSS 0.03579f ; **FLOATING
C2685 VR.t46 VSS 0.03548f ; **FLOATING
C2686 VR.n597 VSS 0.08554f ; **FLOATING
C2687 VR.n598 VSS 0.05851f ; **FLOATING
C2688 VR.n599 VSS 0.21386f ; **FLOATING
C2689 VR.t45 VSS 0.15865f ; **FLOATING
C2690 VR.t43 VSS 0.0759f ; **FLOATING
C2691 VR.n600 VSS 0.0506f ; **FLOATING
C2692 VR.t41 VSS 0.0759f ; **FLOATING
C2693 VR.t39 VSS 0.15865f ; **FLOATING
C2694 VR.n601 VSS 1.82605f ; **FLOATING
C2695 VR.n602 VSS 0.05856f ; **FLOATING
C2696 VR.t32 VSS 0.03548f ; **FLOATING
C2697 VR.t36 VSS 0.03579f ; **FLOATING
C2698 VR.t38 VSS 0.03548f ; **FLOATING
C2699 VR.n603 VSS 0.08554f ; **FLOATING
C2700 VR.n604 VSS 0.05851f ; **FLOATING
C2701 VR.n605 VSS 0.21386f ; **FLOATING
C2702 VR.t37 VSS 0.15865f ; **FLOATING
C2703 VR.t35 VSS 0.0759f ; **FLOATING
C2704 VR.n606 VSS 0.0506f ; **FLOATING
C2705 VR.t33 VSS 0.0759f ; **FLOATING
C2706 VR.t31 VSS 0.15865f ; **FLOATING
C2707 VR.n607 VSS 3.45114f ; **FLOATING
C2708 VR.n608 VSS 0.05856f ; **FLOATING
C2709 VR.t1 VSS 0.03548f ; **FLOATING
C2710 VR.t5 VSS 0.03579f ; **FLOATING
C2711 VR.t7 VSS 0.03548f ; **FLOATING
C2712 VR.n609 VSS 0.08554f ; **FLOATING
C2713 VR.n610 VSS 0.05851f ; **FLOATING
C2714 VR.n611 VSS 0.21386f ; **FLOATING
C2715 VR.t6 VSS 0.15865f ; **FLOATING
C2716 VR.t4 VSS 0.0759f ; **FLOATING
C2717 VR.n612 VSS 0.0506f ; **FLOATING
C2718 VR.t2 VSS 0.0759f ; **FLOATING
C2719 VR.t0 VSS 0.15865f ; **FLOATING
C2720 VR.n613 VSS 2.94024f ; **FLOATING
C2721 VR.n614 VSS 3.52633f ; **FLOATING
C2722 VR.n615 VSS 1.79175f ; **FLOATING
C2723 VR.n616 VSS 0.18019f ; **FLOATING
C2724 VR.t276 VSS 0.02271f ; **FLOATING
C2725 VR.n617 VSS 0.03549f ; **FLOATING
C2726 VR.n618 VSS 0.05214f ; **FLOATING
C2727 VR.n619 VSS 0.16393f ; **FLOATING
C2728 VR.n620 VSS 0.18019f ; **FLOATING
C2729 VR.t267 VSS 0.02271f ; **FLOATING
C2730 VR.n621 VSS 0.03549f ; **FLOATING
C2731 VR.n622 VSS 0.05214f ; **FLOATING
C2732 VR.n623 VSS 0.07647f ; **FLOATING
C2733 VR.n624 VSS 3.83487f ; **FLOATING
C2734 VR.n625 VSS 1.87303f ; **FLOATING
C2735 VR.n626 VSS 0.22126f ; **FLOATING
C2736 VR.t280 VSS 0.04602f ; **FLOATING
C2737 VR.n627 VSS 0.09245f ; **FLOATING
C2738 VR.n628 VSS 0.05789f ; **FLOATING
C2739 VR.n629 VSS 0.16951f ; **FLOATING
C2740 VR.n630 VSS 0.03701f ; **FLOATING
C2741 VR.n631 VSS 0.22126f ; **FLOATING
C2742 VR.n632 VSS 0.22126f ; **FLOATING
C2743 VR.n633 VSS 0.03701f ; **FLOATING
C2744 VR.n634 VSS 0.08205f ; **FLOATING
C2745 VR.n635 VSS 3.89919f ; **FLOATING
C2746 VR.n636 VSS 2.09171f ; **FLOATING
C2747 VR.n637 VSS 0.18019f ; **FLOATING
C2748 VR.t72 VSS 0.02271f ; **FLOATING
C2749 VR.n638 VSS 0.03549f ; **FLOATING
C2750 VR.n639 VSS 0.05214f ; **FLOATING
C2751 VR.n640 VSS 0.16393f ; **FLOATING
C2752 VR.n641 VSS 0.18019f ; **FLOATING
C2753 VR.t55 VSS 0.02271f ; **FLOATING
C2754 VR.n642 VSS 0.03549f ; **FLOATING
C2755 VR.n643 VSS 0.05214f ; **FLOATING
C2756 VR.n644 VSS 0.07647f ; **FLOATING
C2757 VR.n645 VSS 3.83487f ; **FLOATING
C2758 VR.n646 VSS 2.03178f ; **FLOATING
C2759 VR.n647 VSS 0.22126f ; **FLOATING
C2760 VR.t70 VSS 0.04602f ; **FLOATING
C2761 VR.n648 VSS 0.09245f ; **FLOATING
C2762 VR.n649 VSS 0.05789f ; **FLOATING
C2763 VR.n650 VSS 0.16951f ; **FLOATING
C2764 VR.n651 VSS 0.03701f ; **FLOATING
C2765 VR.n652 VSS 0.22126f ; **FLOATING
C2766 VR.n653 VSS 0.22126f ; **FLOATING
C2767 VR.n654 VSS 0.03701f ; **FLOATING
C2768 VR.n655 VSS 0.08205f ; **FLOATING
C2769 VR.n656 VSS 3.89919f ; **FLOATING
C2770 VR.n657 VSS 2.70119f ; **FLOATING
C2771 LOIP.t2 VSS 0.09475f ; **FLOATING
C2772 LOIP.t0 VSS 0.09423f ; **FLOATING
C2773 LOIP.t1 VSS 0.12757f ; **FLOATING
C2774 LOIP.n0 VSS 0.07413f ; **FLOATING
C2775 LOIP.n1 VSS 4.4422f ; **FLOATING
C2776 LOIN.t0 VSS 0.17342f ; **FLOATING
C2777 LOIN.t1 VSS 0.17248f ; **FLOATING
C2778 LOIN.t2 VSS 0.2335f ; **FLOATING
C2779 LOIN.n0 VSS 0.13569f ; **FLOATING
C2780 LOIN.n1 VSS 6.67354f ; **FLOATING
C2781 B1.t0 VSS 0.0388f ; **FLOATING
C2782 B1.t1 VSS 0.11118f ; **FLOATING
C2783 B1.n0 VSS 6.08781f ; **FLOATING
.ends

.subckt vco_ring4 VCTRL B0 B1 LOIP LOIN LOQP LOQN VR VDD VSS
XPEX VSS VDD VCTRL B0 B1 LOIP LOIN LOQP LOQN VR vco_ring4_flat
.ends
.end
