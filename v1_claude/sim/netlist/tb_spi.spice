** sch_path: /home/noritsuna/GPS/xschem/tb_spi.sch
**.subckt tb_spi
VDD vdd 0 pwl(0 0 1u 3.3)
VSCLK sclk 0 pwl(0 0 3.01e-05 0 3.0102e-05 3.3 3.015e-05 3.3 3.0152e-05 0 3.02e-05 0 3.0202e-05 3.3 3.025e-05 3.3 3.0252e-05 0
+ 3.03e-05 0 3.0302e-05 3.3 3.035e-05 3.3 3.0352e-05 0 3.04e-05 0 3.0402e-05 3.3 3.045e-05 3.3 3.0452e-05 0 3.05e-05 0 3.0502e-05 3.3
+ 3.055e-05 3.3 3.0552e-05 0 3.06e-05 0 3.0602e-05 3.3 3.065e-05 3.3 3.0652e-05 0 3.07e-05 0 3.0702e-05 3.3 3.075e-05 3.3 3.0752e-05 0
+ 3.08e-05 0 3.0802e-05 3.3 3.085e-05 3.3 3.0852e-05 0 3.09e-05 0 3.0902e-05 3.3 3.095e-05 3.3 3.0952e-05 0 3.1e-05 0 3.1002e-05 3.3
+ 3.105e-05 3.3 3.1052e-05 0 3.11e-05 0 3.1102e-05 3.3 3.115e-05 3.3 3.1152e-05 0 3.12e-05 0 3.1202e-05 3.3 3.125e-05 3.3 3.1252e-05 0
+ 3.13e-05 0 3.1302e-05 3.3 3.135e-05 3.3 3.1352e-05 0 3.14e-05 0 3.1402e-05 3.3 3.145e-05 3.3 3.1452e-05 0 3.15e-05 0 3.1502e-05 3.3
+ 3.155e-05 3.3 3.1552e-05 0 3.16e-05 0 3.1602e-05 3.3 3.165e-05 3.3 3.1652e-05 0 3.17e-05 0 3.1702e-05 3.3 3.175e-05 3.3 3.1752e-05 0
+ 3.18e-05 0 3.1802e-05 3.3 3.185e-05 3.3 3.1852e-05 0 3.19e-05 0 3.1902e-05 3.3 3.195e-05 3.3 3.1952e-05 0 3.2e-05 0 3.2002e-05 3.3
+ 3.205e-05 3.3 3.2052e-05 0 3.21e-05 0 3.2102e-05 3.3 3.215e-05 3.3 3.2152e-05 0 3.22e-05 0 3.2202e-05 3.3 3.225e-05 3.3 3.2252e-05 0
+ 3.23e-05 0 3.2302e-05 3.3 3.235e-05 3.3 3.2352e-05 0 3.24e-05 0 3.2402e-05 3.3 3.245e-05 3.3 3.2452e-05 0)
VSDI sdi 0 pwl(0 0 3.005e-05 0 3.0052e-05 3.3 3.015e-05 3.3 3.0152e-05 0 3.025e-05 0 3.0252e-05 0 3.035e-05 0 3.0352e-05 0
+ 3.045e-05 0 3.0452e-05 0 3.055e-05 0 3.0552e-05 3.3 3.065e-05 3.3 3.0652e-05 0 3.075e-05 0 3.0752e-05 3.3 3.085e-05 3.3 3.0852e-05 0
+ 3.095e-05 0 3.0952e-05 0 3.105e-05 0 3.1052e-05 3.3 3.115e-05 3.3 3.1152e-05 3.3 3.125e-05 3.3 3.1252e-05 3.3 3.135e-05 3.3 3.1352e-05 0
+ 3.145e-05 0 3.1452e-05 3.3 3.155e-05 3.3 3.1552e-05 0 3.165e-05 0 3.1652e-05 3.3 3.175e-05 3.3 3.1752e-05 0 3.185e-05 0 3.1852e-05 0
+ 3.195e-05 0 3.1952e-05 3.3 3.205e-05 3.3 3.2052e-05 0 3.215e-05 0 3.2152e-05 3.3 3.225e-05 3.3 3.2252e-05 3.3 3.235e-05 3.3 3.2352e-05 0)
VCSN csn 0 pwl(0 3.3 3e-05 3.3 3.0002e-05 0 3.25e-05 0 3.2502e-05 3.3)
XS sclk sdi csn ig1a ig1b ig2a ig2b ig3a ig3b b0 b1 afc0 afc1 afc2 afc3 afc4 afc5 afc6 afc7 icp2 bww bwn vdd 0 spi_regs
**** begin user architecture code
 .include /home/noritsuna/pdk/gf180mcuD/libs.tech/ngspice/design.ngspice
.lib /home/noritsuna/pdk/gf180mcuD/libs.tech/ngspice/sm141064.ngspice typical
.lib /home/noritsuna/pdk/gf180mcuD/libs.tech/ngspice/sm141064.ngspice res_typical
.lib /home/noritsuna/pdk/gf180mcuD/libs.tech/ngspice/sm141064.ngspice mimcap_typical

.control
set num_threads=1
tran 2n 34.5u
meas tran por_ig1a find v(ig1a) at=2.9e-05
meas tran por_ig1b find v(ig1b) at=2.9e-05
meas tran por_ig2a find v(ig2a) at=2.9e-05
meas tran por_ig2b find v(ig2b) at=2.9e-05
meas tran por_ig3a find v(ig3a) at=2.9e-05
meas tran por_ig3b find v(ig3b) at=2.9e-05
meas tran por_b0 find v(b0) at=2.9e-05
meas tran por_b1 find v(b1) at=2.9e-05
meas tran por_afc0 find v(afc0) at=2.9e-05
meas tran por_afc1 find v(afc1) at=2.9e-05
meas tran por_afc2 find v(afc2) at=2.9e-05
meas tran por_afc3 find v(afc3) at=2.9e-05
meas tran por_afc4 find v(afc4) at=2.9e-05
meas tran por_afc5 find v(afc5) at=2.9e-05
meas tran por_afc6 find v(afc6) at=2.9e-05
meas tran por_afc7 find v(afc7) at=2.9e-05
meas tran por_icp2 find v(icp2) at=2.9e-05
meas tran por_bww find v(bww) at=2.9e-05
meas tran por_bwn find v(bwn) at=2.9e-05
echo RES por IG1A=$&por_ig1a IG1B=$&por_ig1b IG2A=$&por_ig2a IG2B=$&por_ig2b IG3A=$&por_ig3a IG3B=$&por_ig3b B0=$&por_b0 B1=$&por_b1 AFC0=$&por_afc0 AFC1=$&por_afc1 AFC2=$&por_afc2 AFC3=$&por_afc3 AFC4=$&por_afc4 AFC5=$&por_afc5 AFC6=$&por_afc6 AFC7=$&por_afc7 ICP2=$&por_icp2 BWW=$&por_bww BWN=$&por_bwn
meas tran write_ig1a find v(ig1a) at=3.4e-05
meas tran write_ig1b find v(ig1b) at=3.4e-05
meas tran write_ig2a find v(ig2a) at=3.4e-05
meas tran write_ig2b find v(ig2b) at=3.4e-05
meas tran write_ig3a find v(ig3a) at=3.4e-05
meas tran write_ig3b find v(ig3b) at=3.4e-05
meas tran write_b0 find v(b0) at=3.4e-05
meas tran write_b1 find v(b1) at=3.4e-05
meas tran write_afc0 find v(afc0) at=3.4e-05
meas tran write_afc1 find v(afc1) at=3.4e-05
meas tran write_afc2 find v(afc2) at=3.4e-05
meas tran write_afc3 find v(afc3) at=3.4e-05
meas tran write_afc4 find v(afc4) at=3.4e-05
meas tran write_afc5 find v(afc5) at=3.4e-05
meas tran write_afc6 find v(afc6) at=3.4e-05
meas tran write_afc7 find v(afc7) at=3.4e-05
meas tran write_icp2 find v(icp2) at=3.4e-05
meas tran write_bww find v(bww) at=3.4e-05
meas tran write_bwn find v(bwn) at=3.4e-05
echo RES write IG1A=$&write_ig1a IG1B=$&write_ig1b IG2A=$&write_ig2a IG2B=$&write_ig2b IG3A=$&write_ig3a IG3B=$&write_ig3b B0=$&write_b0 B1=$&write_b1 AFC0=$&write_afc0 AFC1=$&write_afc1 AFC2=$&write_afc2 AFC3=$&write_afc3 AFC4=$&write_afc4 AFC5=$&write_afc5 AFC6=$&write_afc6 AFC7=$&write_afc7 ICP2=$&write_icp2 BWW=$&write_bww BWN=$&write_bwn
meas tran rstw when v(xs.rst)=1.65 fall=1
echo RES por_release=$&rstw
.endc

**** end user architecture code
**.ends

* expanding   symbol:  spi_regs.sym # of pins=24
** sym_path: /home/noritsuna/GPS/xschem/spi_regs.sym
** sch_path: /home/noritsuna/GPS/xschem/spi_regs.sch
.subckt spi_regs SCLK SDI CS_N IG1A IG1B IG2A IG2B IG3A IG3B B0 B1 AFC0 AFC1 AFC2 AFC3 AFC4 AFC5 AFC6 AFC7 ICP2 BWW BWN VDD VSS
*.ipin SCLK
*.ipin SDI
*.ipin CS_N
*.opin IG1A
*.opin IG1B
*.opin IG2A
*.opin IG2B
*.opin IG3A
*.opin IG3B
*.opin B0
*.opin B1
*.opin AFC0
*.opin AFC1
*.opin AFC2
*.opin AFC3
*.opin AFC4
*.opin AFC5
*.opin AFC6
*.opin AFC7
*.opin ICP2
*.opin BWW
*.opin BWN
*.iopin VDD
*.iopin VSS
XRPU CS_N VDD VSS ppolyf_u_1k r_width=1u r_length=100u
XSCB SCLK sclkb VDD VSS inv_dig
XSCG CS_N sclkb sck VDD VSS nor2
XRPOR pr VDD VSS ppolyf_u_1k r_width=1u r_length=200u
XCPOR pr VSS cap_mim_2f0_m4m5_noshield c_width=70e-6 c_length=70e-6
XP1 pr por1 VDD VSS inv_dig
XP2 por1 por2 VDD VSS inv_dig
XP3 por2 rst VDD VSS inv_dig
XR0 SDI sck rst r0 VDD VSS dffr_s
XR1 r0 sck rst r1 VDD VSS dffr_s
XR2 r1 sck rst r2 VDD VSS dffr_s
XR3 r2 sck rst r3 VDD VSS dffr_s
XR4 r3 sck rst r4 VDD VSS dffr_s
XR5 r4 sck rst r5 VDD VSS dffr_s
XR6 r5 sck rst r6 VDD VSS dffr_s
XR7 r6 sck rst r7 VDD VSS dffr_s
XR8 r7 sck rst r8 VDD VSS dffr_s
XR9 r8 sck rst r9 VDD VSS dffr_s
XR10 r9 sck rst r10 VDD VSS dffr_s
XR11 r10 sck rst r11 VDD VSS dffr_s
XR12 r11 sck rst r12 VDD VSS dffr_s
XR13 r12 sck rst r13 VDD VSS dffr_s
XR14 r13 sck rst r14 VDD VSS dffr_s
XR15 r14 sck rst r15 VDD VSS dffr_s
XR16 r15 sck rst r16 VDD VSS dffr_s
XR17 r16 sck rst r17 VDD VSS dffr_s
XR18 r17 sck rst r18 VDD VSS dffr_s
XR19 r18 sck rst r19 VDD VSS dffr_s
XR20 r19 sck rst r20 VDD VSS dffr_s
XR21 r20 sck rst r21 VDD VSS dffr_s
XR22 r21 sck rst r22 VDD VSS dffr_s
XR23 r22 sck rst r23 VDD VSS dffr_s
XL0 r0 CS_N IG1A VDD VSS latch_s
XL1 r1 CS_N IG1B VDD VSS latch_s
XL2 r2 CS_N IG2A VDD VSS latch_s
XL3 r3 CS_N IG2B VDD VSS latch_s
XL4 r4 CS_N IG3A VDD VSS latch_s
XL5 r5 CS_N IG3B VDD VSS latch_s
XL6 r6 CS_N B0 VDD VSS latch_s
XL7 r7 CS_N B1 VDD VSS latch_s
XL8 r8 CS_N AFC0 VDD VSS latch_s
XL9 r9 CS_N AFC1 VDD VSS latch_s
XL10 r10 CS_N AFC2 VDD VSS latch_s
XL11 r11 CS_N AFC3 VDD VSS latch_s
XL12 r12 CS_N AFC4 VDD VSS latch_s
XL13 r13 CS_N AFC5 VDD VSS latch_s
XL14 r14 CS_N AFC6 VDD VSS latch_s
XL15 r15 CS_N afc7n VDD VSS latch_s
XAFC7 afc7n AFC7 VDD VSS inv_dig
XL16 r16 CS_N ICP2 VDD VSS latch_s
XL17 r17 CS_N BWW VDD VSS latch_s
XL18 r18 CS_N BWN VDD VSS latch_s
.ends

* expanding   symbol:  inv_dig.sym # of pins=4
** sym_path: /home/noritsuna/GPS/xschem/inv_dig.sym
** sch_path: /home/noritsuna/GPS/xschem/inv_dig.sch
.subckt inv_dig A Y VDD VSS
*.ipin A
*.opin Y
*.iopin VDD
*.iopin VSS
XMN Y A VSS VSS nfet_03v3 L=0.28u W=1u nf=1 ad='int((nf+1)/2) * W/nf * 0.18u' as='int((nf+2)/2) * W/nf * 0.18u' pd='2*int((nf+1)/2) * (W/nf + 0.18u)'
+ ps='2*int((nf+2)/2) * (W/nf + 0.18u)' nrd='0.18u / W' nrs='0.18u / W' sa=0 sb=0 sd=0 m=1 par=1
XMP Y A VDD VDD pfet_03v3 L=0.28u W=2u nf=1 ad='int((nf+1)/2) * W/nf * 0.18u' as='int((nf+2)/2) * W/nf * 0.18u' pd='2*int((nf+1)/2) * (W/nf + 0.18u)'
+ ps='2*int((nf+2)/2) * (W/nf + 0.18u)' nrd='0.18u / W' nrs='0.18u / W' sa=0 sb=0 sd=0 m=1 par=1
.ends

* expanding   symbol:  nor2.sym # of pins=5
** sym_path: /home/noritsuna/GPS/xschem/nor2.sym
** sch_path: /home/noritsuna/GPS/xschem/nor2.sch
.subckt nor2 A B Y VDD VSS
*.ipin A
*.ipin B
*.opin Y
*.iopin VDD
*.iopin VSS
XMN1 Y A VSS VSS nfet_03v3 L=0.28u W=1u nf=1 ad='int((nf+1)/2) * W/nf * 0.18u' as='int((nf+2)/2) * W/nf * 0.18u' pd='2*int((nf+1)/2) * (W/nf + 0.18u)'
+ ps='2*int((nf+2)/2) * (W/nf + 0.18u)' nrd='0.18u / W' nrs='0.18u / W' sa=0 sb=0 sd=0 m=1 par=1
XMN2 Y B VSS VSS nfet_03v3 L=0.28u W=1u nf=1 ad='int((nf+1)/2) * W/nf * 0.18u' as='int((nf+2)/2) * W/nf * 0.18u' pd='2*int((nf+1)/2) * (W/nf + 0.18u)'
+ ps='2*int((nf+2)/2) * (W/nf + 0.18u)' nrd='0.18u / W' nrs='0.18u / W' sa=0 sb=0 sd=0 m=1 par=1
XMP1 n1 A VDD VDD pfet_03v3 L=0.28u W=4u nf=1 ad='int((nf+1)/2) * W/nf * 0.18u' as='int((nf+2)/2) * W/nf * 0.18u' pd='2*int((nf+1)/2) * (W/nf + 0.18u)'
+ ps='2*int((nf+2)/2) * (W/nf + 0.18u)' nrd='0.18u / W' nrs='0.18u / W' sa=0 sb=0 sd=0 m=1 par=1
XMP2 Y B n1 VDD pfet_03v3 L=0.28u W=4u nf=1 ad='int((nf+1)/2) * W/nf * 0.18u' as='int((nf+2)/2) * W/nf * 0.18u' pd='2*int((nf+1)/2) * (W/nf + 0.18u)'
+ ps='2*int((nf+2)/2) * (W/nf + 0.18u)' nrd='0.18u / W' nrs='0.18u / W' sa=0 sb=0 sd=0 m=1 par=1
.ends

* expanding   symbol:  dffr_s.sym # of pins=6
** sym_path: /home/noritsuna/GPS/xschem/dffr_s.sym
** sch_path: /home/noritsuna/GPS/xschem/dffr_s.sch
.subckt dffr_s D CK RST Q VDD VSS
*.ipin D
*.ipin CK
*.ipin RST
*.opin Q
*.iopin VDD
*.iopin VSS
XCI CK ckb VDD VSS inv_dig
XT1N D ckb m VSS nfet_03v3 L=0.28u W=1u nf=1 ad='int((nf+1)/2) * W/nf * 0.18u' as='int((nf+2)/2) * W/nf * 0.18u' pd='2*int((nf+1)/2) * (W/nf + 0.18u)'
+ ps='2*int((nf+2)/2) * (W/nf + 0.18u)' nrd='0.18u / W' nrs='0.18u / W' sa=0 sb=0 sd=0 m=1 par=1
XT1P D CK m VDD pfet_03v3 L=0.28u W=2u nf=1 ad='int((nf+1)/2) * W/nf * 0.18u' as='int((nf+2)/2) * W/nf * 0.18u' pd='2*int((nf+1)/2) * (W/nf + 0.18u)'
+ ps='2*int((nf+2)/2) * (W/nf + 0.18u)' nrd='0.18u / W' nrs='0.18u / W' sa=0 sb=0 sd=0 m=1 par=1
XM m RST mb VDD VSS nor2
XMF mb mf VDD VSS inv_dig
XT2N mf CK m VSS nfet_03v3 L=0.28u W=1u nf=1 ad='int((nf+1)/2) * W/nf * 0.18u' as='int((nf+2)/2) * W/nf * 0.18u' pd='2*int((nf+1)/2) * (W/nf + 0.18u)'
+ ps='2*int((nf+2)/2) * (W/nf + 0.18u)' nrd='0.18u / W' nrs='0.18u / W' sa=0 sb=0 sd=0 m=1 par=1
XT2P mf ckb m VDD pfet_03v3 L=0.28u W=2u nf=1 ad='int((nf+1)/2) * W/nf * 0.18u' as='int((nf+2)/2) * W/nf * 0.18u' pd='2*int((nf+1)/2) * (W/nf + 0.18u)'
+ ps='2*int((nf+2)/2) * (W/nf + 0.18u)' nrd='0.18u / W' nrs='0.18u / W' sa=0 sb=0 sd=0 m=1 par=1
XT3N mb CK sl VSS nfet_03v3 L=0.28u W=1u nf=1 ad='int((nf+1)/2) * W/nf * 0.18u' as='int((nf+2)/2) * W/nf * 0.18u' pd='2*int((nf+1)/2) * (W/nf + 0.18u)'
+ ps='2*int((nf+2)/2) * (W/nf + 0.18u)' nrd='0.18u / W' nrs='0.18u / W' sa=0 sb=0 sd=0 m=1 par=1
XT3P mb ckb sl VDD pfet_03v3 L=0.28u W=2u nf=1 ad='int((nf+1)/2) * W/nf * 0.18u' as='int((nf+2)/2) * W/nf * 0.18u' pd='2*int((nf+1)/2) * (W/nf + 0.18u)'
+ ps='2*int((nf+2)/2) * (W/nf + 0.18u)' nrd='0.18u / W' nrs='0.18u / W' sa=0 sb=0 sd=0 m=1 par=1
XS sl RST Q VDD VSS nor2
XSF Q sf VDD VSS inv_dig
XT4N sf ckb sl VSS nfet_03v3 L=0.28u W=1u nf=1 ad='int((nf+1)/2) * W/nf * 0.18u' as='int((nf+2)/2) * W/nf * 0.18u' pd='2*int((nf+1)/2) * (W/nf + 0.18u)'
+ ps='2*int((nf+2)/2) * (W/nf + 0.18u)' nrd='0.18u / W' nrs='0.18u / W' sa=0 sb=0 sd=0 m=1 par=1
XT4P sf CK sl VDD pfet_03v3 L=0.28u W=2u nf=1 ad='int((nf+1)/2) * W/nf * 0.18u' as='int((nf+2)/2) * W/nf * 0.18u' pd='2*int((nf+1)/2) * (W/nf + 0.18u)'
+ ps='2*int((nf+2)/2) * (W/nf + 0.18u)' nrd='0.18u / W' nrs='0.18u / W' sa=0 sb=0 sd=0 m=1 par=1
.ends

* expanding   symbol:  latch_s.sym # of pins=5
** sym_path: /home/noritsuna/GPS/xschem/latch_s.sym
** sch_path: /home/noritsuna/GPS/xschem/latch_s.sch
.subckt latch_s D EN Q VDD VSS
*.ipin D
*.ipin EN
*.opin Q
*.iopin VDD
*.iopin VSS
XEI EN enb VDD VSS inv_dig
XTIN D EN l VSS nfet_03v3 L=0.28u W=1u nf=1 ad='int((nf+1)/2) * W/nf * 0.18u' as='int((nf+2)/2) * W/nf * 0.18u' pd='2*int((nf+1)/2) * (W/nf + 0.18u)'
+ ps='2*int((nf+2)/2) * (W/nf + 0.18u)' nrd='0.18u / W' nrs='0.18u / W' sa=0 sb=0 sd=0 m=1 par=1
XTIP D enb l VDD pfet_03v3 L=0.28u W=2u nf=1 ad='int((nf+1)/2) * W/nf * 0.18u' as='int((nf+2)/2) * W/nf * 0.18u' pd='2*int((nf+1)/2) * (W/nf + 0.18u)'
+ ps='2*int((nf+2)/2) * (W/nf + 0.18u)' nrd='0.18u / W' nrs='0.18u / W' sa=0 sb=0 sd=0 m=1 par=1
X1 l lb VDD VSS inv_dig
X2 lb Q VDD VSS inv_dig
XTFN Q enb l VSS nfet_03v3 L=0.28u W=1u nf=1 ad='int((nf+1)/2) * W/nf * 0.18u' as='int((nf+2)/2) * W/nf * 0.18u' pd='2*int((nf+1)/2) * (W/nf + 0.18u)'
+ ps='2*int((nf+2)/2) * (W/nf + 0.18u)' nrd='0.18u / W' nrs='0.18u / W' sa=0 sb=0 sd=0 m=1 par=1
XTFP Q EN l VDD pfet_03v3 L=0.28u W=2u nf=1 ad='int((nf+1)/2) * W/nf * 0.18u' as='int((nf+2)/2) * W/nf * 0.18u' pd='2*int((nf+1)/2) * (W/nf + 0.18u)'
+ ps='2*int((nf+2)/2) * (W/nf + 0.18u)' nrd='0.18u / W' nrs='0.18u / W' sa=0 sb=0 sd=0 m=1 par=1
.ends

.end
