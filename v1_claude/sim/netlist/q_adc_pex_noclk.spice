** sch_path: /home/noritsuna/GPS/xschem/tb_adc.sch
**.subckt tb_adc
VDD vdd 0 3.3
VCK clk 0 pulse(0 3.3 0 0.2n 0.2n 30.3474n 61.0948n)
VIP inp 0 pwl(0 1.0 10u 1.4)
VIN inn 0 pwl(0 1.4 10u 1.0)
XA inp inn clk sign mag vdd 0 adc2b
C1 sign 0 50f
C2 mag 0 50f
**** begin user architecture code
 .include /home/noritsuna/pdk/gf180mcuD/libs.tech/ngspice/design.ngspice
.lib /home/noritsuna/pdk/gf180mcuD/libs.tech/ngspice/sm141064.ngspice typical
.lib /home/noritsuna/pdk/gf180mcuD/libs.tech/ngspice/sm141064.ngspice res_typical
.lib /home/noritsuna/pdk/gf180mcuD/libs.tech/ngspice/sm141064.ngspice mimcap_typical

.control
set num_threads=1
tran 0.1n 10u
let vd = v(inp)-v(inn)
wrdata /tmp/claude-1000/-home-noritsuna-GPS/c833b4ff-95cf-42fc-a46c-00da2a6a5752/scratchpad/adcpex_noclk vd v(sign) v(mag) v(clk)
meas tran ts when v(sign)=1.65 rise=1
meas tran tm1 when v(mag)=1.65 fall=1
meas tran tm2 when v(mag)=1.65 rise=1
meas tran vs find vd at=ts
meas tran vm1 find vd at=tm1
meas tran vm2 find vd at=tm2
echo RES vth_sign=$&vs vth_mag_lo=$&vm1 vth_mag_hi=$&vm2
meas tran thp avg v(xa.xpex.thp) from=2u to=8u
meas tran thm avg v(xa.xpex.thm) from=2u to=8u
meas tran thn avg v(xa.xpex.thn) from=2u to=8u
echo RES ladder thp=$&thp thm=$&thm thn=$&thn
meas tran iavg avg i(VDD) from=2u to=8u
echo RES iavg=$&iavg
.endc

**** end user architecture code
**.ends

* expanding   symbol:  adc2b.sym # of pins=7
** sym_path: /home/noritsuna/GPS/xschem/adc2b.sym
** sch_path: /home/noritsuna/GPS/xschem/adc2b.sch

* expanding   symbol:  sa_comp.sym # of pins=9
** sym_path: /home/noritsuna/GPS/xschem/sa_comp.sym
** sch_path: /home/noritsuna/GPS/xschem/sa_comp.sch
.subckt sa_comp INP INN REFP REFN CLK Q QB VDD VSS
*.ipin INP
*.ipin INN
*.ipin REFP
*.ipin REFN
*.ipin CLK
*.opin Q
*.opin QB
*.iopin VDD
*.iopin VSS
XMT t CLK VSS VSS nfet_03v3 L=0.28u W=8u nf=2 ad='int((nf+1)/2) * W/nf * 0.18u' as='int((nf+2)/2) * W/nf * 0.18u' pd='2*int((nf+1)/2) * (W/nf + 0.18u)'
+ ps='2*int((nf+2)/2) * (W/nf + 0.18u)' nrd='0.18u / W' nrs='0.18u / W' sa=0 sb=0 sd=0 m=1 par=1
XM1 x1 INP t VSS nfet_03v3 L=0.28u W=4u nf=1 ad='int((nf+1)/2) * W/nf * 0.18u' as='int((nf+2)/2) * W/nf * 0.18u' pd='2*int((nf+1)/2) * (W/nf + 0.18u)'
+ ps='2*int((nf+2)/2) * (W/nf + 0.18u)' nrd='0.18u / W' nrs='0.18u / W' sa=0 sb=0 sd=0 m=1 par=1
XM2 x2 INN t VSS nfet_03v3 L=0.28u W=4u nf=1 ad='int((nf+1)/2) * W/nf * 0.18u' as='int((nf+2)/2) * W/nf * 0.18u' pd='2*int((nf+1)/2) * (W/nf + 0.18u)'
+ ps='2*int((nf+2)/2) * (W/nf + 0.18u)' nrd='0.18u / W' nrs='0.18u / W' sa=0 sb=0 sd=0 m=1 par=1
XM3 x2 REFP t VSS nfet_03v3 L=0.28u W=4u nf=1 ad='int((nf+1)/2) * W/nf * 0.18u' as='int((nf+2)/2) * W/nf * 0.18u' pd='2*int((nf+1)/2) * (W/nf + 0.18u)'
+ ps='2*int((nf+2)/2) * (W/nf + 0.18u)' nrd='0.18u / W' nrs='0.18u / W' sa=0 sb=0 sd=0 m=1 par=1
XM4 x1 REFN t VSS nfet_03v3 L=0.28u W=4u nf=1 ad='int((nf+1)/2) * W/nf * 0.18u' as='int((nf+2)/2) * W/nf * 0.18u' pd='2*int((nf+1)/2) * (W/nf + 0.18u)'
+ ps='2*int((nf+2)/2) * (W/nf + 0.18u)' nrd='0.18u / W' nrs='0.18u / W' sa=0 sb=0 sd=0 m=1 par=1
XM5 on op x1 VSS nfet_03v3 L=0.28u W=2u nf=1 ad='int((nf+1)/2) * W/nf * 0.18u' as='int((nf+2)/2) * W/nf * 0.18u' pd='2*int((nf+1)/2) * (W/nf + 0.18u)'
+ ps='2*int((nf+2)/2) * (W/nf + 0.18u)' nrd='0.18u / W' nrs='0.18u / W' sa=0 sb=0 sd=0 m=1 par=1
XM6 op on x2 VSS nfet_03v3 L=0.28u W=2u nf=1 ad='int((nf+1)/2) * W/nf * 0.18u' as='int((nf+2)/2) * W/nf * 0.18u' pd='2*int((nf+1)/2) * (W/nf + 0.18u)'
+ ps='2*int((nf+2)/2) * (W/nf + 0.18u)' nrd='0.18u / W' nrs='0.18u / W' sa=0 sb=0 sd=0 m=1 par=1
XM7 on op VDD VDD pfet_03v3 L=0.28u W=2u nf=1 ad='int((nf+1)/2) * W/nf * 0.18u' as='int((nf+2)/2) * W/nf * 0.18u' pd='2*int((nf+1)/2) * (W/nf + 0.18u)'
+ ps='2*int((nf+2)/2) * (W/nf + 0.18u)' nrd='0.18u / W' nrs='0.18u / W' sa=0 sb=0 sd=0 m=1 par=1
XM8 op on VDD VDD pfet_03v3 L=0.28u W=2u nf=1 ad='int((nf+1)/2) * W/nf * 0.18u' as='int((nf+2)/2) * W/nf * 0.18u' pd='2*int((nf+1)/2) * (W/nf + 0.18u)'
+ ps='2*int((nf+2)/2) * (W/nf + 0.18u)' nrd='0.18u / W' nrs='0.18u / W' sa=0 sb=0 sd=0 m=1 par=1
XM9 on CLK VDD VDD pfet_03v3 L=0.28u W=1u nf=1 ad='int((nf+1)/2) * W/nf * 0.18u' as='int((nf+2)/2) * W/nf * 0.18u' pd='2*int((nf+1)/2) * (W/nf + 0.18u)'
+ ps='2*int((nf+2)/2) * (W/nf + 0.18u)' nrd='0.18u / W' nrs='0.18u / W' sa=0 sb=0 sd=0 m=1 par=1
XM10 op CLK VDD VDD pfet_03v3 L=0.28u W=1u nf=1 ad='int((nf+1)/2) * W/nf * 0.18u' as='int((nf+2)/2) * W/nf * 0.18u' pd='2*int((nf+1)/2) * (W/nf + 0.18u)'
+ ps='2*int((nf+2)/2) * (W/nf + 0.18u)' nrd='0.18u / W' nrs='0.18u / W' sa=0 sb=0 sd=0 m=1 par=1
XM11 x1 CLK VDD VDD pfet_03v3 L=0.28u W=1u nf=1 ad='int((nf+1)/2) * W/nf * 0.18u' as='int((nf+2)/2) * W/nf * 0.18u' pd='2*int((nf+1)/2) * (W/nf + 0.18u)'
+ ps='2*int((nf+2)/2) * (W/nf + 0.18u)' nrd='0.18u / W' nrs='0.18u / W' sa=0 sb=0 sd=0 m=1 par=1
XM12 x2 CLK VDD VDD pfet_03v3 L=0.28u W=1u nf=1 ad='int((nf+1)/2) * W/nf * 0.18u' as='int((nf+2)/2) * W/nf * 0.18u' pd='2*int((nf+1)/2) * (W/nf + 0.18u)'
+ ps='2*int((nf+2)/2) * (W/nf + 0.18u)' nrd='0.18u / W' nrs='0.18u / W' sa=0 sb=0 sd=0 m=1 par=1
XI1 op opb VDD VSS inv_dig
XI2 on onb VDD VSS inv_dig
XS1 opb QB Q VDD VSS nor2
XS2 onb Q QB VDD VSS nor2
.ends

* expanding   symbol:  nand2.sym # of pins=5
** sym_path: /home/noritsuna/GPS/xschem/nand2.sym
** sch_path: /home/noritsuna/GPS/xschem/nand2.sch
.subckt nand2 A B Y VDD VSS
*.ipin A
*.ipin B
*.opin Y
*.iopin VDD
*.iopin VSS
XMN1 Y A n1 VSS nfet_03v3 L=0.28u W=2u nf=1 ad='int((nf+1)/2) * W/nf * 0.18u' as='int((nf+2)/2) * W/nf * 0.18u' pd='2*int((nf+1)/2) * (W/nf + 0.18u)'
+ ps='2*int((nf+2)/2) * (W/nf + 0.18u)' nrd='0.18u / W' nrs='0.18u / W' sa=0 sb=0 sd=0 m=1 par=1
XMN2 n1 B VSS VSS nfet_03v3 L=0.28u W=2u nf=1 ad='int((nf+1)/2) * W/nf * 0.18u' as='int((nf+2)/2) * W/nf * 0.18u' pd='2*int((nf+1)/2) * (W/nf + 0.18u)'
+ ps='2*int((nf+2)/2) * (W/nf + 0.18u)' nrd='0.18u / W' nrs='0.18u / W' sa=0 sb=0 sd=0 m=1 par=1
XMP1 Y A VDD VDD pfet_03v3 L=0.28u W=2u nf=1 ad='int((nf+1)/2) * W/nf * 0.18u' as='int((nf+2)/2) * W/nf * 0.18u' pd='2*int((nf+1)/2) * (W/nf + 0.18u)'
+ ps='2*int((nf+2)/2) * (W/nf + 0.18u)' nrd='0.18u / W' nrs='0.18u / W' sa=0 sb=0 sd=0 m=1 par=1
XMP2 Y B VDD VDD pfet_03v3 L=0.28u W=2u nf=1 ad='int((nf+1)/2) * W/nf * 0.18u' as='int((nf+2)/2) * W/nf * 0.18u' pd='2*int((nf+1)/2) * (W/nf + 0.18u)'
+ ps='2*int((nf+2)/2) * (W/nf + 0.18u)' nrd='0.18u / W' nrs='0.18u / W' sa=0 sb=0 sd=0 m=1 par=1
.ends

* expanding   symbol:  inv_dig.sym # of pins=4
** sym_path: /home/noritsuna/GPS/xschem/inv_dig.sym
** sch_path: /home/noritsuna/GPS/xschem/inv_dig.sch
.subckt inv_dig A Y VDD VSS
*.ipin A
*.opin Y
*.iopin VDD
*.iopin VSS
XMN Y A VSS VSS nfet_03v3 L=0.28u W=1u nf=1 ad='int((nf+1)/2) * W/nf * 0.18u' as='int((nf+2)/2) * W/nf * 0.18u' pd='2*int((nf+1)/2) * (W/nf + 0.18u)'
+ ps='2*int((nf+2)/2) * (W/nf + 0.18u)' nrd='0.18u / W' nrs='0.18u / W' sa=0 sb=0 sd=0 m=1 par=1
XMP Y A VDD VDD pfet_03v3 L=0.28u W=2u nf=1 ad='int((nf+1)/2) * W/nf * 0.18u' as='int((nf+2)/2) * W/nf * 0.18u' pd='2*int((nf+1)/2) * (W/nf + 0.18u)'
+ ps='2*int((nf+2)/2) * (W/nf + 0.18u)' nrd='0.18u / W' nrs='0.18u / W' sa=0 sb=0 sd=0 m=1 par=1
.ends

* expanding   symbol:  nor2.sym # of pins=5
** sym_path: /home/noritsuna/GPS/xschem/nor2.sym
** sch_path: /home/noritsuna/GPS/xschem/nor2.sch
.subckt nor2 A B Y VDD VSS
*.ipin A
*.ipin B
*.opin Y
*.iopin VDD
*.iopin VSS
XMN1 Y A VSS VSS nfet_03v3 L=0.28u W=1u nf=1 ad='int((nf+1)/2) * W/nf * 0.18u' as='int((nf+2)/2) * W/nf * 0.18u' pd='2*int((nf+1)/2) * (W/nf + 0.18u)'
+ ps='2*int((nf+2)/2) * (W/nf + 0.18u)' nrd='0.18u / W' nrs='0.18u / W' sa=0 sb=0 sd=0 m=1 par=1
XMN2 Y B VSS VSS nfet_03v3 L=0.28u W=1u nf=1 ad='int((nf+1)/2) * W/nf * 0.18u' as='int((nf+2)/2) * W/nf * 0.18u' pd='2*int((nf+1)/2) * (W/nf + 0.18u)'
+ ps='2*int((nf+2)/2) * (W/nf + 0.18u)' nrd='0.18u / W' nrs='0.18u / W' sa=0 sb=0 sd=0 m=1 par=1
XMP1 n1 A VDD VDD pfet_03v3 L=0.28u W=4u nf=1 ad='int((nf+1)/2) * W/nf * 0.18u' as='int((nf+2)/2) * W/nf * 0.18u' pd='2*int((nf+1)/2) * (W/nf + 0.18u)'
+ ps='2*int((nf+2)/2) * (W/nf + 0.18u)' nrd='0.18u / W' nrs='0.18u / W' sa=0 sb=0 sd=0 m=1 par=1
XMP2 Y B n1 VDD pfet_03v3 L=0.28u W=4u nf=1 ad='int((nf+1)/2) * W/nf * 0.18u' as='int((nf+2)/2) * W/nf * 0.18u' pd='2*int((nf+1)/2) * (W/nf + 0.18u)'
+ ps='2*int((nf+2)/2) * (W/nf + 0.18u)' nrd='0.18u / W' nrs='0.18u / W' sa=0 sb=0 sd=0 m=1 par=1
.ends
* NGSPICE file created from adc2b_flat.ext - technology: gf180mcuD

.subckt adc2b_flat VSS VDD INP INN CLK SIGN MAG
X0 a_17060_19773# a_19300_18164# VSS ppolyf_u_1k r_width=10u r_length=7.435u
X1 VSS CLK a_21560_13640# VSS nfet_03v3 ad=1.78p pd=8.89u as=1.06p ps=4.53u w=4u l=0.28u
X2 a_3107_1769# CLK VDD VDD pfet_03v3 ad=0.445p pd=2.89u as=0.445p ps=2.89u w=1u l=0.28u
X3 a_9945_13640# CLK VDD VDD pfet_03v3 ad=0.445p pd=2.89u as=0.445p ps=2.89u w=1u l=0.28u
X4 a_1545_5582# CLK VDD VDD pfet_03v3 ad=0.445p pd=2.89u as=0.445p ps=2.89u w=1u l=0.28u
X5 a_3225_5582# a_1545_5582# VDD VDD pfet_03v3 ad=0.89p pd=4.89u as=0.89p ps=4.89u w=2u l=0.28u
X6 a_1380_18164# a_12580_18164# VSS ppolyf_u_1k r_width=10u r_length=1.4u
X7 a_3225_9782# a_1545_9782# a_6585_9782# VSS nfet_03v3 ad=0.89p pd=4.89u as=0.89p ps=4.89u w=2u l=0.28u
X8 a_14840_1180# a_11625_5582# VSS VSS nfet_03v3 ad=0.89p pd=4.89u as=0.89p ps=4.89u w=2u l=0.28u
X9 a_1545_9782# a_3225_9782# VDD VDD pfet_03v3 ad=0.89p pd=4.89u as=0.89p ps=4.89u w=2u l=0.28u
X10 a_1545_1180# a_1427_1769# VSS VSS nfet_03v3 ad=0.445p pd=2.89u as=0.445p ps=2.89u w=1u l=0.28u
X11 a_6440_1180# CLK VDD VDD pfet_03v3 ad=0.445p pd=2.89u as=0.445p ps=2.89u w=1u l=0.28u
X12 a_9945_5582# a_1545_5582# VDD VDD pfet_03v3 ad=0.89p pd=4.89u as=0.89p ps=4.89u w=2u l=0.28u
X13 a_3107_14509# SIGN a_4905_13640# VDD pfet_03v3 ad=1.78p pd=8.89u as=1.78p ps=8.89u w=4u l=0.28u
X14 a_3225_1180# a_3107_1769# VSS VSS nfet_03v3 ad=0.445p pd=2.89u as=0.445p ps=2.89u w=1u l=0.28u
X15 a_14867_1769# a_3225_1180# VSS VSS nfet_03v3 ad=0.445p pd=2.89u as=0.445p ps=2.89u w=1u l=0.28u
X16 a_3225_5582# CLK VDD VDD pfet_03v3 ad=0.445p pd=2.89u as=0.445p ps=2.89u w=1u l=0.28u
X17 a_12580_18164# a_13187_14509# VSS ppolyf_u_1k r_width=10u r_length=1.4u
X18 a_13187_5969# a_11625_5582# a_31785_13640# VDD pfet_03v3 ad=1.78p pd=8.89u as=1.78p ps=8.89u w=4u l=0.28u
X19 a_13187_5969# a_9945_5582# VSS VSS nfet_03v3 ad=0.445p pd=2.89u as=0.445p ps=2.89u w=1u l=0.28u
X20 a_5860_19890# a_3620_18164# VSS ppolyf_u_1k r_width=10u r_length=8.02u
X21 a_13187_14509# a_19300_18164# VSS ppolyf_u_1k r_width=10u r_length=7.435u
X22 a_4905_9782# CLK VDD VDD pfet_03v3 ad=0.445p pd=2.89u as=0.445p ps=2.89u w=1u l=0.28u
X23 a_8265_5582# a_3225_5582# VSS VSS nfet_03v3 ad=0.445p pd=2.89u as=0.445p ps=2.89u w=1u l=0.28u
X24 a_1545_9782# a_3225_9782# a_4905_9782# VSS nfet_03v3 ad=0.89p pd=4.89u as=0.89p ps=4.89u w=2u l=0.28u
X25 a_3225_9782# a_1545_9782# VDD VDD pfet_03v3 ad=0.89p pd=4.89u as=0.89p ps=4.89u w=2u l=0.28u
X26 a_1380_18164# VSS cap_mim_2f0_m4m5_noshield c_width=50u c_length=50u
X27 a_5860_19890# a_8100_18164# VSS ppolyf_u_1k r_width=10u r_length=8.02u
X28 VDD a_8100_18164# VSS ppolyf_u_1k r_width=10u r_length=8.02u
X29 a_9945_13640# a_1380_18164# a_8120_13640# VSS nfet_03v3 ad=1.78p pd=8.89u as=1.78p ps=8.89u w=4u l=0.28u
X30 a_6440_1180# a_13187_14509# a_21560_13640# VSS nfet_03v3 ad=1.78p pd=8.89u as=1.78p ps=8.89u w=4u l=0.28u
X31 a_1545_9782# CLK VDD VDD pfet_03v3 ad=0.445p pd=2.89u as=0.445p ps=2.89u w=1u l=0.28u
X32 a_11625_5582# a_8265_5582# VSS VSS nfet_03v3 ad=0.445p pd=2.89u as=0.445p ps=2.89u w=1u l=0.28u
X33 a_1380_19890# a_1380_18164# VSS ppolyf_u_1k r_width=10u r_length=8.02u
X34 a_14867_1769# a_16665_13640# VSS VSS nfet_03v3 ad=0.445p pd=2.89u as=0.445p ps=2.89u w=1u l=0.28u
X35 a_9945_5582# a_1545_5582# VSS VSS nfet_03v3 ad=0.445p pd=2.89u as=0.445p ps=2.89u w=1u l=0.28u
X36 MAG a_11625_5582# VDD VDD pfet_03v3 ad=0.89p pd=4.89u as=0.89p ps=4.89u w=2u l=0.28u
X37 a_4905_9782# a_12580_18164# a_25065_17980# VSS nfet_03v3 ad=1.78p pd=8.89u as=1.78p ps=8.89u w=4u l=0.28u
X38 a_9945_13640# INN a_8120_13640# VSS nfet_03v3 ad=1.78p pd=8.89u as=1.78p ps=8.89u w=4u l=0.28u
X39 a_16665_13640# a_1545_1180# VSS VSS nfet_03v3 ad=0.445p pd=2.89u as=0.445p ps=2.89u w=1u l=0.28u
X40 a_6585_9782# CLK VDD VDD pfet_03v3 ad=0.445p pd=2.89u as=0.445p ps=2.89u w=1u l=0.28u
X41 a_16665_13640# a_14867_1769# VSS VSS nfet_03v3 ad=0.445p pd=2.89u as=0.445p ps=2.89u w=1u l=0.28u
X42 a_13187_5969# a_11625_5582# VSS VSS nfet_03v3 ad=0.445p pd=2.89u as=0.445p ps=2.89u w=1u l=0.28u
X43 a_11625_5582# a_13187_5969# VSS VSS nfet_03v3 ad=0.445p pd=2.89u as=0.445p ps=2.89u w=1u l=0.28u
X44 a_1427_14509# a_3225_9782# VDD VDD pfet_03v3 ad=0.89p pd=4.89u as=0.89p ps=4.89u w=2u l=0.28u
X45 a_1380_19890# a_3620_18164# VSS ppolyf_u_1k r_width=10u r_length=8.02u
X46 a_3225_9782# CLK VDD VDD pfet_03v3 ad=0.445p pd=2.89u as=0.445p ps=2.89u w=1u l=0.28u
X47 a_3107_1769# a_1427_1769# VDD VDD pfet_03v3 ad=0.89p pd=4.89u as=0.89p ps=4.89u w=2u l=0.28u
X48 a_4905_13640# a_4787_14509# VDD VDD pfet_03v3 ad=1.78p pd=8.89u as=1.78p ps=8.89u w=4u l=0.28u
X49 a_3107_14509# a_4787_14509# VSS VSS nfet_03v3 ad=0.445p pd=2.89u as=0.445p ps=2.89u w=1u l=0.28u
X50 a_4787_14509# a_1545_9782# VDD VDD pfet_03v3 ad=0.89p pd=4.89u as=0.89p ps=4.89u w=2u l=0.28u
X51 a_31785_13640# a_9945_5582# VDD VDD pfet_03v3 ad=1.78p pd=8.89u as=1.78p ps=8.89u w=4u l=0.28u
X52 a_1427_14509# a_3225_9782# VSS VSS nfet_03v3 ad=0.445p pd=2.89u as=0.445p ps=2.89u w=1u l=0.28u
X53 SIGN a_1427_14509# VSS VSS nfet_03v3 ad=0.445p pd=2.89u as=0.445p ps=2.89u w=1u l=0.28u
X54 MAG a_14867_1769# VDD VDD pfet_03v3 ad=0.89p pd=4.89u as=0.89p ps=4.89u w=2u l=0.28u
X55 a_28425_13640# a_8265_5582# VDD VDD pfet_03v3 ad=1.78p pd=8.89u as=1.78p ps=8.89u w=4u l=0.28u
X56 a_16665_13640# a_14867_1769# a_14985_13640# VDD pfet_03v3 ad=1.78p pd=8.89u as=1.78p ps=8.89u w=4u l=0.28u
X57 a_4787_14509# a_1545_9782# VSS VSS nfet_03v3 ad=0.445p pd=2.89u as=0.445p ps=2.89u w=1u l=0.28u
X58 a_3107_1769# a_1427_1769# a_8265_13640# VSS nfet_03v3 ad=0.89p pd=4.89u as=0.89p ps=4.89u w=2u l=0.28u
X59 VSS CLK a_25065_17980# VSS nfet_03v3 ad=1.06p pd=4.53u as=1.06p ps=4.53u w=4u l=0.28u
X60 a_6440_1180# INN a_21560_13640# VSS nfet_03v3 ad=1.78p pd=8.89u as=1.78p ps=8.89u w=4u l=0.28u
X61 a_1427_1769# a_3107_1769# a_9945_13640# VSS nfet_03v3 ad=0.89p pd=4.89u as=0.89p ps=4.89u w=2u l=0.28u
X62 a_1427_1769# a_3107_1769# VDD VDD pfet_03v3 ad=0.89p pd=4.89u as=0.89p ps=4.89u w=2u l=0.28u
X63 a_3107_14509# SIGN VSS VSS nfet_03v3 ad=0.445p pd=2.89u as=0.445p ps=2.89u w=1u l=0.28u
X64 VSS CLK a_8120_13640# VSS nfet_03v3 ad=1.06p pd=4.53u as=1.06p ps=4.53u w=4u l=0.28u
X65 a_6585_9782# a_12580_18164# a_25065_17980# VSS nfet_03v3 ad=1.78p pd=8.89u as=1.78p ps=8.89u w=4u l=0.28u
X66 SIGN a_3107_14509# a_1545_13640# VDD pfet_03v3 ad=1.78p pd=8.89u as=1.78p ps=8.89u w=4u l=0.28u
X67 a_11625_5582# a_13187_5969# a_28425_13640# VDD pfet_03v3 ad=1.78p pd=8.89u as=1.78p ps=8.89u w=4u l=0.28u
X68 SIGN a_3107_14509# VSS VSS nfet_03v3 ad=0.445p pd=2.89u as=0.445p ps=2.89u w=1u l=0.28u
X69 a_1545_5582# a_3225_5582# a_4760_1180# VSS nfet_03v3 ad=0.89p pd=4.89u as=0.89p ps=4.89u w=2u l=0.28u
X70 a_6585_9782# INN a_25065_17980# VSS nfet_03v3 ad=1.78p pd=8.89u as=1.78p ps=8.89u w=4u l=0.28u
X71 a_14867_1769# a_16665_13640# a_18345_13640# VDD pfet_03v3 ad=1.78p pd=8.89u as=1.78p ps=8.89u w=4u l=0.28u
X72 a_1545_1180# a_1427_1769# VDD VDD pfet_03v3 ad=0.89p pd=4.89u as=0.89p ps=4.89u w=2u l=0.28u
X73 a_8120_13640# CLK VSS VSS nfet_03v3 ad=1.06p pd=4.53u as=1.06p ps=4.53u w=4u l=0.28u
X74 a_4760_1180# a_1380_18164# a_21560_13640# VSS nfet_03v3 ad=1.78p pd=8.89u as=1.78p ps=8.89u w=4u l=0.28u
X75 a_3225_5582# a_1545_5582# a_6440_1180# VSS nfet_03v3 ad=0.89p pd=4.89u as=0.89p ps=4.89u w=2u l=0.28u
X76 a_12580_18164# VSS cap_mim_2f0_m4m5_noshield c_width=50u c_length=50u
X77 a_21560_13640# CLK VSS VSS nfet_03v3 ad=1.06p pd=4.53u as=1.06p ps=4.53u w=4u l=0.28u
X78 a_14985_13640# a_1545_1180# VDD VDD pfet_03v3 ad=1.78p pd=8.89u as=1.78p ps=8.89u w=4u l=0.28u
X79 a_1427_1769# CLK VDD VDD pfet_03v3 ad=0.445p pd=2.89u as=0.445p ps=2.89u w=1u l=0.28u
X80 a_8265_13640# INP a_8120_13640# VSS nfet_03v3 ad=1.78p pd=8.89u as=1.78p ps=8.89u w=4u l=0.28u
X81 a_4760_1180# INP a_21560_13640# VSS nfet_03v3 ad=1.78p pd=8.89u as=1.78p ps=8.89u w=4u l=0.28u
X82 a_8265_13640# CLK VDD VDD pfet_03v3 ad=0.445p pd=2.89u as=0.445p ps=2.89u w=1u l=0.28u
X83 a_3225_1180# a_3107_1769# VDD VDD pfet_03v3 ad=0.89p pd=4.89u as=0.89p ps=4.89u w=2u l=0.28u
X84 a_17060_19773# VSS VSS ppolyf_u_1k r_width=10u r_length=7.435u
X85 a_1545_13640# a_1427_14509# VDD VDD pfet_03v3 ad=1.78p pd=8.89u as=1.78p ps=8.89u w=4u l=0.28u
X86 a_18345_13640# a_3225_1180# VDD VDD pfet_03v3 ad=1.78p pd=8.89u as=1.78p ps=8.89u w=4u l=0.28u
X87 MAG a_14867_1769# a_14840_1180# VSS nfet_03v3 ad=0.89p pd=4.89u as=0.89p ps=4.89u w=2u l=0.28u
X88 a_8265_13640# a_13187_14509# a_8120_13640# VSS nfet_03v3 ad=1.78p pd=8.89u as=1.78p ps=8.89u w=4u l=0.28u
X89 a_1545_5582# a_3225_5582# VDD VDD pfet_03v3 ad=0.89p pd=4.89u as=0.89p ps=4.89u w=2u l=0.28u
X90 a_13187_14509# VSS cap_mim_2f0_m4m5_noshield c_width=50u c_length=50u
X91 a_25065_17980# CLK VSS VSS nfet_03v3 ad=1.06p pd=4.53u as=1.78p ps=8.89u w=4u l=0.28u
X92 a_4905_9782# INP a_25065_17980# VSS nfet_03v3 ad=1.78p pd=8.89u as=1.78p ps=8.89u w=4u l=0.28u
X93 a_4760_1180# CLK VDD VDD pfet_03v3 ad=0.445p pd=2.89u as=0.445p ps=2.89u w=1u l=0.28u
X94 a_8265_5582# a_3225_5582# VDD VDD pfet_03v3 ad=0.89p pd=4.89u as=0.89p ps=4.89u w=2u l=0.28u
C0 INN a_29004_17920# 0.01642f
C1 a_4787_14509# a_6440_1180# 0.0399f
C2 a_1427_1769# VSS 0.17868f
C3 a_9945_5582# a_4905_9782# 0.06915f
C4 a_13187_5969# a_6585_9782# 0.04359f
C5 a_11625_5582# a_4905_9782# 0.89609f
C6 INN a_4905_9782# 0.08417f
C7 VDD a_5860_19890# 0.01044f
C8 VDD a_13044_1120# 0.36569f
C9 a_9945_5582# a_21560_13640# 0.02478f
C10 a_13454_13580# a_13044_13580# 0.0129f
C11 a_6585_9782# a_28425_13640# 0.05635f
C12 VDD SIGN 3.26579f
C13 a_11625_5582# a_21560_13640# 0.72259f
C14 a_3107_1769# VSS 0.06554f
C15 INN a_21560_13640# 0.09938f
C16 a_13187_5969# a_4905_9782# 0.03676f
C17 a_4787_14509# a_4760_1180# 0.03557f
C18 a_6585_9782# a_8265_5582# 0.17622f
C19 a_18084_5180# a_4905_9782# 0.02528f
C20 INN a_8120_13640# 0.10508f
C21 VDD INP 0.51544f
C22 a_3225_5582# VSS 0.02384f
C23 a_14867_1769# a_9945_13640# 0.03275f
C24 a_5054_1120# a_1545_5582# 0.02687f
C25 INN a_25065_17980# 0.5212f
C26 a_8265_5582# a_4905_9782# 0.06681f
C27 VDD a_11774_1120# 0.35048f
C28 a_3225_1180# a_3374_1120# 0.02481f
C29 a_14867_1769# a_8265_13640# 0.03263f
C30 a_9945_13640# a_1380_18164# 0.05549f
C31 a_8265_5582# a_21560_13640# 0.69079f
C32 a_1427_14509# a_6440_1180# 0.03849f
C33 a_3225_1180# a_4787_14509# 0.03336f
C34 a_1545_1180# a_9945_13640# 0.13508f
C35 a_1545_1180# a_8265_13640# 0.15545f
C36 a_8265_5582# a_8120_13640# 0.28411f
C37 a_1545_9782# SIGN 0.17234f
C38 a_13454_13580# a_8265_13640# 0.05511f
C39 a_1694_5522# a_1545_5582# 0.01511f
C40 a_1427_14509# a_4760_1180# 0.03849f
C41 INN a_13187_14509# 0.38094f
C42 a_4787_14509# a_14867_1769# 0.12207f
C43 a_11774_13580# a_11364_13580# 0.0129f
C44 a_14867_1769# a_33614_9722# 0.01149f
C45 a_13044_13580# a_8265_13640# 0.01014f
C46 a_26484_13580# a_21560_13640# 0.04769f
C47 a_1545_1180# a_4905_13640# 0.16066f
C48 INN a_12580_18164# 0.0461f
C49 a_14840_1180# a_14724_1120# 0.01998f
C50 a_3107_14509# a_3225_1180# 0.58755f
C51 VDD CLK 8.75348f
C52 a_1545_1180# a_4787_14509# 0.45324f
C53 a_11774_13580# a_9945_13640# 0.05515f
C54 a_25214_13580# a_21560_13640# 0.01421f
C55 a_6585_9782# a_6440_1180# 0.06916f
C56 a_10094_13580# a_9945_13640# 0.05054f
C57 a_10094_13580# a_9684_13580# 0.0129f
C58 VDD a_20174_1120# 0.35048f
C59 a_21560_13640# a_24804_13580# 0.04856f
C60 a_1427_14509# a_3225_1180# 0.03849f
C61 a_3107_14509# a_14867_1769# 0.06263f
C62 a_6324_1120# a_6440_1180# 0.02173f
C63 MAG a_18084_1120# 0.01113f
C64 a_6440_1180# a_4905_9782# 0.06329f
C65 a_6585_9782# a_4760_1180# 0.06987f
C66 a_21560_13640# a_6440_1180# 0.60728f
C67 a_23124_13580# a_21560_13640# 0.04806f
C68 a_9945_5582# SIGN 0.031f
C69 a_1427_14509# a_14867_1769# 1.36419f
C70 INN a_3620_18164# 0.01089f
C71 a_9945_13640# a_8265_13640# 0.72106f
C72 VDD a_23124_5180# 0.36272f
C73 a_3107_14509# a_1545_1180# 0.21687f
C74 a_11625_5582# SIGN 0.04359f
C75 a_8414_13580# a_8265_13640# 0.04756f
C76 a_4760_1180# a_4905_9782# 0.14294f
C77 VDD a_4644_5522# 0.22416f
C78 MAG SIGN 0.059f
C79 a_13187_5969# SIGN 0.04359f
C80 a_21854_13580# a_21560_13640# 0.01648f
C81 a_8414_13580# a_8004_13580# 0.0129f
C82 a_1545_13640# a_1545_1180# 0.13548f
C83 a_4760_1180# a_21560_13640# 0.59145f
C84 VDD a_21444_5180# 0.3627f
C85 a_3225_9782# VSS 0.14182f
C86 a_1427_14509# a_1545_1180# 0.39386f
C87 a_11625_5582# INP 0.15473f
C88 a_1427_1769# a_1545_5582# 0.03901f
C89 INN INP 0.0566f
C90 a_1545_9782# VSS 3.54177f
C91 a_3225_1180# a_6585_9782# 0.04356f
C92 a_21560_13640# a_21444_13580# 0.04076f
C93 a_4787_14509# a_9945_13640# 0.06792f
C94 a_6324_13580# a_6734_13580# 0.0129f
C95 a_6324_13580# a_4905_13640# 0.05265f
C96 a_8265_5582# SIGN 0.35982f
C97 a_3107_1769# a_1545_5582# 0.03025f
C98 a_4787_14509# a_8265_13640# 1.66651f
C99 a_3225_1180# a_4905_9782# 0.08272f
C100 a_5054_13580# a_4905_13640# 0.04654f
C101 a_16665_13640# a_6585_9782# 0.62496f
C102 a_6585_9782# a_14867_1769# 0.05754f
C103 a_4644_13580# a_5054_13580# 0.0129f
C104 a_3225_1180# a_21560_13640# 0.08792f
C105 a_4760_1180# a_5054_5522# 0.01297f
C106 a_3225_9782# a_23124_5180# 0.01236f
C107 a_13187_14509# a_6440_1180# 0.08798f
C108 a_16665_13640# a_4905_9782# 0.04248f
C109 a_4787_14509# a_4905_13640# 0.09381f
C110 a_3225_5582# a_1545_5582# 1.48483f
C111 a_14867_1769# a_4905_9782# 0.06677f
C112 VDD a_23534_5180# 0.34888f
C113 a_16665_13640# a_21560_13640# 0.03321f
C114 a_3225_9782# a_21444_5180# 0.01189f
C115 a_3225_1180# a_8120_13640# 0.04081f
C116 a_3107_14509# a_9945_13640# 0.03838f
C117 a_1545_1180# a_6585_9782# 0.06062f
C118 a_8265_5582# a_11774_1120# 0.02168f
C119 a_1380_18164# a_4905_9782# 0.07043f
C120 a_3107_14509# a_8265_13640# 0.38203f
C121 CLK a_9945_5582# 0.07372f
C122 a_1545_1180# a_4905_9782# 0.0426f
C123 VDD a_6734_5522# 0.21693f
C124 a_21560_13640# a_1380_18164# 0.0914f
C125 a_1427_1769# a_20174_9722# 0.01179f
C126 a_1427_14509# a_9945_13640# 0.26993f
C127 CLK a_11625_5582# 0.06885f
C128 INN CLK 0.1077f
C129 a_3107_14509# a_6734_13580# 0.05018f
C130 a_3107_14509# a_4905_13640# 0.20444f
C131 a_1545_1180# a_21560_13640# 0.0847f
C132 a_1427_14509# a_8265_13640# 0.18704f
C133 a_1427_1769# a_3107_1769# 6.4974f
C134 a_8120_13640# a_1380_18164# 1.02045f
C135 VDD a_1694_5522# 0.21379f
C136 a_3107_14509# a_4787_14509# 0.14034f
C137 a_20174_1120# MAG 0.0228f
C138 a_3225_1180# a_13187_14509# 0.03033f
C139 a_1545_1180# a_8120_13640# 0.1345f
C140 a_3107_1769# a_18494_9722# 0.01149f
C141 SIGN a_6440_1180# 0.03944f
C142 a_3374_13580# a_2964_13580# 0.0129f
C143 a_23534_5180# a_3225_9782# 0.0264f
C144 a_8120_13640# a_13044_13580# 0.05346f
C145 VDD a_1545_5582# 3.06415f
C146 a_3374_5522# a_3225_5582# 0.01511f
C147 CLK a_8265_5582# 0.0672f
C148 a_16665_13640# a_13187_14509# 0.05243f
C149 a_1427_14509# a_4787_14509# 0.78234f
C150 a_3107_1769# a_3225_5582# 0.03039f
C151 a_4760_1180# SIGN 0.03944f
C152 a_6585_9782# a_9945_13640# 3.25682f
C153 a_1427_14509# a_25214_5180# 0.01988f
C154 VDD a_23534_9722# 0.21366f
C155 a_1380_18164# a_13187_14509# 0.09781f
C156 a_6585_9782# a_8265_13640# 0.06195f
C157 a_1545_13640# a_2964_13580# 0.05265f
C158 VDD a_23124_9722# 0.22595f
C159 a_9945_13640# a_4905_9782# 0.09428f
C160 a_12580_18164# a_1380_18164# 0.28092f
C161 a_1545_1180# a_13187_14509# 0.25981f
C162 a_11364_13580# a_8120_13640# 0.05114f
C163 a_3107_14509# a_1545_13640# 0.04905f
C164 a_1545_13640# a_1694_13580# 0.0476f
C165 a_8120_13640# a_10094_13580# 0.01105f
C166 a_8265_13640# a_4905_9782# 0.05187f
C167 INP a_4760_1180# 0.14345f
C168 a_1284_13580# a_1694_13580# 0.0129f
C169 a_3107_14509# a_1427_14509# 0.43695f
C170 a_1427_14509# a_1694_13580# 0.01315f
C171 a_1694_1120# a_1545_1180# 0.02481f
C172 VDD a_21854_9722# 0.21366f
C173 a_3225_9782# a_19764_5180# 0.01352f
C174 a_3225_1180# SIGN 0.10977f
C175 a_3225_9782# a_1545_5582# 0.05191f
C176 VDD a_21444_9722# 0.22595f
C177 a_1545_13640# a_1427_14509# 0.13828f
C178 a_4787_14509# a_6585_9782# 0.03196f
C179 a_8120_13640# a_9945_13640# 0.86132f
C180 a_8120_13640# a_9684_13580# 0.0497f
C181 a_16814_1120# a_14840_1180# 0.01988f
C182 a_8414_13580# a_8120_13640# 0.01483f
C183 VDD a_20174_9722# 0.21554f
C184 a_8100_18164# a_1380_18164# 0.1364f
C185 VDD a_1427_1769# 3.20478f
C186 a_18345_13640# INP 0.02357f
C187 a_8120_13640# a_8265_13640# 0.6763f
C188 a_16665_13640# SIGN 0.0412f
C189 a_4787_14509# a_4905_9782# 0.03266f
C190 a_32364_17920# a_32774_17920# 0.0129f
C191 VDD a_3374_5522# 0.21462f
C192 INP a_3225_1180# 3.47182f
C193 SIGN a_14867_1769# 0.25743f
C194 VDD a_19764_9722# 0.22407f
C195 VDD a_18494_9722# 0.21554f
C196 a_8004_13580# a_8120_13640# 0.04076f
C197 VDD a_3107_1769# 3.17946f
C198 CLK a_6440_1180# 0.24324f
C199 a_18084_9722# VDD 0.22407f
C200 a_30684_17920# a_31094_17920# 0.0129f
C201 a_3620_18164# a_1380_18164# 0.12495f
C202 a_16665_13640# INP 0.08988f
C203 INP a_14867_1769# 0.65945f
C204 a_1545_1180# SIGN 0.22676f
C205 INP a_14985_13640# 0.05488f
C206 a_13187_5969# a_16814_5522# 0.01149f
C207 VDD a_3225_5582# 3.12079f
C208 CLK a_4760_1180# 0.48944f
C209 INP a_1380_18164# 0.03613f
C210 a_13187_14509# a_8265_13640# 0.05649f
C211 a_1427_14509# a_6585_9782# 0.04952f
C212 a_1427_1769# a_3225_9782# 0.18326f
C213 a_1545_1180# INP 0.61228f
C214 a_31094_17920# a_6585_9782# 0.04074f
C215 a_9945_5582# a_1545_5582# 0.11388f
C216 a_30684_17920# a_6585_9782# 0.01801f
C217 a_1427_14509# a_4905_9782# 0.05089f
C218 a_1545_9782# a_1427_1769# 0.25848f
C219 a_6585_9782# a_29414_17920# 0.04432f
C220 a_32774_17920# a_4905_9782# 0.04071f
C221 a_11364_1120# a_3225_5582# 0.01141f
C222 a_3107_1769# a_3225_9782# 0.04964f
C223 a_32364_17920# a_4905_9782# 0.01666f
C224 a_29004_17920# a_29414_17920# 0.0129f
C225 a_1427_1769# a_28164_5180# 0.01052f
C226 CLK a_3225_1180# 0.11884f
C227 a_1545_9782# a_3107_1769# 0.03181f
C228 a_9684_1120# a_1545_5582# 0.01048f
C229 a_16665_13640# CLK 0.03094f
C230 a_6734_1120# a_3225_5582# 0.02811f
C231 CLK a_14867_1769# 0.49657f
C232 SIGN a_9945_13640# 0.28829f
C233 a_8265_5582# a_1545_5582# 0.08902f
C234 a_32364_17920# a_25065_17980# 0.04777f
C235 a_31094_17920# a_25065_17980# 0.0105f
C236 a_6585_9782# a_29004_17920# 0.01723f
C237 SIGN a_8265_13640# 0.0345f
C238 CLK a_1380_18164# 0.03733f
C239 a_30684_17920# a_25065_17980# 0.04992f
C240 a_6585_9782# a_4905_9782# 4.39473f
C241 INP a_9945_13640# 0.02375f
C242 a_27734_17920# a_4905_9782# 0.04384f
C243 CLK a_1545_1180# 0.23849f
C244 a_1427_1769# a_9945_5582# 0.02915f
C245 a_3107_1769# a_31934_5180# 0.02085f
C246 SIGN a_6734_13580# 0.01385f
C247 a_6734_9722# VDD 0.21429f
C248 SIGN a_4905_13640# 0.15412f
C249 a_26894_5180# VDD 0.35048f
C250 a_27734_17920# a_27324_17920# 0.0129f
C251 a_1427_1769# a_11625_5582# 0.03124f
C252 a_6324_9722# VDD 0.2246f
C253 INP a_8265_13640# 1.13075f
C254 a_27324_17920# a_4905_9782# 0.01582f
C255 VDD a_5054_9722# 0.21429f
C256 a_3107_1769# a_28574_5180# 0.02085f
C257 VDD a_11364_1120# 0.36536f
C258 a_9945_5582# a_10094_5522# 0.01275f
C259 a_21560_13640# a_4905_9782# 0.04608f
C260 a_9945_5582# a_3107_1769# 0.03124f
C261 a_6734_5522# a_6440_1180# 0.01367f
C262 VDD a_4644_9722# 0.2246f
C263 a_13187_5969# a_1427_1769# 0.03676f
C264 a_4787_14509# SIGN 0.23647f
C265 a_11625_5582# a_3107_1769# 0.03124f
C266 INP a_4905_13640# 0.02349f
C267 a_6585_9782# a_25065_17980# 0.9352f
C268 a_32364_17920# a_12580_18164# 0.01219f
C269 a_3374_13580# SIGN 0.04921f
C270 VDD a_3225_9782# 2.96565f
C271 a_29004_17920# a_25065_17980# 0.04966f
C272 VDD a_3374_9722# 0.21429f
C273 a_13187_5969# a_3107_1769# 0.0364f
C274 a_27734_17920# a_25065_17980# 0.0103f
C275 a_30684_17920# a_12580_18164# 0.01378f
C276 VDD a_2964_9722# 0.22669f
C277 a_29844_5180# a_9945_13640# 0.02366f
C278 VDD a_1284_5522# 0.22745f
C279 a_25065_17980# a_4905_9782# 0.97364f
C280 INP a_4787_14509# 0.03332f
C281 a_3225_9782# a_8414_9722# 0.01119f
C282 VDD a_1694_9722# 0.21379f
C283 a_27324_17920# a_25065_17980# 0.04806f
C284 a_1427_1769# a_8265_5582# 0.03348f
C285 a_1545_9782# VDD 2.53933f
C286 a_8120_13640# a_21560_13640# 0.06956f
C287 a_30254_5180# a_1427_1769# 0.02318f
C288 a_21560_13640# a_25065_17980# 0.08953f
C289 a_3107_14509# SIGN 1.3042f
C290 a_1545_5582# a_6440_1180# 0.14213f
C291 VDD a_33614_13580# 0.58576f
C292 VDD a_1284_9722# 0.22745f
C293 a_3107_1769# a_8265_5582# 0.03124f
C294 VDD a_33204_13580# 0.58276f
C295 CLK a_9945_13640# 0.04994f
C296 a_1545_13640# SIGN 0.2054f
C297 VDD a_6324_5522# 0.22416f
C298 a_9684_1120# a_3225_5582# 0.01236f
C299 a_8120_13640# a_25065_17980# 0.1403f
C300 a_6585_9782# a_12580_18164# 0.13662f
C301 a_1427_14509# SIGN 0.98717f
C302 VDD a_31934_13580# 0.60202f
C303 CLK a_8265_13640# 0.06143f
C304 a_8120_13640# a_19300_18164# 0.48673f
C305 a_3107_14509# INP 0.13173f
C306 a_11625_5582# a_11774_5522# 0.01226f
C307 a_4760_1180# a_1545_5582# 0.29843f
C308 a_8265_5582# a_3225_5582# 0.18211f
C309 a_8265_5582# a_8414_5522# 0.01511f
C310 a_3374_9722# a_3225_9782# 0.01638f
C311 a_12580_18164# a_4905_9782# 1.08472f
C312 VDD a_31934_5180# 0.35048f
C313 a_21560_13640# a_13187_14509# 0.05573f
C314 a_13187_5969# a_15134_5522# 0.01269f
C315 a_1545_13640# INP 0.05272f
C316 a_1427_1769# a_31524_5180# 0.01163f
C317 a_1545_9782# a_3225_9782# 1.05195f
C318 a_21560_13640# a_12580_18164# 0.02406f
C319 a_1427_14509# INP 0.05907f
C320 VDD a_31785_13640# 0.86412f
C321 VDD a_31524_13580# 0.63502f
C322 VDD a_9945_5582# 2.17249f
C323 a_1545_9782# a_1694_9722# 0.01749f
C324 VDD a_30254_13580# 0.58576f
C325 a_8120_13640# a_13187_14509# 0.73599f
C326 VDD a_11625_5582# 2.59763f
C327 CLK a_4787_14509# 0.69638f
C328 INN VDD 2.6528f
C329 VDD a_29844_13580# 0.58308f
C330 a_8120_13640# a_12580_18164# 0.82951f
C331 a_3225_1180# a_26894_9722# 0.01151f
C332 a_3225_1180# a_1545_5582# 0.03234f
C333 VDD MAG 1.16766f
C334 VDD a_1284_1120# 0.36665f
C335 a_13187_5969# VDD 1.36097f
C336 a_12580_18164# a_25065_17980# 0.17248f
C337 a_1427_1769# a_6440_1180# 0.03557f
C338 a_19300_18164# a_13187_14509# 0.19841f
C339 a_6585_9782# SIGN 0.04475f
C340 VDD a_28425_13640# 0.89589f
C341 VDD a_28574_13580# 0.60202f
C342 VDD a_9684_1120# 0.36272f
C343 a_3107_1769# a_6440_1180# 0.03124f
C344 VDD a_28164_13580# 0.63502f
C345 SIGN a_4905_9782# 0.05216f
C346 a_33614_13580# a_33204_13580# 0.0129f
C347 a_1427_1769# a_4760_1180# 0.03124f
C348 a_3107_14509# CLK 0.1062f
C349 VDD a_8265_5582# 2.19971f
C350 a_9945_5582# a_3225_9782# 0.32557f
C351 a_14867_1769# a_31934_9722# 0.01296f
C352 a_12580_18164# a_13187_14509# 0.91934f
C353 a_3225_5582# a_6440_1180# 0.3552f
C354 a_3107_1769# a_4760_1180# 0.49206f
C355 a_10094_1120# a_3225_5582# 0.0264f
C356 a_11625_5582# a_3225_9782# 0.29898f
C357 VDD a_33204_5180# 0.36279f
C358 a_1545_1180# a_1545_5582# 0.03901f
C359 INP a_4905_9782# 0.09177f
C360 a_1427_14509# CLK 0.31786f
C361 a_1545_9782# a_9945_5582# 0.02929f
C362 a_14867_1769# a_31524_9722# 0.01027f
C363 a_1545_9782# a_11625_5582# 0.03124f
C364 a_13187_5969# a_3225_9782# 0.44882f
C365 INP a_21560_13640# 0.05986f
C366 a_25214_9722# a_1545_1180# 0.01181f
C367 a_31785_13640# a_33204_13580# 0.04876f
C368 a_17060_19773# a_13187_14509# 0.01062f
C369 a_4760_1180# a_3225_5582# 0.11381f
C370 a_1427_1769# a_3225_1180# 0.1014f
C371 a_3225_9782# a_18494_5180# 0.01078f
C372 a_1545_9782# a_13187_5969# 0.04359f
C373 a_3225_9782# a_18084_5180# 0.01144f
C374 a_11625_5582# a_33204_13580# 0.01513f
C375 INP a_8120_13640# 0.15726f
C376 a_1545_9782# a_18494_5180# 0.02343f
C377 a_31785_13640# a_31934_13580# 0.0476f
C378 a_31934_13580# a_31524_13580# 0.0129f
C379 a_3225_1180# a_3107_1769# 1.80038f
C380 a_16665_13640# a_28574_9722# 0.01749f
C381 INP a_25065_17980# 0.05748f
C382 VDD a_31524_5180# 0.36281f
C383 a_8100_18164# a_12580_18164# 0.01008f
C384 a_8265_5582# a_3225_9782# 0.10258f
C385 a_13187_5969# a_33614_13580# 0.04066f
C386 a_13187_5969# a_33204_13580# 0.01542f
C387 a_1427_1769# a_14867_1769# 0.16113f
C388 INP a_19300_18164# 0.04779f
C389 a_1545_9782# a_8265_5582# 0.02929f
C390 CLK a_6585_9782# 0.01694f
C391 a_3225_1180# a_3225_5582# 0.03234f
C392 a_3107_1769# a_14867_1769# 0.15107f
C393 a_9945_5582# a_31785_13640# 0.0727f
C394 a_9945_5582# a_31524_13580# 0.01608f
C395 VDD a_6440_1180# 1.81794f
C396 a_1427_1769# a_1545_1180# 2.08442f
C397 VDD a_10094_1120# 0.34888f
C398 VDD a_2964_1120# 0.36665f
C399 a_11625_5582# a_31785_13640# 0.1413f
C400 CLK a_4905_9782# 0.0173f
C401 a_9945_5582# a_11625_5582# 0.7174f
C402 a_11625_5582# a_30254_13580# 0.04415f
C403 INP a_13187_14509# 0.20757f
C404 a_29844_13580# a_30254_13580# 0.0129f
C405 a_11625_5582# a_29844_13580# 0.02046f
C406 a_13187_5969# a_31785_13640# 0.36246f
C407 CLK a_21560_13640# 0.58826f
C408 a_1545_1180# a_3107_1769# 0.04723f
C409 a_13187_5969# a_9945_5582# 0.32341f
C410 INP a_12580_18164# 0.75944f
C411 a_11625_5582# MAG 0.1601f
C412 VDD a_4760_1180# 1.63123f
C413 a_23534_9722# a_9945_13640# 0.01386f
C414 a_13187_5969# a_11625_5582# 1.40168f
C415 a_13187_5969# a_29844_13580# 0.01476f
C416 a_9945_5582# a_28425_13640# 0.01458f
C417 CLK a_8120_13640# 0.1599f
C418 a_11625_5582# a_28425_13640# 0.39058f
C419 a_28425_13640# a_29844_13580# 0.0487f
C420 VDD a_20174_13580# 0.5834f
C421 CLK a_24804_17920# 0.0105f
C422 CLK a_25065_17980# 0.16021f
C423 a_9945_5582# a_8265_5582# 3.04027f
C424 a_19764_13580# VDD 0.58329f
C425 VDD a_18494_1120# 0.34967f
C426 a_13187_5969# a_28425_13640# 0.20993f
C427 a_4760_1180# a_4644_1120# 0.02982f
C428 a_18494_13580# VDD 0.60019f
C429 a_11625_5582# a_8265_5582# 1.05111f
C430 a_18345_13640# VDD 0.88551f
C431 a_3225_9782# a_6440_1180# 0.10172f
C432 VDD a_18084_13580# 0.63479f
C433 a_28425_13640# a_28574_13580# 0.0476f
C434 VDD a_3225_1180# 2.48505f
C435 a_21854_9722# a_8265_13640# 0.01645f
C436 a_1545_9782# a_6440_1180# 0.0436f
C437 a_28574_13580# a_28164_13580# 0.0129f
C438 a_1427_1769# a_9945_13640# 0.33884f
C439 VDD a_16814_13580# 0.58394f
C440 a_8265_5582# a_28425_13640# 0.06354f
C441 INP SIGN 0.71066f
C442 a_16404_13580# VDD 0.58329f
C443 a_4760_1180# a_3225_9782# 0.26947f
C444 VDD a_16665_13640# 1.33208f
C445 a_1427_1769# a_8265_13640# 1.68655f
C446 CLK a_13187_14509# 0.04735f
C447 a_8265_5582# a_28164_13580# 0.01563f
C448 VDD a_14867_1769# 2.70723f
C449 a_15134_13580# VDD 0.60019f
C450 a_3107_1769# a_9945_13640# 0.16354f
C451 a_1545_9782# a_4760_1180# 0.23608f
C452 VDD a_14985_13640# 0.89075f
C453 CLK a_12580_18164# 0.06839f
C454 VDD a_14724_13580# 0.63479f
C455 VDD a_1380_18164# 1.56448f
C456 a_3107_1769# a_8265_13640# 0.58595f
C457 VDD a_1545_1180# 3.18224f
C458 a_1427_1769# a_4787_14509# 1.49802f
C459 a_3225_1180# a_3225_9782# 0.03849f
C460 a_9945_5582# a_6440_1180# 0.0964f
C461 a_1545_9782# a_3225_1180# 0.03755f
C462 a_3107_1769# a_4787_14509# 0.03834f
C463 a_11625_5582# a_6440_1180# 0.1137f
C464 a_26894_13580# a_26484_13580# 0.0129f
C465 INN a_6440_1180# 0.05972f
C466 VDD a_24804_5180# 0.36281f
C467 a_14867_1769# a_3225_9782# 0.03569f
C468 a_3225_9782# a_20174_5180# 0.02814f
C469 CLK SIGN 0.13922f
C470 a_13187_5969# a_6440_1180# 0.14038f
C471 a_9945_5582# a_4760_1180# 0.56868f
C472 a_1545_9782# a_14867_1769# 0.14168f
C473 a_3107_14509# a_1427_1769# 0.09797f
C474 a_6585_9782# a_19764_5180# 0.02366f
C475 a_16665_13640# a_30254_9722# 0.0153f
C476 a_11625_5582# a_4760_1180# 1.15214f
C477 a_8414_1120# a_1545_5582# 0.02254f
C478 a_11625_5582# a_14840_1180# 0.04369f
C479 a_13187_5969# a_4760_1180# 0.25054f
C480 CLK INP 0.93207f
C481 a_3107_14509# a_3107_1769# 0.01262f
C482 a_8265_5582# a_6440_1180# 0.09513f
C483 a_1427_14509# a_1427_1769# 0.24148f
C484 a_1545_9782# a_1545_1180# 0.03761f
C485 VDD a_9945_13640# 0.91402f
C486 MAG a_14840_1180# 0.39581f
C487 a_18345_13640# a_11625_5582# 0.06412f
C488 VDD a_8265_13640# 1.29667f
C489 a_9945_5582# a_3225_1180# 0.03887f
C490 a_24804_5180# a_3225_9782# 0.0107f
C491 a_1427_14509# a_3107_1769# 0.11552f
C492 MAG a_18494_1120# 0.0228f
C493 a_11625_5582# a_3225_1180# 0.03332f
C494 INN a_3225_1180# 0.269f
C495 a_4760_1180# a_8265_5582# 0.22634f
C496 a_11625_5582# a_13454_5522# 0.01247f
C497 VDD a_6734_13580# 0.5834f
C498 a_3107_14509# a_16814_9722# 0.01153f
C499 VDD a_6324_13580# 0.58329f
C500 a_26894_13580# a_4760_1180# 0.04068f
C501 VDD a_4905_13640# 0.89075f
C502 VDD a_5054_13580# 0.59966f
C503 a_16665_13640# a_9945_5582# 0.04371f
C504 a_25214_13580# a_24804_13580# 0.0129f
C505 a_13187_5969# a_3225_1180# 0.0443f
C506 VDD a_2964_5522# 0.22647f
C507 VDD a_3374_1120# 0.34678f
C508 a_16665_13640# a_11625_5582# 0.04466f
C509 INN a_16665_13640# 0.0471f
C510 a_9945_5582# a_14867_1769# 0.03896f
C511 VDD a_4644_13580# 0.63556f
C512 a_11625_5582# a_14867_1769# 0.90224f
C513 a_3107_14509# a_15134_9722# 0.01621f
C514 VDD a_4787_14509# 1.8822f
C515 a_4787_14509# a_10094_9722# 0.01655f
C516 a_25214_13580# a_6440_1180# 0.04068f
C517 a_13187_5969# a_16665_13640# 0.04331f
C518 a_1427_1769# a_6585_9782# 0.08521f
C519 a_18345_13640# a_8265_5582# 0.02741f
C520 MAG a_14867_1769# 0.27453f
C521 a_4760_1180# a_26484_13580# 0.01698f
C522 a_13187_5969# a_14867_1769# 0.42771f
C523 INN a_1380_18164# 2.10377f
C524 a_16665_13640# a_28425_13640# 0.05654f
C525 a_3225_1180# a_8265_5582# 0.03229f
C526 a_1545_1180# a_9945_5582# 0.03887f
C527 a_25214_5180# VDD 0.35048f
C528 a_24804_13580# a_6440_1180# 0.01816f
C529 a_3374_13580# VDD 0.5834f
C530 MAG a_15134_1120# 0.02496f
C531 a_1545_1180# a_11625_5582# 0.04718f
C532 a_1427_1769# a_4905_9782# 0.08465f
C533 INN a_1545_1180# 0.18707f
C534 a_3107_1769# a_6585_9782# 0.1764f
C535 a_1545_9782# a_9945_13640# 0.06269f
C536 a_26894_5180# a_4787_14509# 0.01988f
C537 a_23534_13580# a_6440_1180# 0.04288f
C538 a_16665_13640# a_8265_5582# 0.06016f
C539 VDD a_2964_13580# 0.58329f
C540 a_23124_13580# a_23534_13580# 0.0129f
C541 a_1545_9782# a_8265_13640# 0.06296f
C542 a_23124_13580# a_6440_1180# 0.02108f
C543 a_8265_5582# a_14867_1769# 0.08988f
C544 a_3107_1769# a_4905_9782# 4.37857f
C545 a_1427_14509# a_11774_9722# 0.01239f
C546 a_14985_13640# a_8265_5582# 0.04031f
C547 a_3107_14509# VDD 1.18866f
C548 VDD a_1694_13580# 0.59998f
C549 a_28164_5180# a_8265_13640# 0.02368f
C550 VDD a_13454_1120# 0.3476f
C551 a_8414_1120# a_3225_5582# 0.0121f
C552 VDD a_19764_1120# 0.36279f
C553 a_1545_13640# VDD 0.89772f
C554 a_6324_1120# a_3225_5582# 0.01553f
C555 a_4760_1180# a_6440_1180# 3.43699f
C556 a_4787_14509# a_3225_9782# 0.0841f
C557 VDD a_1284_13580# 0.63738f
C558 a_1545_1180# a_8265_5582# 0.03294f
C559 a_1427_14509# VDD 2.97451f
C560 a_1427_14509# a_11364_9722# 0.01112f
C561 VDD a_26484_5180# 0.36281f
C562 a_8004_1120# a_3225_5582# 0.01251f
C563 a_1545_9782# a_4787_14509# 2.96396f
C564 a_1427_14509# a_8414_9722# 0.01857f
C565 a_21854_13580# a_4760_1180# 0.04322f
C566 a_9945_5582# a_9945_13640# 0.03287f
C567 a_11625_5582# a_9945_13640# 0.0285f
C568 INN a_9945_13640# 0.05439f
C569 a_13044_1120# a_1545_5582# 0.01157f
C570 a_3225_1180# a_6440_1180# 0.40777f
C571 a_21854_13580# a_21444_13580# 0.0129f
C572 a_4760_1180# a_21444_13580# 0.02132f
C573 a_9945_5582# a_8265_13640# 0.02915f
C574 a_11625_5582# a_8265_13640# 0.03124f
C575 a_13187_5969# a_9945_13640# 0.04359f
C576 a_3107_14509# a_1545_9782# 0.03587f
C577 VDD a_6585_9782# 1.78382f
C578 a_13187_5969# a_8265_13640# 0.04322f
C579 a_1427_14509# a_3225_9782# 1.56221f
C580 a_3225_1180# a_4760_1180# 0.39182f
C581 a_14867_1769# a_6440_1180# 0.07444f
C582 a_19764_13580# a_20174_13580# 0.0129f
C583 VDD a_8414_1120# 0.34888f
C584 a_1427_1769# a_33614_5180# 0.01993f
C585 a_1427_14509# a_1545_9782# 0.38771f
C586 VDD a_4905_9782# 1.30592f
C587 a_9945_5582# a_4787_14509# 0.02929f
C588 a_8265_5582# a_9945_13640# 0.05038f
C589 a_1545_9782# a_26484_5180# 0.01005f
C590 a_19764_13580# a_18345_13640# 0.04961f
C591 a_11625_5582# a_4787_14509# 0.03124f
C592 a_6734_9722# a_6585_9782# 0.01226f
C593 a_16665_13640# a_4760_1180# 0.02739f
C594 a_8004_1120# VDD 0.3627f
C595 a_18345_13640# a_18494_13580# 0.04654f
C596 VDD a_21560_13640# 0.24988f
C597 a_1545_1180# a_6440_1180# 0.15742f
C598 a_8265_5582# a_8265_13640# 0.13247f
C599 a_4760_1180# a_14867_1769# 0.07444f
C600 a_18494_13580# a_18084_13580# 0.0129f
C601 a_13187_5969# a_4787_14509# 0.04359f
C602 a_18345_13640# a_3225_1180# 0.05529f
C603 a_4760_1180# a_1380_18164# 0.08916f
C604 a_14867_1769# a_14840_1180# 0.05272f
C605 VDD a_8120_13640# 0.19534f
C606 a_5054_9722# a_4905_9782# 0.01226f
C607 a_20174_13580# a_14867_1769# 0.04071f
C608 a_1427_1769# SIGN 0.11964f
C609 a_18345_13640# a_16665_13640# 0.0491f
C610 a_1545_1180# a_4760_1180# 0.12605f
C611 a_19764_13580# a_14867_1769# 0.0153f
C612 a_6585_9782# a_3225_9782# 0.4348f
C613 a_3107_14509# a_9945_5582# 0.1091f
C614 a_18345_13640# a_14867_1769# 0.35418f
C615 a_16665_13640# a_3225_1180# 2.11751f
C616 a_4787_14509# a_8265_5582# 0.03362f
C617 VDD a_5054_5522# 0.21693f
C618 a_3107_1769# SIGN 0.01332f
C619 a_9945_5582# a_13454_1120# 0.02481f
C620 a_1545_9782# a_6585_9782# 0.26287f
C621 a_3225_1180# a_14867_1769# 0.24462f
C622 a_16404_13580# a_16814_13580# 0.0129f
C623 a_3225_9782# a_4905_9782# 0.29111f
C624 a_16665_13640# a_16814_13580# 0.05076f
C625 VDD a_21854_5180# 0.34888f
C626 a_16814_13580# a_14867_1769# 0.01327f
C627 a_1427_14509# a_9945_5582# 0.0361f
C628 a_1545_5582# VSS 0.02532f
C629 a_3225_1180# a_1380_18164# 0.50761f
C630 a_1427_14509# a_11625_5582# 0.03849f
C631 a_1545_9782# a_4905_9782# 0.13038f
C632 a_18345_13640# a_1545_1180# 0.15772f
C633 a_16404_13580# a_14867_1769# 0.01109f
C634 MAG a_19764_1120# 0.01113f
C635 a_16665_13640# a_14867_1769# 0.77445f
C636 a_16404_13580# a_14985_13640# 0.05265f
C637 a_16665_13640# a_14985_13640# 0.20327f
C638 a_1545_1180# a_3225_1180# 1.10662f
C639 VDD a_13187_14509# 1.16591f
C640 a_14985_13640# a_14867_1769# 0.11708f
C641 a_1427_14509# a_13187_5969# 0.04359f
C642 a_15134_13580# a_14985_13640# 0.04654f
C643 a_16665_13640# a_1380_18164# 1.90373f
C644 a_9945_13640# a_6440_1180# 0.03701f
C645 VDD a_12580_18164# 0.51466f
C646 a_3107_14509# a_8265_5582# 0.03838f
C647 a_14867_1769# a_1380_18164# 0.01043f
C648 a_1694_1120# VDD 0.34678f
C649 a_15134_13580# a_14724_13580# 0.0129f
C650 a_16665_13640# a_1545_1180# 0.25068f
C651 a_8265_13640# a_6440_1180# 0.04359f
C652 a_1545_1180# a_14867_1769# 0.45652f
C653 a_1427_1769# a_29844_5180# 0.01143f
C654 a_15134_13580# a_1545_1180# 0.01118f
C655 a_1545_1180# a_14985_13640# 0.21228f
C656 VDD a_33614_5180# 0.35048f
C657 a_1427_14509# a_8265_5582# 0.07733f
C658 a_4760_1180# a_9945_13640# 0.03701f
C659 VDD a_18084_1120# 0.36279f
C660 a_13454_9722# SIGN 0.0145f
C661 a_1545_1180# a_14724_13580# 0.01505f
C662 a_1545_1180# a_1380_18164# 0.29823f
C663 a_3225_9782# a_21854_5180# 0.01133f
C664 a_9945_5582# a_6585_9782# 0.06936f
C665 a_4760_1180# a_8265_13640# 0.03124f
C666 a_11625_5582# a_6585_9782# 0.06304f
C667 INN a_6585_9782# 0.21633f
C668 a_11774_9722# SIGN 0.01579f
C669 a_1545_9782# a_21854_5180# 0.02254f
C670 MAG VSS 13.1279f
C671 SIGN VSS 12.958f
C672 INN VSS 10.2238f
C673 INP VSS 8.5743f
C674 CLK VSS 17.7195f
C675 VDD VSS 0.28504p
C676 a_20174_1120# VSS 0.04368f
C677 a_19764_1120# VSS 0.04368f
C678 a_18494_1120# VSS 0.04368f
C679 a_18084_1120# VSS 0.04368f
C680 a_16814_1120# VSS 0.39439f
C681 a_16404_1120# VSS 0.40799f ; **FLOATING
C682 a_15134_1120# VSS 0.38371f
C683 a_14840_1180# VSS 0.95652f ; **FLOATING
C684 a_14724_1120# VSS 0.38721f
C685 a_13454_1120# VSS 0.04368f
C686 a_13044_1120# VSS 0.04368f
C687 a_11774_1120# VSS 0.04368f
C688 a_11364_1120# VSS 0.04368f
C689 a_10094_1120# VSS 0.04368f
C690 a_9684_1120# VSS 0.04368f
C691 a_8414_1120# VSS 0.04368f
C692 a_8004_1120# VSS 0.04368f
C693 a_6734_1120# VSS 0.387f
C694 a_6324_1120# VSS 0.38539f
C695 a_5054_1120# VSS 0.38545f
C696 a_4644_1120# VSS 0.38456f
C697 a_3374_1120# VSS 0.04368f
C698 a_2964_1120# VSS 0.04368f
C699 a_1694_1120# VSS 0.04368f
C700 a_1284_1120# VSS 0.04368f
C701 a_33614_5180# VSS 0.04368f
C702 a_33204_5180# VSS 0.04368f
C703 a_31934_5180# VSS 0.04368f
C704 a_31524_5180# VSS 0.04368f
C705 a_30254_5180# VSS 0.38721f
C706 a_29844_5180# VSS 0.38367f
C707 a_28574_5180# VSS 0.38721f
C708 a_28164_5180# VSS 0.38371f
C709 a_26894_5180# VSS 0.04368f
C710 a_26484_5180# VSS 0.04368f
C711 a_25214_5180# VSS 0.04368f
C712 a_24804_5180# VSS 0.04368f
C713 a_23534_5180# VSS 0.04368f
C714 a_23124_5180# VSS 0.04368f
C715 a_21854_5180# VSS 0.04368f
C716 a_21444_5180# VSS 0.04368f
C717 a_20174_5180# VSS 0.387f
C718 a_19764_5180# VSS 0.38367f
C719 a_18494_5180# VSS 0.38348f
C720 a_18084_5180# VSS 0.38462f
C721 a_16814_5522# VSS 0.24097f
C722 a_16404_5522# VSS 0.2518f ; **FLOATING
C723 a_15134_5522# VSS 0.24181f
C724 a_14724_5522# VSS 0.25096f ; **FLOATING
C725 a_13454_5522# VSS 0.24044f
C726 a_13044_5522# VSS 0.25233f ; **FLOATING
C727 a_11774_5522# VSS 0.24128f
C728 a_11364_5522# VSS 0.25233f ; **FLOATING
C729 a_10094_5522# VSS 0.24128f
C730 a_9684_5522# VSS 0.25233f ; **FLOATING
C731 a_8414_5522# VSS 0.24128f
C732 a_8004_5522# VSS 0.2541f ; **FLOATING
C733 a_6734_5522# VSS 0.02717f
C734 a_6324_5522# VSS 0.02717f
C735 a_5054_5522# VSS 0.02717f
C736 a_4644_5522# VSS 0.02717f
C737 a_3374_5522# VSS 0.02717f
C738 a_3225_5582# VSS 5.74548f ; **FLOATING
C739 a_2964_5522# VSS 0.02717f
C740 a_1694_5522# VSS 0.02717f
C741 a_1545_5582# VSS 7.57225f ; **FLOATING
C742 a_1284_5522# VSS 0.02717f
C743 a_33614_9722# VSS 0.24358f
C744 a_33204_9722# VSS 0.25096f ; **FLOATING
C745 a_31934_9722# VSS 0.24358f
C746 a_31524_9722# VSS 0.25096f
C747 a_30254_9722# VSS 0.24275f
C748 a_29844_9722# VSS 0.25096f ; **FLOATING
C749 a_28574_9722# VSS 0.24044f
C750 a_28164_9722# VSS 0.25327f ; **FLOATING
C751 a_26894_9722# VSS 0.24275f
C752 a_26484_9722# VSS 0.25096f ; **FLOATING
C753 a_25214_9722# VSS 0.24275f
C754 a_24804_9722# VSS 0.25096f ; **FLOATING
C755 a_23534_9722# VSS 0.02717f
C756 a_23124_9722# VSS 0.02717f
C757 a_21854_9722# VSS 0.02717f
C758 a_21444_9722# VSS 0.02717f
C759 a_20174_9722# VSS 0.02717f
C760 a_1427_1769# VSS 6.28091f ; **FLOATING
C761 a_19764_9722# VSS 0.02717f
C762 a_18494_9722# VSS 0.02717f
C763 a_3107_1769# VSS 5.51121f ; **FLOATING
C764 a_18084_9722# VSS 0.02717f
C765 a_16814_9722# VSS 0.24232f
C766 a_16404_9722# VSS 0.25096f ; **FLOATING
C767 a_15134_9722# VSS 0.24097f
C768 a_14724_9722# VSS 0.25096f ; **FLOATING
C769 a_13454_9722# VSS 0.24232f
C770 a_13044_9722# VSS 0.25159f ; **FLOATING
C771 a_11774_9722# VSS 0.24044f
C772 a_11364_9722# VSS 0.25347f
C773 a_10094_9722# VSS 0.24044f
C774 a_9684_9722# VSS 0.25347f ; **FLOATING
C775 a_8414_9722# VSS 0.24044f
C776 a_8004_9722# VSS 0.25212f ; **FLOATING
C777 a_6734_9722# VSS 0.02717f
C778 a_6324_9722# VSS 0.02717f
C779 a_5054_9722# VSS 0.02717f
C780 a_4644_9722# VSS 0.02717f
C781 a_3374_9722# VSS 0.02717f
C782 a_3225_9782# VSS 8.64431f ; **FLOATING
C783 a_2964_9722# VSS 0.02717f
C784 a_1694_9722# VSS 0.02717f
C785 a_1545_9782# VSS 6.01505f ; **FLOATING
C786 a_1284_9722# VSS 0.02717f
C787 a_33614_13580# VSS 0.07326f
C788 a_33204_13580# VSS 0.07326f
C789 a_31934_13580# VSS 0.07326f
C790 a_31785_13640# VSS 0.55101f ; **FLOATING
C791 a_31524_13580# VSS 0.07326f
C792 a_9945_5582# VSS 9.29897f ; **FLOATING
C793 a_30254_13580# VSS 0.07326f
C794 a_11625_5582# VSS 9.46121f ; **FLOATING
C795 a_29844_13580# VSS 0.07326f
C796 a_13187_5969# VSS 10.9246f ; **FLOATING
C797 a_28574_13580# VSS 0.07326f
C798 a_28425_13640# VSS 0.47453f ; **FLOATING
C799 a_28164_13580# VSS 0.07326f
C800 a_8265_5582# VSS 6.9892f ; **FLOATING
C801 a_26894_13580# VSS 0.65977f
C802 a_26484_13580# VSS 0.65679f
C803 a_25214_13580# VSS 0.65977f
C804 a_24804_13580# VSS 0.65679f
C805 a_23534_13580# VSS 0.65827f
C806 a_6440_1180# VSS 8.22007f ; **FLOATING
C807 a_23124_13580# VSS 0.65679f
C808 a_21854_13580# VSS 0.65732f
C809 a_4760_1180# VSS 6.21742f ; **FLOATING
C810 a_21444_13580# VSS 0.65774f
C811 a_20174_13580# VSS 0.07326f
C812 a_19764_13580# VSS 0.07326f
C813 a_18494_13580# VSS 0.07326f
C814 a_18345_13640# VSS 0.40798f ; **FLOATING
C815 a_18084_13580# VSS 0.07326f
C816 a_3225_1180# VSS 7.91308f ; **FLOATING
C817 a_16814_13580# VSS 0.07326f
C818 a_16665_13640# VSS 4.58672f ; **FLOATING
C819 a_16404_13580# VSS 0.07326f
C820 a_14867_1769# VSS 10.8984f ; **FLOATING
C821 a_15134_13580# VSS 0.07326f
C822 a_14985_13640# VSS 0.40305f ; **FLOATING
C823 a_14724_13580# VSS 0.07326f
C824 a_1545_1180# VSS 11f ; **FLOATING
C825 a_13454_13580# VSS 0.65774f
C826 a_13044_13580# VSS 0.65732f
C827 a_11774_13580# VSS 0.65774f
C828 a_11364_13580# VSS 0.65732f
C829 a_10094_13580# VSS 0.65827f
C830 a_9945_13640# VSS 7.51482f ; **FLOATING
C831 a_9684_13580# VSS 0.65679f
C832 a_8414_13580# VSS 0.65679f
C833 a_8265_13640# VSS 6.18007f ; **FLOATING
C834 a_8004_13580# VSS 0.65827f
C835 a_6734_13580# VSS 0.07326f
C836 a_6324_13580# VSS 0.07326f
C837 a_5054_13580# VSS 0.07326f
C838 a_4905_13640# VSS 0.44343f ; **FLOATING
C839 a_4644_13580# VSS 0.07326f
C840 a_4787_14509# VSS 4.95935f ; **FLOATING
C841 a_3374_13580# VSS 0.07326f
C842 a_2964_13580# VSS 0.07326f
C843 a_3107_14509# VSS 5.87892f ; **FLOATING
C844 a_1694_13580# VSS 0.07326f
C845 a_1545_13640# VSS 0.4472f ; **FLOATING
C846 a_1284_13580# VSS 0.07326f
C847 a_1427_14509# VSS 7.35902f ; **FLOATING
C848 a_32774_17920# VSS 0.65977f
C849 a_32364_17920# VSS 0.65679f
C850 a_31094_17920# VSS 0.65977f
C851 a_30684_17920# VSS 0.65679f
C852 a_29414_17920# VSS 0.65977f
C853 a_6585_9782# VSS 7.80706f ; **FLOATING
C854 a_29004_17920# VSS 0.65654f
C855 a_27734_17920# VSS 0.65977f
C856 a_4905_9782# VSS 6.66993f ; **FLOATING
C857 a_27324_17920# VSS 0.65679f
C858 a_26024_17920# VSS 0.73115f ; **FLOATING
C859 a_21560_13640# VSS 3.49902f ; **FLOATING
C860 a_8120_13640# VSS 6.9196f ; **FLOATING
C861 a_25065_17980# VSS 3.11191f ; **FLOATING
C862 a_24804_17920# VSS 0.73307f
C863 a_19300_18164# VSS 4.48115f ; **FLOATING
C864 a_13187_14509# VSS 73.52551f ; **FLOATING
C865 a_12580_18164# VSS 70.79601f ; **FLOATING
C866 a_17060_19773# VSS 4.72932f ; **FLOATING
C867 a_8100_18164# VSS 4.39198f ; **FLOATING
C868 a_5860_19890# VSS 4.38724f ; **FLOATING
C869 a_3620_18164# VSS 4.3966f ; **FLOATING
C870 a_1380_18164# VSS 72.11411f ; **FLOATING
C871 a_1380_19890# VSS 4.40625f ; **FLOATING
.ends

.subckt adc2b INP INN CLK SIGN MAG VDD VSS
XPEX VSS VDD INP INN CLK SIGN MAG adc2b_flat
.ends
.end
