** sch_path: /home/noritsuna/GPS/xschem/tb_adc.sch
**.subckt tb_adc
VDD vdd 0 3.3
VCK clk 0 pulse(0 3.3 0 0.2n 0.2n 30.3474n 61.0948n)
VIP inp 0 pwl(0 1.0 10u 1.4)
VIN inn 0 pwl(0 1.4 10u 1.0)
XA inp inn clk sign mag vdd 0 adc2b
C1 sign 0 50f
C2 mag 0 50f
**** begin user architecture code
 .include /home/noritsuna/pdk/gf180mcuD/libs.tech/ngspice/design.ngspice
.lib /home/noritsuna/pdk/gf180mcuD/libs.tech/ngspice/sm141064.ngspice typical
.lib /home/noritsuna/pdk/gf180mcuD/libs.tech/ngspice/sm141064.ngspice res_typical
.lib /home/noritsuna/pdk/gf180mcuD/libs.tech/ngspice/sm141064.ngspice mimcap_typical

.control
set num_threads=1
tran 0.1n 10u
let vd = v(inp)-v(inn)
wrdata /tmp/claude-1000/-home-noritsuna-GPS/c833b4ff-95cf-42fc-a46c-00da2a6a5752/scratchpad/adcpex2 vd v(sign) v(mag)
meas tran ts when v(sign)=1.65 rise=1
meas tran tm1 when v(mag)=1.65 fall=1
meas tran tm2 when v(mag)=1.65 rise=1
meas tran vs find vd at=ts
meas tran vm1 find vd at=tm1
meas tran vm2 find vd at=tm2
echo RES vth_sign=$&vs vth_mag_lo=$&vm1 vth_mag_hi=$&vm2
meas tran thp avg v(xa.xpex.thp) from=2u to=8u
meas tran thm avg v(xa.xpex.thm) from=2u to=8u
meas tran thn avg v(xa.xpex.thn) from=2u to=8u
echo RES ladder thp=$&thp thm=$&thm thn=$&thn
meas tran iavg avg i(VDD) from=2u to=8u
echo RES iavg=$&iavg
.endc

**** end user architecture code
**.ends

* expanding   symbol:  adc2b.sym # of pins=7
** sym_path: /home/noritsuna/GPS/xschem/adc2b.sym
** sch_path: /home/noritsuna/GPS/xschem/adc2b.sch

* expanding   symbol:  sa_comp.sym # of pins=9
** sym_path: /home/noritsuna/GPS/xschem/sa_comp.sym
** sch_path: /home/noritsuna/GPS/xschem/sa_comp.sch
.subckt sa_comp INP INN REFP REFN CLK Q QB VDD VSS
*.ipin INP
*.ipin INN
*.ipin REFP
*.ipin REFN
*.ipin CLK
*.opin Q
*.opin QB
*.iopin VDD
*.iopin VSS
XMT t CLK VSS VSS nfet_03v3 L=0.28u W=8u nf=2 ad='int((nf+1)/2) * W/nf * 0.18u' as='int((nf+2)/2) * W/nf * 0.18u' pd='2*int((nf+1)/2) * (W/nf + 0.18u)'
+ ps='2*int((nf+2)/2) * (W/nf + 0.18u)' nrd='0.18u / W' nrs='0.18u / W' sa=0 sb=0 sd=0 m=1 par=1
XM1 x1 INP t VSS nfet_03v3 L=0.28u W=4u nf=1 ad='int((nf+1)/2) * W/nf * 0.18u' as='int((nf+2)/2) * W/nf * 0.18u' pd='2*int((nf+1)/2) * (W/nf + 0.18u)'
+ ps='2*int((nf+2)/2) * (W/nf + 0.18u)' nrd='0.18u / W' nrs='0.18u / W' sa=0 sb=0 sd=0 m=1 par=1
XM2 x2 INN t VSS nfet_03v3 L=0.28u W=4u nf=1 ad='int((nf+1)/2) * W/nf * 0.18u' as='int((nf+2)/2) * W/nf * 0.18u' pd='2*int((nf+1)/2) * (W/nf + 0.18u)'
+ ps='2*int((nf+2)/2) * (W/nf + 0.18u)' nrd='0.18u / W' nrs='0.18u / W' sa=0 sb=0 sd=0 m=1 par=1
XM3 x2 REFP t VSS nfet_03v3 L=0.28u W=4u nf=1 ad='int((nf+1)/2) * W/nf * 0.18u' as='int((nf+2)/2) * W/nf * 0.18u' pd='2*int((nf+1)/2) * (W/nf + 0.18u)'
+ ps='2*int((nf+2)/2) * (W/nf + 0.18u)' nrd='0.18u / W' nrs='0.18u / W' sa=0 sb=0 sd=0 m=1 par=1
XM4 x1 REFN t VSS nfet_03v3 L=0.28u W=4u nf=1 ad='int((nf+1)/2) * W/nf * 0.18u' as='int((nf+2)/2) * W/nf * 0.18u' pd='2*int((nf+1)/2) * (W/nf + 0.18u)'
+ ps='2*int((nf+2)/2) * (W/nf + 0.18u)' nrd='0.18u / W' nrs='0.18u / W' sa=0 sb=0 sd=0 m=1 par=1
XM5 on op x1 VSS nfet_03v3 L=0.28u W=2u nf=1 ad='int((nf+1)/2) * W/nf * 0.18u' as='int((nf+2)/2) * W/nf * 0.18u' pd='2*int((nf+1)/2) * (W/nf + 0.18u)'
+ ps='2*int((nf+2)/2) * (W/nf + 0.18u)' nrd='0.18u / W' nrs='0.18u / W' sa=0 sb=0 sd=0 m=1 par=1
XM6 op on x2 VSS nfet_03v3 L=0.28u W=2u nf=1 ad='int((nf+1)/2) * W/nf * 0.18u' as='int((nf+2)/2) * W/nf * 0.18u' pd='2*int((nf+1)/2) * (W/nf + 0.18u)'
+ ps='2*int((nf+2)/2) * (W/nf + 0.18u)' nrd='0.18u / W' nrs='0.18u / W' sa=0 sb=0 sd=0 m=1 par=1
XM7 on op VDD VDD pfet_03v3 L=0.28u W=2u nf=1 ad='int((nf+1)/2) * W/nf * 0.18u' as='int((nf+2)/2) * W/nf * 0.18u' pd='2*int((nf+1)/2) * (W/nf + 0.18u)'
+ ps='2*int((nf+2)/2) * (W/nf + 0.18u)' nrd='0.18u / W' nrs='0.18u / W' sa=0 sb=0 sd=0 m=1 par=1
XM8 op on VDD VDD pfet_03v3 L=0.28u W=2u nf=1 ad='int((nf+1)/2) * W/nf * 0.18u' as='int((nf+2)/2) * W/nf * 0.18u' pd='2*int((nf+1)/2) * (W/nf + 0.18u)'
+ ps='2*int((nf+2)/2) * (W/nf + 0.18u)' nrd='0.18u / W' nrs='0.18u / W' sa=0 sb=0 sd=0 m=1 par=1
XM9 on CLK VDD VDD pfet_03v3 L=0.28u W=1u nf=1 ad='int((nf+1)/2) * W/nf * 0.18u' as='int((nf+2)/2) * W/nf * 0.18u' pd='2*int((nf+1)/2) * (W/nf + 0.18u)'
+ ps='2*int((nf+2)/2) * (W/nf + 0.18u)' nrd='0.18u / W' nrs='0.18u / W' sa=0 sb=0 sd=0 m=1 par=1
XM10 op CLK VDD VDD pfet_03v3 L=0.28u W=1u nf=1 ad='int((nf+1)/2) * W/nf * 0.18u' as='int((nf+2)/2) * W/nf * 0.18u' pd='2*int((nf+1)/2) * (W/nf + 0.18u)'
+ ps='2*int((nf+2)/2) * (W/nf + 0.18u)' nrd='0.18u / W' nrs='0.18u / W' sa=0 sb=0 sd=0 m=1 par=1
XM11 x1 CLK VDD VDD pfet_03v3 L=0.28u W=1u nf=1 ad='int((nf+1)/2) * W/nf * 0.18u' as='int((nf+2)/2) * W/nf * 0.18u' pd='2*int((nf+1)/2) * (W/nf + 0.18u)'
+ ps='2*int((nf+2)/2) * (W/nf + 0.18u)' nrd='0.18u / W' nrs='0.18u / W' sa=0 sb=0 sd=0 m=1 par=1
XM12 x2 CLK VDD VDD pfet_03v3 L=0.28u W=1u nf=1 ad='int((nf+1)/2) * W/nf * 0.18u' as='int((nf+2)/2) * W/nf * 0.18u' pd='2*int((nf+1)/2) * (W/nf + 0.18u)'
+ ps='2*int((nf+2)/2) * (W/nf + 0.18u)' nrd='0.18u / W' nrs='0.18u / W' sa=0 sb=0 sd=0 m=1 par=1
XI1 op opb VDD VSS inv_dig
XI2 on onb VDD VSS inv_dig
XS1 opb QB Q VDD VSS nor2
XS2 onb Q QB VDD VSS nor2
.ends

* expanding   symbol:  nand2.sym # of pins=5
** sym_path: /home/noritsuna/GPS/xschem/nand2.sym
** sch_path: /home/noritsuna/GPS/xschem/nand2.sch
.subckt nand2 A B Y VDD VSS
*.ipin A
*.ipin B
*.opin Y
*.iopin VDD
*.iopin VSS
XMN1 Y A n1 VSS nfet_03v3 L=0.28u W=2u nf=1 ad='int((nf+1)/2) * W/nf * 0.18u' as='int((nf+2)/2) * W/nf * 0.18u' pd='2*int((nf+1)/2) * (W/nf + 0.18u)'
+ ps='2*int((nf+2)/2) * (W/nf + 0.18u)' nrd='0.18u / W' nrs='0.18u / W' sa=0 sb=0 sd=0 m=1 par=1
XMN2 n1 B VSS VSS nfet_03v3 L=0.28u W=2u nf=1 ad='int((nf+1)/2) * W/nf * 0.18u' as='int((nf+2)/2) * W/nf * 0.18u' pd='2*int((nf+1)/2) * (W/nf + 0.18u)'
+ ps='2*int((nf+2)/2) * (W/nf + 0.18u)' nrd='0.18u / W' nrs='0.18u / W' sa=0 sb=0 sd=0 m=1 par=1
XMP1 Y A VDD VDD pfet_03v3 L=0.28u W=2u nf=1 ad='int((nf+1)/2) * W/nf * 0.18u' as='int((nf+2)/2) * W/nf * 0.18u' pd='2*int((nf+1)/2) * (W/nf + 0.18u)'
+ ps='2*int((nf+2)/2) * (W/nf + 0.18u)' nrd='0.18u / W' nrs='0.18u / W' sa=0 sb=0 sd=0 m=1 par=1
XMP2 Y B VDD VDD pfet_03v3 L=0.28u W=2u nf=1 ad='int((nf+1)/2) * W/nf * 0.18u' as='int((nf+2)/2) * W/nf * 0.18u' pd='2*int((nf+1)/2) * (W/nf + 0.18u)'
+ ps='2*int((nf+2)/2) * (W/nf + 0.18u)' nrd='0.18u / W' nrs='0.18u / W' sa=0 sb=0 sd=0 m=1 par=1
.ends

* expanding   symbol:  inv_dig.sym # of pins=4
** sym_path: /home/noritsuna/GPS/xschem/inv_dig.sym
** sch_path: /home/noritsuna/GPS/xschem/inv_dig.sch
.subckt inv_dig A Y VDD VSS
*.ipin A
*.opin Y
*.iopin VDD
*.iopin VSS
XMN Y A VSS VSS nfet_03v3 L=0.28u W=1u nf=1 ad='int((nf+1)/2) * W/nf * 0.18u' as='int((nf+2)/2) * W/nf * 0.18u' pd='2*int((nf+1)/2) * (W/nf + 0.18u)'
+ ps='2*int((nf+2)/2) * (W/nf + 0.18u)' nrd='0.18u / W' nrs='0.18u / W' sa=0 sb=0 sd=0 m=1 par=1
XMP Y A VDD VDD pfet_03v3 L=0.28u W=2u nf=1 ad='int((nf+1)/2) * W/nf * 0.18u' as='int((nf+2)/2) * W/nf * 0.18u' pd='2*int((nf+1)/2) * (W/nf + 0.18u)'
+ ps='2*int((nf+2)/2) * (W/nf + 0.18u)' nrd='0.18u / W' nrs='0.18u / W' sa=0 sb=0 sd=0 m=1 par=1
.ends

* expanding   symbol:  nor2.sym # of pins=5
** sym_path: /home/noritsuna/GPS/xschem/nor2.sym
** sch_path: /home/noritsuna/GPS/xschem/nor2.sch
.subckt nor2 A B Y VDD VSS
*.ipin A
*.ipin B
*.opin Y
*.iopin VDD
*.iopin VSS
XMN1 Y A VSS VSS nfet_03v3 L=0.28u W=1u nf=1 ad='int((nf+1)/2) * W/nf * 0.18u' as='int((nf+2)/2) * W/nf * 0.18u' pd='2*int((nf+1)/2) * (W/nf + 0.18u)'
+ ps='2*int((nf+2)/2) * (W/nf + 0.18u)' nrd='0.18u / W' nrs='0.18u / W' sa=0 sb=0 sd=0 m=1 par=1
XMN2 Y B VSS VSS nfet_03v3 L=0.28u W=1u nf=1 ad='int((nf+1)/2) * W/nf * 0.18u' as='int((nf+2)/2) * W/nf * 0.18u' pd='2*int((nf+1)/2) * (W/nf + 0.18u)'
+ ps='2*int((nf+2)/2) * (W/nf + 0.18u)' nrd='0.18u / W' nrs='0.18u / W' sa=0 sb=0 sd=0 m=1 par=1
XMP1 n1 A VDD VDD pfet_03v3 L=0.28u W=4u nf=1 ad='int((nf+1)/2) * W/nf * 0.18u' as='int((nf+2)/2) * W/nf * 0.18u' pd='2*int((nf+1)/2) * (W/nf + 0.18u)'
+ ps='2*int((nf+2)/2) * (W/nf + 0.18u)' nrd='0.18u / W' nrs='0.18u / W' sa=0 sb=0 sd=0 m=1 par=1
XMP2 Y B n1 VDD pfet_03v3 L=0.28u W=4u nf=1 ad='int((nf+1)/2) * W/nf * 0.18u' as='int((nf+2)/2) * W/nf * 0.18u' pd='2*int((nf+1)/2) * (W/nf + 0.18u)'
+ ps='2*int((nf+2)/2) * (W/nf + 0.18u)' nrd='0.18u / W' nrs='0.18u / W' sa=0 sb=0 sd=0 m=1 par=1
.ends
* NGSPICE file created from adc2b_flat.ext - technology: gf180mcuD

.subckt adc2b_flat VSS VDD INP INN CLK SIGN MAG
X0 a_5487_59449# a_3807_67989# VDD VDD pfet_03v3 ad=0.89p pd=4.89u as=0.89p ps=4.89u w=2u l=0.28u
X1 a_8120_58860# CLK.t7 VDD VDD pfet_03v3 ad=0.445p pd=2.89u as=0.445p ps=2.89u w=1u l=0.28u
X2 a_8120_35480# INN a_3780_31140# VSS nfet_03v3 ad=1.78p pd=8.89u as=1.78p ps=8.89u w=4u l=0.28u
X3 a_3807_32009# VSS cap_mim_2f0_m4m5_noshield c_width=50u c_length=50u
X4 a_5487_48809# a_3925_48422# VSS VSS nfet_03v3 ad=0.445p pd=2.89u as=0.445p ps=2.89u w=1u l=0.28u
X5 a_8120_35480# a_1380_1364# a_3780_31140# VSS nfet_03v3 ad=1.78p pd=8.89u as=1.78p ps=8.89u w=4u l=0.28u
X6 a_11480_24700# a_8265_20500# VDD VDD pfet_03v3 ad=1.78p pd=8.89u as=1.78p ps=8.89u w=4u l=0.28u
X7 a_3807_72189# a_3807_67989# VDD VDD pfet_03v3 ad=0.89p pd=4.89u as=0.89p ps=4.89u w=2u l=0.28u
X8 a_3925_71802# SIGN VSS VSS nfet_03v3 ad=0.445p pd=2.89u as=0.445p ps=2.89u w=1u l=0.28u
X9 a_1380_3090# a_1380_1364# VSS ppolyf_u_1k r_width=10u r_length=8.02u
X10 a_11480_71460# a_8265_67260# VDD VDD pfet_03v3 ad=1.78p pd=8.89u as=1.78p ps=8.89u w=4u l=0.28u
X11 a_5487_36069# CLK.t6 VDD VDD pfet_03v3 ad=0.445p pd=2.89u as=0.445p ps=2.89u w=1u l=0.28u
X12 a_5487_25429# a_8265_20500# VSS VSS nfet_03v3 ad=0.445p pd=2.89u as=0.445p ps=2.89u w=1u l=0.28u
X13 a_5860_3090# a_3620_1364# VSS ppolyf_u_1k r_width=10u r_length=8.02u
X14 a_5487_59449# a_3807_67989# a_8120_58860# VSS nfet_03v3 ad=0.89p pd=4.89u as=0.89p ps=4.89u w=2u l=0.28u
X15 SIGN a_3925_71802# VSS VSS nfet_03v3 ad=0.445p pd=2.89u as=0.445p ps=2.89u w=1u l=0.28u
X16 a_3925_48422# a_3807_48809# VSS VSS nfet_03v3 ad=0.445p pd=2.89u as=0.445p ps=2.89u w=1u l=0.28u
X17 a_3925_48422# a_5487_48809# a_7285_48080# VDD pfet_03v3 ad=1.78p pd=8.89u as=1.78p ps=8.89u w=4u l=0.28u
X18 a_8265_67260# a_5487_59449# VDD VDD pfet_03v3 ad=0.89p pd=4.89u as=0.89p ps=4.89u w=2u l=0.28u
X19 a_3925_54520# INP a_3780_54520# VSS nfet_03v3 ad=1.78p pd=8.89u as=1.78p ps=8.89u w=4u l=0.28u
X20 a_5487_48809# a_3925_48422# a_11480_48080# VDD pfet_03v3 ad=1.78p pd=8.89u as=1.78p ps=8.89u w=4u l=0.28u
X21 a_3925_25042# a_5487_25429# a_7285_24700# VDD pfet_03v3 ad=1.78p pd=8.89u as=1.78p ps=8.89u w=4u l=0.28u
X22 a_3807_25429# a_3807_21229# VSS VSS nfet_03v3 ad=0.445p pd=2.89u as=0.445p ps=2.89u w=1u l=0.28u
X23 a_8120_12100# a_3807_32009# a_3780_7760# VSS nfet_03v3 ad=1.78p pd=8.89u as=1.78p ps=8.89u w=4u l=0.28u
X24 VDD a_8100_1364# VSS ppolyf_u_1k r_width=10u r_length=8.02u
X25 a_8120_35480# CLK.t6 VDD VDD pfet_03v3 ad=0.445p pd=2.89u as=0.445p ps=2.89u w=1u l=0.28u
X26 a_3925_25042# a_5487_25429# VSS VSS nfet_03v3 ad=0.445p pd=2.89u as=0.445p ps=2.89u w=1u l=0.28u
X27 a_5487_25429# a_3925_25042# a_11480_24700# VDD pfet_03v3 ad=1.78p pd=8.89u as=1.78p ps=8.89u w=4u l=0.28u
X28 a_3925_7760# CLK.t3 VDD VDD pfet_03v3 ad=0.445p pd=2.89u as=0.445p ps=2.89u w=1u l=0.28u
X29 a_3807_55389# a_3807_32009# VSS ppolyf_u_1k r_width=10u r_length=1.4u
X30 a_8265_43880# a_5487_36069# VSS VSS nfet_03v3 ad=0.445p pd=2.89u as=0.445p ps=2.89u w=1u l=0.28u
X31 a_3807_44609# a_5487_36069# a_3925_31140# VSS nfet_03v3 ad=0.89p pd=4.89u as=0.89p ps=4.89u w=2u l=0.28u
X32 a_3780_31140# CLK.t6 VSS VSS nfet_03v3 ad=1.06p pd=4.53u as=1.78p ps=8.89u w=4u l=0.28u
X33 a_5860_3090# a_8100_1364# VSS ppolyf_u_1k r_width=10u r_length=8.02u
X34 a_3925_71802# a_3807_72189# VSS VSS nfet_03v3 ad=0.445p pd=2.89u as=0.445p ps=2.89u w=1u l=0.28u
X35 a_3925_71802# SIGN a_7285_71460# VDD pfet_03v3 ad=1.78p pd=8.89u as=1.78p ps=8.89u w=4u l=0.28u
X36 a_3807_67989# CLK.t7 VDD VDD pfet_03v3 ad=0.445p pd=2.89u as=0.445p ps=2.89u w=1u l=0.28u
X37 a_7285_48080# a_3807_48809# VDD VDD pfet_03v3 ad=1.78p pd=8.89u as=1.78p ps=8.89u w=4u l=0.28u
X38 a_3807_48809# a_3807_44609# VDD VDD pfet_03v3 ad=0.89p pd=4.89u as=0.89p ps=4.89u w=2u l=0.28u
X39 a_1380_1364# VSS cap_mim_2f0_m4m5_noshield c_width=50u c_length=50u
X40 SIGN a_3925_71802# a_11480_71460# VDD pfet_03v3 ad=1.78p pd=8.89u as=1.78p ps=8.89u w=4u l=0.28u
X41 a_5487_25429# a_3925_25042# VSS VSS nfet_03v3 ad=0.445p pd=2.89u as=0.445p ps=2.89u w=1u l=0.28u
X42 a_1380_1364# a_3807_55389# VSS ppolyf_u_1k r_width=10u r_length=1.4u
X43 a_7285_24700# a_3807_25429# VDD VDD pfet_03v3 ad=1.78p pd=8.89u as=1.78p ps=8.89u w=4u l=0.28u
X44 a_3807_21229# a_5487_12689# a_3925_7760# VSS nfet_03v3 ad=0.89p pd=4.89u as=0.89p ps=4.89u w=2u l=0.28u
X45 a_5487_36069# a_3807_44609# a_8120_35480# VSS nfet_03v3 ad=0.89p pd=4.89u as=0.89p ps=4.89u w=2u l=0.28u
X46 a_3807_25429# a_3807_21229# VDD VDD pfet_03v3 ad=0.89p pd=4.89u as=0.89p ps=4.89u w=2u l=0.28u
X47 a_7285_71460# a_3807_72189# VDD VDD pfet_03v3 ad=1.78p pd=8.89u as=1.78p ps=8.89u w=4u l=0.28u
X48 a_3925_54520# a_3807_55389# a_3780_54520# VSS nfet_03v3 ad=1.78p pd=8.89u as=1.78p ps=8.89u w=4u l=0.28u
X49 a_3807_21229# CLK.t5 VDD VDD pfet_03v3 ad=0.445p pd=2.89u as=0.445p ps=2.89u w=1u l=0.28u
X50 VSS CLK.t7 a_3780_54520# VSS nfet_03v3 ad=1.78p pd=8.89u as=1.06p ps=4.53u w=4u l=0.28u
X51 a_8265_43880# a_5487_36069# VDD VDD pfet_03v3 ad=0.89p pd=4.89u as=0.89p ps=4.89u w=2u l=0.28u
X52 MAG a_3925_48422# a_24920_1180# VSS nfet_03v3 ad=0.89p pd=4.89u as=0.89p ps=4.89u w=2u l=0.28u
X53 a_3807_72189# a_3807_67989# VSS VSS nfet_03v3 ad=0.445p pd=2.89u as=0.445p ps=2.89u w=1u l=0.28u
X54 a_3807_44609# a_5487_36069# VDD VDD pfet_03v3 ad=0.89p pd=4.89u as=0.89p ps=4.89u w=2u l=0.28u
X55 a_3925_25042# a_3807_25429# VSS VSS nfet_03v3 ad=0.445p pd=2.89u as=0.445p ps=2.89u w=1u l=0.28u
X56 a_3925_54520# CLK.t7 VDD VDD pfet_03v3 ad=0.445p pd=2.89u as=0.445p ps=2.89u w=1u l=0.28u
X57 a_8120_58860# INN a_3780_54520# VSS nfet_03v3 ad=1.78p pd=8.89u as=1.78p ps=8.89u w=4u l=0.28u
X58 a_3925_31140# INP a_3780_31140# VSS nfet_03v3 ad=1.78p pd=8.89u as=1.78p ps=8.89u w=4u l=0.28u
X59 a_24920_1180# a_5487_25429# VSS VSS nfet_03v3 ad=0.89p pd=4.89u as=0.89p ps=4.89u w=2u l=0.28u
X60 a_8120_58860# a_3807_55389# a_3780_54520# VSS nfet_03v3 ad=1.78p pd=8.89u as=1.78p ps=8.89u w=4u l=0.28u
X61 a_5487_12689# a_3807_21229# a_8120_12100# VSS nfet_03v3 ad=0.89p pd=4.89u as=0.89p ps=4.89u w=2u l=0.28u
X62 a_17060_2973# a_19300_1364# VSS ppolyf_u_1k r_width=10u r_length=7.435u
X63 a_8265_20500# a_5487_12689# VDD VDD pfet_03v3 ad=0.89p pd=4.89u as=0.89p ps=4.89u w=2u l=0.28u
X64 a_8265_20500# a_5487_12689# VSS VSS nfet_03v3 ad=0.445p pd=2.89u as=0.445p ps=2.89u w=1u l=0.28u
X65 a_8120_12100# CLK.t2 VDD VDD pfet_03v3 ad=0.445p pd=2.89u as=0.445p ps=2.89u w=1u l=0.28u
X66 a_3925_7760# a_1380_1364# a_3780_7760# VSS nfet_03v3 ad=1.78p pd=8.89u as=1.78p ps=8.89u w=4u l=0.28u
X67 VSS CLK.t0 a_3780_7760# VSS nfet_03v3 ad=1.78p pd=8.89u as=1.06p ps=4.53u w=4u l=0.28u
X68 a_8120_12100# INN a_3780_7760# VSS nfet_03v3 ad=1.78p pd=8.89u as=1.78p ps=8.89u w=4u l=0.28u
X69 a_3807_32009# a_19300_1364# VSS ppolyf_u_1k r_width=10u r_length=7.435u
X70 a_3807_21229# a_5487_12689# VDD VDD pfet_03v3 ad=0.89p pd=4.89u as=0.89p ps=4.89u w=2u l=0.28u
X71 a_5487_48809# a_8265_43880# VSS VSS nfet_03v3 ad=0.445p pd=2.89u as=0.445p ps=2.89u w=1u l=0.28u
X72 a_3807_44609# CLK.t6 VDD VDD pfet_03v3 ad=0.445p pd=2.89u as=0.445p ps=2.89u w=1u l=0.28u
X73 a_5487_59449# CLK.t7 VDD VDD pfet_03v3 ad=0.445p pd=2.89u as=0.445p ps=2.89u w=1u l=0.28u
X74 a_5487_36069# a_3807_44609# VDD VDD pfet_03v3 ad=0.89p pd=4.89u as=0.89p ps=4.89u w=2u l=0.28u
X75 a_17060_2973# VSS VSS ppolyf_u_1k r_width=10u r_length=7.435u
X76 MAG a_3925_48422# VDD VDD pfet_03v3 ad=0.89p pd=4.89u as=0.89p ps=4.89u w=2u l=0.28u
X77 a_3807_67989# a_5487_59449# VDD VDD pfet_03v3 ad=0.89p pd=4.89u as=0.89p ps=4.89u w=2u l=0.28u
X78 a_3925_7760# INP a_3780_7760# VSS nfet_03v3 ad=1.78p pd=8.89u as=1.78p ps=8.89u w=4u l=0.28u
X79 MAG a_5487_25429# VDD VDD pfet_03v3 ad=0.89p pd=4.89u as=0.89p ps=4.89u w=2u l=0.28u
X80 a_3807_55389# VSS cap_mim_2f0_m4m5_noshield c_width=50u c_length=50u
X81 SIGN a_8265_67260# VSS VSS nfet_03v3 ad=0.445p pd=2.89u as=0.445p ps=2.89u w=1u l=0.28u
X82 a_3925_31140# a_3807_32009# a_3780_31140# VSS nfet_03v3 ad=1.78p pd=8.89u as=1.78p ps=8.89u w=4u l=0.28u
X83 a_5487_12689# a_3807_21229# VDD VDD pfet_03v3 ad=0.89p pd=4.89u as=0.89p ps=4.89u w=2u l=0.28u
X84 a_3925_48422# a_5487_48809# VSS VSS nfet_03v3 ad=0.445p pd=2.89u as=0.445p ps=2.89u w=1u l=0.28u
X85 a_3925_31140# CLK.t6 VDD VDD pfet_03v3 ad=0.445p pd=2.89u as=0.445p ps=2.89u w=1u l=0.28u
X86 VSS CLK.t6 a_3780_31140# VSS nfet_03v3 ad=1.78p pd=8.89u as=1.06p ps=4.53u w=4u l=0.28u
X87 a_5487_12689# CLK.t4 VDD VDD pfet_03v3 ad=0.445p pd=2.89u as=0.445p ps=2.89u w=1u l=0.28u
X88 a_8265_67260# a_5487_59449# VSS VSS nfet_03v3 ad=0.445p pd=2.89u as=0.445p ps=2.89u w=1u l=0.28u
X89 a_3807_67989# a_5487_59449# a_3925_54520# VSS nfet_03v3 ad=0.89p pd=4.89u as=0.89p ps=4.89u w=2u l=0.28u
X90 a_3780_54520# CLK.t7 VSS VSS nfet_03v3 ad=1.06p pd=4.53u as=1.78p ps=8.89u w=4u l=0.28u
X91 a_11480_48080# a_8265_43880# VDD VDD pfet_03v3 ad=1.78p pd=8.89u as=1.78p ps=8.89u w=4u l=0.28u
X92 a_3807_48809# a_3807_44609# VSS VSS nfet_03v3 ad=0.445p pd=2.89u as=0.445p ps=2.89u w=1u l=0.28u
X93 a_3780_7760# CLK.t1 VSS VSS nfet_03v3 ad=1.06p pd=4.53u as=1.78p ps=8.89u w=4u l=0.28u
X94 a_1380_3090# a_3620_1364# VSS ppolyf_u_1k r_width=10u r_length=8.02u
C0 a_3925_48422# MAG 0.27462f
C1 a_10524_7700# a_8120_12100# 0.01552f
C2 a_7596_7700# a_3780_7760# 0.01072f
C3 CLK a_3807_25429# 0.03709f
C4 a_5344_39620# VDD 0.36665f
C5 a_3664_7700# a_3780_7760# 0.04076f
C6 a_3925_7760# INN 0.01807f
C7 a_5487_36069# CLK 0.12136f
C8 a_7285_71460# a_7434_71400# 0.04654f
C9 a_9114_48020# a_8704_48020# 0.0129f
C10 a_10524_7700# a_10934_7700# 0.0129f
C11 a_8265_67260# a_8414_67200# 0.02481f
C12 a_5754_71742# a_3925_71802# 0.01595f
C13 a_11364_24640# a_11480_24700# 0.04076f
C14 a_11480_48080# a_13044_48020# 0.01509f
C15 a_3664_12382# VDD 0.22745f
C16 a_11774_24640# VDD 0.58329f
C17 a_3780_31140# INP 0.06179f
C18 a_13454_24640# VDD 0.60275f
C19 a_3807_25429# a_4074_20782# 0.01732f
C20 a_10934_54460# a_10524_54460# 0.0129f
C21 a_8414_63000# VDD 0.34888f
C22 a_8120_35480# CLK 0.08625f
C23 a_5487_48809# a_16814_48362# 0.01296f
C24 a_13044_48020# VDD 0.63223f
C25 a_5754_39620# a_3807_44609# 0.02853f
C26 a_7024_24640# VDD 0.63479f
C27 a_10094_16582# VDD 0.21515f
C28 a_10524_7700# a_3780_7760# 0.04917f
C29 a_3807_67989# INN 0.10995f
C30 a_3807_48809# VDD 1.21426f
C31 a_4074_16582# VDD 0.21462f
C32 a_13044_71400# VDD 0.63223f
C33 a_3925_7760# a_5487_12689# 0.02512f
C34 a_5344_43820# VDD 0.36377f
C35 a_3780_54520# a_10524_54460# 0.04917f
C36 a_3925_31140# a_5754_31080# 0.04066f
C37 a_11364_71400# a_3925_71802# 0.01581f
C38 a_10094_35762# VDD 0.21693f
C39 a_8265_43880# a_5487_48809# 0.1086f
C40 a_25214_1120# MAG 0.02496f
C41 a_3780_31140# a_5344_31080# 0.04956f
C42 a_3925_31140# a_3807_32009# 0.06928f
C43 a_11480_71460# a_11774_71400# 0.01648f
C44 a_7434_24640# VDD 0.60019f
C45 a_8120_58860# a_10094_59142# 0.01149f
C46 a_8414_16240# a_5487_12689# 0.02223f
C47 a_3780_7760# a_5754_7700# 0.01384f
C48 a_3925_48422# a_5487_25429# 1.82821f
C49 a_5487_25429# a_15134_24982# 0.01296f
C50 INN a_8120_12100# 0.11209f
C51 INN a_5487_12689# 0.19161f
C52 a_11364_24640# a_3925_25042# 0.01581f
C53 a_3780_31140# a_8844_31080# 0.05544f
C54 a_3925_31140# VDD 0.68858f
C55 a_3925_7760# a_3780_7760# 0.66682f
C56 a_7285_48080# a_3807_48809# 0.05138f
C57 a_3925_54520# INP 0.27323f
C58 INP a_1380_1364# 0.24514f
C59 a_8265_43880# a_5487_36069# 0.14279f
C60 a_11480_71460# a_13454_71400# 0.04066f
C61 a_3780_54520# INN 0.05829f
C62 a_3807_48809# CLK 0.03709f
C63 a_3807_72189# a_3925_71802# 0.19076f
C64 a_13454_24640# a_13044_24640# 0.0129f
C65 a_5487_48809# a_3925_48422# 0.70976f
C66 a_3780_54520# a_5754_54460# 0.01384f
C67 a_5344_63000# VDD 0.36505f
C68 a_8704_48020# VDD 0.58253f
C69 a_3664_16582# VDD 0.22567f
C70 a_3780_7760# INN 0.05829f
C71 a_3807_44609# VDD 2.99884f
C72 a_8120_12100# a_5487_12689# 0.20813f
C73 SIGN a_11774_71400# 0.04353f
C74 a_11480_48080# a_13454_48020# 0.04066f
C75 a_8265_20500# a_8414_20440# 0.02481f
C76 a_11480_71460# a_3925_71802# 0.16289f
C77 a_29844_1120# VDD 0.36279f
C78 a_4074_63342# a_3807_67989# 0.01226f
C79 a_10934_7700# a_8120_12100# 0.04066f
C80 a_11774_71400# VDD 0.58329f
C81 a_3925_31140# CLK 0.02299f
C82 a_13454_48020# VDD 0.60275f
C83 a_5487_59449# a_10094_63342# 0.01149f
C84 a_11364_24640# VDD 0.58317f
C85 a_3807_72189# a_3807_67989# 0.11878f
C86 a_8265_20500# a_10094_20782# 0.0139f
C87 a_7285_48080# a_8704_48020# 0.04961f
C88 a_3780_7760# a_8120_12100# 0.58568f
C89 a_7596_31080# a_3780_31140# 0.01072f
C90 a_11364_48020# a_11480_48080# 0.04076f
C91 a_5487_25429# MAG 0.1602f
C92 a_28164_1120# VDD 0.36279f
C93 a_24920_1180# a_3925_48422# 0.0516f
C94 a_8120_58860# a_8004_58800# 0.01998f
C95 a_11480_48080# a_11774_48020# 0.01648f
C96 a_13454_71400# VDD 0.60275f
C97 a_8265_43880# a_10094_44162# 0.0139f
C98 a_5487_36069# a_10094_39962# 0.01149f
C99 a_3780_31140# a_7024_31080# 0.0178f
C100 a_5487_59449# a_3925_54520# 0.02512f
C101 CLK a_3807_44609# 0.16378f
C102 a_8265_20500# a_5487_25429# 0.1086f
C103 a_8100_1364# a_1380_1364# 0.03767f
C104 a_5487_59449# a_1380_1364# 0.03924f
C105 a_11364_48020# VDD 0.58317f
C106 a_8120_35480# a_3780_31140# 0.58568f
C107 a_5487_59449# a_8004_58800# 0.01371f
C108 a_8004_20440# VDD 0.36665f
C109 a_8004_63000# VDD 0.3627f
C110 a_11774_48020# VDD 0.58329f
C111 SIGN a_3925_71802# 0.69483f
C112 a_4074_35762# VDD 0.21379f
C113 a_8704_24640# a_9114_24640# 0.0129f
C114 a_10934_31080# a_10524_31080# 0.0129f
C115 a_3925_71802# VDD 1.67089f
C116 a_8004_43820# VDD 0.36665f
C117 a_3925_7760# VDD 0.68858f
C118 a_1380_1364# a_1380_3090# 0.02927f
C119 a_3807_44609# a_4074_39962# 0.01511f
C120 a_3925_54520# a_4074_59142# 0.01511f
C121 a_8414_39620# VDD 0.35048f
C122 a_5487_36069# a_1380_1364# 0.75417f
C123 a_5754_12040# a_3807_21229# 0.02871f
C124 INN a_3807_32009# 1.87941f
C125 a_3664_63342# VDD 0.22567f
C126 a_8414_16240# VDD 0.34888f
C127 a_11480_71460# a_11364_71400# 0.04076f
C128 a_7285_24700# a_5487_25429# 0.20754f
C129 a_5754_63000# a_3807_67989# 0.02659f
C130 a_8704_24640# a_3925_25042# 0.01772f
C131 a_7024_71400# VDD 0.63479f
C132 a_3807_48809# a_3925_48422# 0.19076f
C133 a_3780_54520# a_7596_54460# 0.01072f
C134 INN VDD 1.20738f
C135 a_8120_35480# a_1380_1364# 0.56518f
C136 a_3807_67989# VDD 2.95024f
C137 a_28574_1120# MAG 0.0228f
C138 a_5860_3090# VDD 0.01044f
C139 a_3925_25042# a_11480_24700# 0.16289f
C140 a_8120_12100# a_3807_32009# 0.56518f
C141 a_24920_1180# MAG 0.39581f
C142 a_3807_55389# INN 0.09114f
C143 a_3925_7760# CLK 0.02299f
C144 a_3807_32009# a_5487_12689# 1.01336f
C145 a_3807_67989# a_3807_55389# 0.83699f
C146 a_9254_54460# a_8844_54460# 0.0129f
C147 a_5754_43820# VDD 0.34967f
C148 a_3807_21229# a_3807_25429# 0.11878f
C149 a_3925_7760# a_4074_12382# 0.01511f
C150 a_3925_31140# a_3780_31140# 0.66682f
C151 a_7285_71460# a_3925_71802# 0.37231f
C152 a_8120_12100# VDD 0.72081f
C153 a_3925_25042# a_9114_24640# 0.04484f
C154 a_9254_7700# a_8120_12100# 0.05266f
C155 a_5487_12689# VDD 3.07678f
C156 SIGN a_11364_71400# 0.02214f
C157 a_9684_59142# VDD 0.22431f
C158 a_5487_59449# a_8120_58860# 0.20813f
C159 INN CLK 5.05771f
C160 a_8704_24640# VDD 0.58253f
C161 a_3807_67989# CLK 0.15489f
C162 a_3925_71802# a_8704_71400# 0.01772f
C163 a_3780_7760# a_3807_32009# 0.05974f
C164 a_11364_71400# VDD 0.58317f
C165 a_7285_24700# a_3807_25429# 0.05138f
C166 a_4074_31080# a_3780_31140# 0.01483f
C167 a_5487_25429# a_3807_25429# 0.11516f
C168 a_3925_48422# a_8704_48020# 0.01772f
C169 a_3780_54520# a_3807_55389# 0.12103f
C170 a_11480_24700# VDD 0.94704f
C171 a_9254_7700# a_3780_7760# 0.01037f
C172 a_4074_63342# VDD 0.21462f
C173 a_3807_72189# SIGN 0.11516f
C174 a_24920_1180# a_5487_25429# 0.04369f
C175 a_8120_12100# CLK 0.08625f
C176 a_9114_48020# VDD 0.58394f
C177 a_7434_48020# a_7024_48020# 0.0129f
C178 CLK a_5487_12689# 0.11777f
C179 a_9114_24640# VDD 0.58394f
C180 a_3807_72189# VDD 1.21426f
C181 a_9254_54460# a_8120_58860# 0.05266f
C182 a_3780_54520# CLK 0.13796f
C183 a_5344_58800# a_3925_54520# 0.02887f
C184 a_8120_12100# a_8004_12040# 0.01998f
C185 a_11480_71460# SIGN 0.38275f
C186 a_5487_12689# a_8004_12040# 0.01371f
C187 a_5754_39620# VDD 0.3476f
C188 a_5487_36069# a_8004_39620# 0.0136f
C189 a_4074_7700# a_3664_7700# 0.0129f
C190 a_10094_12382# a_8120_12100# 0.01149f
C191 a_3780_31140# a_9254_31080# 0.01037f
C192 a_11364_48020# a_3925_48422# 0.01581f
C193 a_4074_16582# a_3807_21229# 0.01226f
C194 a_5754_24982# a_3925_25042# 0.01595f
C195 a_11480_71460# VDD 0.94704f
C196 a_11774_48020# a_3925_48422# 0.01288f
C197 a_3780_7760# CLK 0.13796f
C198 a_5487_48809# a_15134_48362# 0.01296f
C199 a_5344_7700# a_5754_7700# 0.0129f
C200 a_5487_25429# a_11774_24640# 0.04353f
C201 a_3925_25042# VDD 1.67089f
C202 a_5754_20440# VDD 0.34967f
C203 a_5487_59449# a_8265_67260# 0.14279f
C204 a_3807_44609# a_1380_1364# 0.41482f
C205 a_3664_35762# VDD 0.22745f
C206 a_3925_31140# INP 0.27323f
C207 a_5344_7700# a_3925_7760# 0.01552f
C208 a_3807_72189# CLK 0.03709f
C209 a_3925_25042# a_3807_55389# 0.08711f
C210 a_11480_24700# a_13044_24640# 0.01509f
C211 a_9684_16582# VDD 0.22431f
C212 a_3925_25042# a_4074_24982# 0.01511f
C213 a_29844_1120# MAG 0.01113f
C214 a_8120_35480# a_5487_36069# 0.20813f
C215 a_9114_71400# a_3925_71802# 0.04484f
C216 a_7285_24700# a_7434_24640# 0.04654f
C217 a_3807_32009# VDD 2.70768f
C218 a_5487_59449# a_8414_63000# 0.02223f
C219 a_3807_72189# a_7285_71460# 0.05138f
C220 a_3780_31140# a_3664_31080# 0.04076f
C221 a_5754_54460# a_5344_54460# 0.0129f
C222 a_11480_48080# VDD 0.94704f
C223 a_3807_48809# a_4074_44162# 0.01732f
C224 SIGN VDD 2.26144f
C225 a_5754_63000# VDD 0.34727f
C226 a_3925_31140# a_5344_31080# 0.01552f
C227 INN a_3780_31140# 0.05829f
C228 a_3807_55389# a_3807_32009# 0.40092f
C229 a_4074_7700# a_3925_7760# 0.05124f
C230 a_3807_67989# a_5754_67200# 0.01094f
C231 SIGN a_3807_55389# 0.0364f
C232 a_3807_48809# a_5487_48809# 0.11516f
C233 a_28164_1120# MAG 0.01113f
C234 a_8004_16240# a_5487_12689# 0.01146f
C235 a_3807_55389# VDD 6.10415f
C236 a_3780_54520# a_5344_54460# 0.04956f
C237 a_8414_67200# VDD 0.3476f
C238 a_4074_54460# a_3780_54520# 0.01483f
C239 a_3925_7760# a_1380_1364# 0.06928f
C240 CLK a_3807_32009# 3.55579f
C241 a_7285_48080# VDD 0.88551f
C242 a_5344_16240# VDD 0.36505f
C243 CLK VDD 13.6311f
C244 a_8004_67200# VDD 0.36665f
C245 a_3925_54520# INN 0.01807f
C246 a_11364_24640# a_5487_25429# 0.02214f
C247 a_3925_54520# a_3807_67989# 0.10361f
C248 INN a_1380_1364# 0.27074f
C249 a_4074_12382# VDD 0.21379f
C250 a_3807_67989# a_1380_1364# 0.03924f
C251 SIGN a_7285_71460# 0.20754f
C252 a_5344_7700# a_3780_7760# 0.04956f
C253 a_3807_55389# CLK 0.72898f
C254 a_3925_54520# a_5754_54460# 0.04066f
C255 a_3925_7760# INP 0.27323f
C256 a_5487_36069# a_3925_31140# 0.02512f
C257 a_5344_67200# VDD 0.36377f
C258 a_5487_48809# a_8704_48020# 0.01306f
C259 a_8120_35480# a_10094_35762# 0.01149f
C260 a_5487_25429# a_16814_24982# 0.01296f
C261 a_7285_71460# VDD 0.88551f
C262 a_13044_24640# VDD 0.63223f
C263 a_9114_48020# a_3925_48422# 0.04484f
C264 a_10094_12382# VDD 0.21693f
C265 SIGN a_8704_71400# 0.01306f
C266 a_30254_1120# VDD 0.35048f
C267 a_3925_7760# a_3807_21229# 0.10361f
C268 a_3807_67989# a_5754_58800# 0.02871f
C269 a_4074_39962# VDD 0.21462f
C270 a_8704_71400# VDD 0.58253f
C271 a_8844_31080# a_9254_31080# 0.0129f
C272 a_3807_72189# a_5754_67200# 0.01988f
C273 INN INP 4.68251f
C274 a_5487_36069# a_3807_44609# 0.76576f
C275 a_4074_7700# a_3780_7760# 0.01483f
C276 a_3664_39962# VDD 0.22745f
C277 a_3664_59142# VDD 0.22745f
C278 a_3780_54520# a_3925_54520# 0.66682f
C279 INN a_3807_21229# 0.10995f
C280 a_9684_35762# VDD 0.22431f
C281 a_11480_48080# a_8265_43880# 0.06318f
C282 a_3925_71802# a_4074_71742# 0.01511f
C283 a_5487_36069# a_8414_35420# 0.01993f
C284 a_3780_54520# a_3664_54460# 0.04076f
C285 a_3925_25042# a_3925_48422# 0.01554f
C286 a_5487_59449# a_8004_63000# 0.01145f
C287 a_8120_58860# a_10524_54460# 0.01552f
C288 a_11364_48020# a_5487_48809# 0.02214f
C289 a_8265_20500# a_5487_12689# 0.14279f
C290 a_8265_43880# VDD 1.32076f
C291 a_7434_24640# a_7024_24640# 0.0129f
C292 a_8120_35480# a_3807_44609# 0.02886f
C293 a_11774_48020# a_5487_48809# 0.04353f
C294 a_3780_7760# a_1380_1364# 0.06129f
C295 a_7024_7700# a_3780_7760# 0.0178f
C296 a_3780_31140# a_10524_31080# 0.04917f
C297 a_5754_16240# VDD 0.34727f
C298 a_3925_31140# a_5344_35420# 0.02887f
C299 a_8120_35480# a_8414_35420# 0.01311f
C300 a_5344_12040# a_3925_7760# 0.02887f
C301 a_8265_43880# a_3807_55389# 0.04457f
C302 a_8120_12100# a_3807_21229# 0.02886f
C303 a_24920_1180# a_24804_1120# 0.01998f
C304 a_3780_54520# a_8844_54460# 0.05544f
C305 a_3807_21229# a_5487_12689# 0.72779f
C306 a_3780_31140# a_5754_31080# 0.01384f
C307 a_10094_59142# VDD 0.21693f
C308 a_8004_16240# VDD 0.3627f
C309 a_3780_54520# INP 0.06179f
C310 a_8414_43820# VDD 0.3476f
C311 a_8265_20500# a_11480_24700# 0.06318f
C312 a_3925_48422# a_3807_32009# 0.08539f
C313 a_3780_31140# a_3807_32009# 0.06129f
C314 a_11480_48080# a_3925_48422# 0.16289f
C315 SIGN a_3925_48422# 1.50209f
C316 a_7285_71460# a_8704_71400# 0.04961f
C317 a_8120_58860# INN 0.11209f
C318 a_8120_58860# a_3807_67989# 0.02886f
C319 a_3780_7760# INP 0.06179f
C320 a_5487_59449# INN 0.19161f
C321 a_3925_48422# VDD 2.77011f
C322 a_8120_35480# a_9254_31080# 0.05266f
C323 a_5487_59449# a_3807_67989# 0.72779f
C324 a_7434_71400# a_7024_71400# 0.0129f
C325 a_5754_67200# VDD 0.34967f
C326 SIGN a_9114_71400# 0.01283f
C327 a_3807_48809# a_3807_44609# 0.11878f
C328 a_11364_24640# a_11774_24640# 0.0129f
C329 a_8704_24640# a_7285_24700# 0.04961f
C330 a_5487_36069# a_8414_39620# 0.02223f
C331 a_3807_55389# a_3925_48422# 0.13033f
C332 a_5344_20440# VDD 0.36377f
C333 a_8704_24640# a_5487_25429# 0.01306f
C334 a_13044_48020# a_13454_48020# 0.0129f
C335 a_10094_39962# VDD 0.21693f
C336 a_9114_71400# VDD 0.58394f
C337 a_10934_54460# a_8120_58860# 0.04066f
C338 a_3925_48422# a_4074_48362# 0.01511f
C339 a_8265_67260# a_3925_71802# 0.38327f
C340 a_10094_63342# VDD 0.21515f
C341 a_7285_48080# a_3925_48422# 0.37231f
C342 a_4074_31080# a_3925_31140# 0.05124f
C343 a_3925_25042# a_8265_20500# 0.38136f
C344 INN a_5487_36069# 0.19161f
C345 a_5487_25429# a_11480_24700# 0.38275f
C346 a_3780_54520# a_8120_58860# 0.58568f
C347 a_3925_31140# a_3807_44609# 0.10361f
C348 a_3807_32009# a_1380_1364# 1.66095f
C349 a_3780_31140# CLK 0.13796f
C350 SIGN a_1380_1364# 0.04359f
C351 a_13454_71400# a_13044_71400# 0.0129f
C352 a_3780_7760# a_8844_7700# 0.05544f
C353 a_8414_12040# a_8120_12100# 0.01311f
C354 a_5487_25429# a_9114_24640# 0.01283f
C355 a_8120_35480# a_10934_31080# 0.04066f
C356 a_8414_12040# a_5487_12689# 0.01993f
C357 a_5754_20440# a_3807_21229# 0.01094f
C358 a_3925_54520# VDD 0.68858f
C359 INN a_8120_35480# 0.11209f
C360 a_1380_1364# VDD 3.71458f
C361 SIGN MAG 0.0548f
C362 a_9684_63342# VDD 0.22431f
C363 a_5754_35420# a_3807_44609# 0.02871f
C364 a_3925_54520# a_3807_55389# 0.06928f
C365 a_3807_55389# a_1380_1364# 1.28772f
C366 MAG VDD 1.16766f
C367 INP a_3807_32009# 2.35552f
C368 a_9114_48020# a_5487_48809# 0.01283f
C369 a_3925_25042# a_7285_24700# 0.37231f
C370 a_8265_20500# VDD 1.32076f
C371 a_3925_25042# a_5487_25429# 0.69384f
C372 a_9254_54460# a_3780_54520# 0.01037f
C373 a_3807_21229# a_3807_32009# 0.83699f
C374 a_3620_1364# a_1380_1364# 0.04825f
C375 a_8265_43880# a_8414_43820# 0.02481f
C376 a_3925_31140# a_4074_35762# 0.01511f
C377 INP VDD 1.27427f
C378 a_8414_20440# VDD 0.3476f
C379 a_3925_54520# CLK 0.02299f
C380 a_3807_55389# a_8265_20500# 0.04457f
C381 a_9114_71400# a_8704_71400# 0.0129f
C382 CLK a_1380_1364# 6.01291f
C383 a_5754_31080# a_5344_31080# 0.0129f
C384 a_3780_54520# a_7024_54460# 0.0178f
C385 a_3807_21229# VDD 2.95512f
C386 a_3807_55389# INP 0.07112f
C387 a_8265_43880# a_3925_48422# 0.38136f
C388 SIGN a_16814_71742# 0.01296f
C389 a_5487_25429# a_3807_32009# 0.08329f
C390 a_8120_58860# a_8414_58800# 0.01311f
C391 a_17060_2973# a_3807_32009# 0.18155f
C392 a_5487_59449# a_8414_58800# 0.01993f
C393 a_3807_48809# a_5754_43820# 0.01988f
C394 a_7285_24700# VDD 0.88551f
C395 a_5487_36069# a_8004_35420# 0.01371f
C396 a_5487_25429# VDD 2.70924f
C397 a_7434_48020# VDD 0.60019f
C398 a_10094_16582# a_5487_12689# 0.01149f
C399 INP CLK 2.1457f
C400 INN a_3925_31140# 0.01807f
C401 a_5754_20440# a_3807_25429# 0.01988f
C402 a_3925_25042# a_3807_25429# 0.19076f
C403 a_24920_1180# a_26894_1120# 0.01988f
C404 a_30254_1120# MAG 0.0228f
C405 a_9684_39962# VDD 0.22431f
C406 a_11774_71400# a_3925_71802# 0.01288f
C407 CLK a_3807_21229# 0.15489f
C408 a_3807_55389# a_5487_25429# 0.08957f
C409 a_9254_7700# a_8844_7700# 0.0129f
C410 a_11480_24700# a_11774_24640# 0.01648f
C411 a_5754_48362# a_3925_48422# 0.01595f
C412 a_4074_31080# a_3664_31080# 0.0129f
C413 a_13454_24640# a_11480_24700# 0.04066f
C414 a_8120_58860# VDD 0.72081f
C415 a_8120_35480# a_8004_35420# 0.01998f
C416 a_11480_48080# a_5487_48809# 0.38275f
C417 a_5487_59449# VDD 3.07203f
C418 a_11364_48020# a_11774_48020# 0.0129f
C419 a_7434_48020# a_7285_48080# 0.04654f
C420 INN a_3807_44609# 0.10995f
C421 a_8265_67260# a_10094_67542# 0.0139f
C422 a_11480_71460# a_8265_67260# 0.06318f
C423 a_8120_58860# a_3807_55389# 0.56518f
C424 a_5487_48809# VDD 1.58447f
C425 a_7434_71400# VDD 0.60019f
C426 a_8100_1364# a_3807_55389# 0.01008f
C427 a_8004_39620# VDD 0.36279f
C428 a_5487_59449# a_3807_55389# 1.01336f
C429 a_8120_35480# a_10524_31080# 0.01552f
C430 a_3807_55389# a_5487_48809# 0.13316f
C431 a_5754_43820# a_3807_44609# 0.01094f
C432 a_3925_54520# a_5344_54460# 0.01552f
C433 a_3807_25429# VDD 1.21426f
C434 a_4074_54460# a_3925_54520# 0.05124f
C435 a_8120_58860# CLK 0.08625f
C436 a_5487_36069# VDD 3.11155f
C437 a_15134_71742# SIGN 0.01296f
C438 a_3925_7760# a_5754_7700# 0.04066f
C439 a_4074_59142# VDD 0.21379f
C440 a_3925_25042# a_11774_24640# 0.01288f
C441 a_28574_1120# VDD 0.34967f
C442 a_7285_48080# a_5487_48809# 0.20754f
C443 a_5487_59449# CLK 0.11777f
C444 a_9684_12382# VDD 0.22431f
C445 a_4074_54460# a_3664_54460# 0.0129f
C446 SIGN a_8265_67260# 0.10869f
C447 a_11480_71460# a_13044_71400# 0.01509f
C448 a_7024_48020# VDD 0.63479f
C449 a_3780_31140# a_1380_1364# 0.05974f
C450 a_8120_35480# VDD 0.72081f
C451 a_3807_72189# a_4074_67542# 0.01732f
C452 a_8265_67260# VDD 1.32076f
C453 a_11364_71400# a_11774_71400# 0.0129f
C454 a_5754_16240# a_3807_21229# 0.02659f
R0 CLK.t6 CLK.n4 76.9535
R1 CLK.n1 CLK.t0 66.9351
R2 CLK.n1 CLK.t1 66.9351
R3 CLK.n0 CLK.t4 64.0265
R4 CLK.n3 CLK.t3 57.3995
R5 CLK.n4 CLK.t5 52.5086
R6 CLK.n0 CLK.t2 48.7505
R7 CLK.n2 CLK.n1 19.2009
R8 CLK.t7 CLK.t6 13.4165
R9 CLK.n3 CLK.n2 11.4065
R10 CLK.n4 CLK.n3 11.1725
R11 CLK CLK.t7 7.5785
R12 CLK.n2 CLK.n0 5.3165
C455 MAG VSS 17.4608f
C456 INN VSS 23.6504f
C457 INP VSS 15.7277f
C458 CLK VSS 36.6011f
C459 SIGN VSS 24.233f
C460 VDD VSS 0.41801p
C461 a_30254_1120# VSS 0.04368f
C462 a_29844_1120# VSS 0.04368f
C463 a_28574_1120# VSS 0.04368f
C464 a_28164_1120# VSS 0.04368f
C465 a_26894_1120# VSS 0.39439f
C466 a_26484_1120# VSS 0.40799f ; **FLOATING
C467 a_25214_1120# VSS 0.38371f
C468 a_24920_1180# VSS 0.95652f ; **FLOATING
C469 a_24804_1120# VSS 0.38721f
C470 a_19300_1364# VSS 4.72673f ; **FLOATING
C471 a_17060_2973# VSS 4.76546f ; **FLOATING
C472 a_8100_1364# VSS 4.39198f ; **FLOATING
C473 a_5860_3090# VSS 4.38724f ; **FLOATING
C474 a_3620_1364# VSS 4.3966f ; **FLOATING
C475 a_1380_3090# VSS 4.40625f ; **FLOATING
C476 a_10934_7700# VSS 0.65977f
C477 a_10524_7700# VSS 0.65679f
C478 a_9254_7700# VSS 0.65977f
C479 a_8844_7700# VSS 0.65832f
C480 a_7596_7700# VSS 0.74138f
C481 a_7024_7700# VSS 0.74083f
C482 a_5754_7700# VSS 0.65977f
C483 a_5344_7700# VSS 0.65679f
C484 a_4074_7700# VSS 0.65883f
C485 a_3780_7760# VSS 4.01893f ; **FLOATING
C486 a_3664_7700# VSS 0.65774f
C487 a_10094_12382# VSS 0.02717f
C488 a_9684_12382# VSS 0.02717f
C489 a_8414_12040# VSS 0.38483f
C490 a_8120_12100# VSS 2.70745f ; **FLOATING
C491 a_8004_12040# VSS 0.38539f
C492 a_5754_12040# VSS 0.38545f
C493 a_5344_12040# VSS 0.38483f
C494 a_4074_12382# VSS 0.02717f
C495 a_3925_7760# VSS 2.94014f ; **FLOATING
C496 a_3664_12382# VSS 0.02717f
C497 a_10094_16582# VSS 0.02717f
C498 a_9684_16582# VSS 0.02717f
C499 a_8414_16240# VSS 0.04368f
C500 a_8004_16240# VSS 0.04368f
C501 a_5754_16240# VSS 0.04368f
C502 a_5344_16240# VSS 0.04368f
C503 a_4074_16582# VSS 0.02717f
C504 a_3664_16582# VSS 0.02717f
C505 a_10094_20782# VSS 0.24358f
C506 a_9684_20782# VSS 0.25096f ; **FLOATING
C507 a_8414_20440# VSS 0.04368f
C508 a_8004_20440# VSS 0.04368f
C509 a_5487_12689# VSS 6.28554f ; **FLOATING
C510 a_5754_20440# VSS 0.04368f
C511 a_5344_20440# VSS 0.04368f
C512 a_4074_20782# VSS 0.24044f
C513 a_3664_20782# VSS 0.2541f ; **FLOATING
C514 a_3807_21229# VSS 6.88287f ; **FLOATING
C515 a_16814_24982# VSS 0.24358f
C516 a_16404_24982# VSS 0.25096f ; **FLOATING
C517 a_15134_24982# VSS 0.24358f
C518 a_14724_24982# VSS 0.25096f ; **FLOATING
C519 a_13454_24640# VSS 0.07326f
C520 a_13044_24640# VSS 0.07326f
C521 a_8265_20500# VSS 5.18849f ; **FLOATING
C522 a_11774_24640# VSS 0.07326f
C523 a_11480_24700# VSS 0.55804f ; **FLOATING
C524 a_11364_24640# VSS 0.07326f
C525 a_9114_24640# VSS 0.07326f
C526 a_8704_24640# VSS 0.07326f
C527 a_7434_24640# VSS 0.07326f
C528 a_7285_24700# VSS 0.40798f ; **FLOATING
C529 a_7024_24640# VSS 0.07326f
C530 a_5754_24982# VSS 0.24275f
C531 a_5344_24982# VSS 0.2518f ; **FLOATING
C532 a_5487_25429# VSS 16.115f ; **FLOATING
C533 a_4074_24982# VSS 0.24044f
C534 a_3925_25042# VSS 7.33969f ; **FLOATING
C535 a_3664_24982# VSS 0.2541f ; **FLOATING
C536 a_3807_25429# VSS 4.0535f ; **FLOATING
C537 a_10934_31080# VSS 0.65977f
C538 a_10524_31080# VSS 0.65679f
C539 a_1380_1364# VSS 93.8047f ; **FLOATING
C540 a_9254_31080# VSS 0.65977f
C541 a_8844_31080# VSS 0.65832f
C542 a_7596_31080# VSS 0.74138f
C543 a_7024_31080# VSS 0.74083f
C544 a_5754_31080# VSS 0.65977f
C545 a_5344_31080# VSS 0.65679f
C546 a_4074_31080# VSS 0.65883f
C547 a_3780_31140# VSS 4.01893f ; **FLOATING
C548 a_3664_31080# VSS 0.65774f
C549 a_3807_32009# VSS 86.0221f ; **FLOATING
C550 a_10094_35762# VSS 0.02717f
C551 a_9684_35762# VSS 0.02717f
C552 a_8414_35420# VSS 0.38483f
C553 a_8120_35480# VSS 2.70745f ; **FLOATING
C554 a_8004_35420# VSS 0.38539f
C555 a_5754_35420# VSS 0.38545f
C556 a_5344_35420# VSS 0.38483f
C557 a_4074_35762# VSS 0.02717f
C558 a_3925_31140# VSS 2.94014f ; **FLOATING
C559 a_3664_35762# VSS 0.02717f
C560 a_10094_39962# VSS 0.02717f
C561 a_9684_39962# VSS 0.02717f
C562 a_8414_39620# VSS 0.04368f
C563 a_8004_39620# VSS 0.04368f
C564 a_5754_39620# VSS 0.04368f
C565 a_5344_39620# VSS 0.04368f
C566 a_4074_39962# VSS 0.02717f
C567 a_3664_39962# VSS 0.02717f
C568 a_10094_44162# VSS 0.24358f
C569 a_9684_44162# VSS 0.25096f ; **FLOATING
C570 a_8414_43820# VSS 0.04368f
C571 a_8004_43820# VSS 0.04368f
C572 a_5487_36069# VSS 6.34344f ; **FLOATING
C573 a_5754_43820# VSS 0.04368f
C574 a_5344_43820# VSS 0.04368f
C575 a_4074_44162# VSS 0.24044f
C576 a_3664_44162# VSS 0.2541f ; **FLOATING
C577 a_3807_44609# VSS 7.20592f ; **FLOATING
C578 a_16814_48362# VSS 0.24358f
C579 a_16404_48362# VSS 0.25096f ; **FLOATING
C580 a_15134_48362# VSS 0.24358f
C581 a_14724_48362# VSS 0.25096f ; **FLOATING
C582 a_13454_48020# VSS 0.07326f
C583 a_13044_48020# VSS 0.07326f
C584 a_8265_43880# VSS 5.18849f ; **FLOATING
C585 a_11774_48020# VSS 0.07326f
C586 a_11480_48080# VSS 0.55804f ; **FLOATING
C587 a_11364_48020# VSS 0.07326f
C588 a_9114_48020# VSS 0.07326f
C589 a_8704_48020# VSS 0.07326f
C590 a_7434_48020# VSS 0.07326f
C591 a_7285_48080# VSS 0.40798f ; **FLOATING
C592 a_7024_48020# VSS 0.07326f
C593 a_5754_48362# VSS 0.24275f
C594 a_5344_48362# VSS 0.2518f ; **FLOATING
C595 a_5487_48809# VSS 9.28035f ; **FLOATING
C596 a_4074_48362# VSS 0.24044f
C597 a_3925_48422# VSS 22.0819f ; **FLOATING
C598 a_3664_48362# VSS 0.2541f ; **FLOATING
C599 a_3807_48809# VSS 4.0535f ; **FLOATING
C600 a_10934_54460# VSS 0.65977f
C601 a_10524_54460# VSS 0.65679f
C602 a_9254_54460# VSS 0.65977f
C603 a_8844_54460# VSS 0.65832f
C604 a_7596_54460# VSS 0.74138f
C605 a_7024_54460# VSS 0.74083f
C606 a_5754_54460# VSS 0.65977f
C607 a_5344_54460# VSS 0.65679f
C608 a_4074_54460# VSS 0.65883f
C609 a_3780_54520# VSS 4.01893f ; **FLOATING
C610 a_3664_54460# VSS 0.65774f
C611 a_3807_55389# VSS 98.5123f ; **FLOATING
C612 a_10094_59142# VSS 0.02717f
C613 a_9684_59142# VSS 0.02717f
C614 a_8414_58800# VSS 0.38483f
C615 a_8120_58860# VSS 2.70745f ; **FLOATING
C616 a_8004_58800# VSS 0.38539f
C617 a_5754_58800# VSS 0.38545f
C618 a_5344_58800# VSS 0.38483f
C619 a_4074_59142# VSS 0.02717f
C620 a_3925_54520# VSS 2.94014f ; **FLOATING
C621 a_3664_59142# VSS 0.02717f
C622 a_10094_63342# VSS 0.02717f
C623 a_9684_63342# VSS 0.02717f
C624 a_8414_63000# VSS 0.04368f
C625 a_8004_63000# VSS 0.04368f
C626 a_5754_63000# VSS 0.04368f
C627 a_5344_63000# VSS 0.04368f
C628 a_4074_63342# VSS 0.02717f
C629 a_3664_63342# VSS 0.02717f
C630 a_10094_67542# VSS 0.24358f
C631 a_9684_67542# VSS 0.25096f ; **FLOATING
C632 a_8414_67200# VSS 0.04368f
C633 a_8004_67200# VSS 0.04368f
C634 a_5487_59449# VSS 6.28023f ; **FLOATING
C635 a_5754_67200# VSS 0.04368f
C636 a_5344_67200# VSS 0.04368f
C637 a_4074_67542# VSS 0.24044f
C638 a_3664_67542# VSS 0.2541f ; **FLOATING
C639 a_3807_67989# VSS 6.87756f ; **FLOATING
C640 a_16814_71742# VSS 0.24358f
C641 a_16404_71742# VSS 0.25096f ; **FLOATING
C642 a_15134_71742# VSS 0.24358f
C643 a_14724_71742# VSS 0.25096f ; **FLOATING
C644 a_13454_71400# VSS 0.07326f
C645 a_13044_71400# VSS 0.07326f
C646 a_8265_67260# VSS 5.1927f ; **FLOATING
C647 a_11774_71400# VSS 0.07326f
C648 a_11480_71460# VSS 0.55804f ; **FLOATING
C649 a_11364_71400# VSS 0.07326f
C650 a_9114_71400# VSS 0.07326f
C651 a_8704_71400# VSS 0.07326f
C652 a_7434_71400# VSS 0.07326f
C653 a_7285_71460# VSS 0.40798f ; **FLOATING
C654 a_7024_71400# VSS 0.07326f
C655 a_5754_71742# VSS 0.24275f
C656 a_5344_71742# VSS 0.2518f ; **FLOATING
C657 a_4074_71742# VSS 0.24044f
C658 a_3925_71802# VSS 7.34435f ; **FLOATING
C659 a_3664_71742# VSS 0.2541f ; **FLOATING
C660 a_3807_72189# VSS 4.0535f ; **FLOATING
C661 CLK.t2 VSS 0.07964f ; **FLOATING
C662 CLK.t4 VSS 0.23928f ; **FLOATING
C663 CLK.n0 VSS 1.28215f ; **FLOATING
C664 CLK.t0 VSS 0.1334f ; **FLOATING
C665 CLK.t1 VSS 0.1334f ; **FLOATING
C666 CLK.n1 VSS 0.55729f ; **FLOATING
C667 CLK.n2 VSS 1.14002f ; **FLOATING
C668 CLK.t3 VSS 0.11118f ; **FLOATING
C669 CLK.n3 VSS 1.13025f ; **FLOATING
C670 CLK.t5 VSS 0.08939f ; **FLOATING
C671 CLK.n4 VSS 4.364f ; **FLOATING
C672 CLK.t6 VSS 11.7864f ; **FLOATING
C673 CLK.t7 VSS 11.5455f ; **FLOATING
.ends

.subckt adc2b INP INN CLK SIGN MAG VDD VSS
XPEX VSS VDD INP INN CLK SIGN MAG adc2b_flat
.ends
.end
