** sch_path: /home/noritsuna/GPS/xschem/tb_adc.sch
**.subckt tb_adc
VDD vdd 0 3.3
VCK clk 0 pulse(0 3.3 0 0.2n 0.2n 30.3474n 61.0948n)
VIP inp 0 pwl(0 1.0 10u 1.4)
VIN inn 0 pwl(0 1.4 10u 1.0)
XA inp inn clk sign mag vdd 0 adc2b
C1 sign 0 50f
C2 mag 0 50f
**** begin user architecture code
 .include /home/noritsuna/pdk/gf180mcuD/libs.tech/ngspice/design.ngspice
.lib /home/noritsuna/pdk/gf180mcuD/libs.tech/ngspice/sm141064.ngspice typical
.lib /home/noritsuna/pdk/gf180mcuD/libs.tech/ngspice/sm141064.ngspice res_typical
.lib /home/noritsuna/pdk/gf180mcuD/libs.tech/ngspice/sm141064.ngspice mimcap_typical

.control
set num_threads=1
tran 0.1n 10u
let vd = v(inp)-v(inn)
meas tran ts when v(sign)=1.65 rise=1
meas tran tm1 when v(mag)=1.65 fall=1
meas tran tm2 when v(mag)=1.65 rise=1
meas tran vs find vd at=ts
meas tran vm1 find vd at=tm1
meas tran vm2 find vd at=tm2
echo RES vth_sign=$&vs vth_mag_lo=$&vm1 vth_mag_hi=$&vm2
meas tran thp avg v(xa.xpex.thp) from=2u to=8u
meas tran thm avg v(xa.xpex.thm) from=2u to=8u
meas tran thn avg v(xa.xpex.thn) from=2u to=8u
echo RES ladder thp=$&thp thm=$&thm thn=$&thn
meas tran iavg avg i(VDD) from=2u to=8u
echo RES iavg=$&iavg
.endc

**** end user architecture code
**.ends

* expanding   symbol:  adc2b.sym # of pins=7
** sym_path: /home/noritsuna/GPS/xschem/adc2b.sym
** sch_path: /home/noritsuna/GPS/xschem/adc2b.sch

* expanding   symbol:  sa_comp.sym # of pins=9
** sym_path: /home/noritsuna/GPS/xschem/sa_comp.sym
** sch_path: /home/noritsuna/GPS/xschem/sa_comp.sch
.subckt sa_comp INP INN REFP REFN CLK Q QB VDD VSS
*.ipin INP
*.ipin INN
*.ipin REFP
*.ipin REFN
*.ipin CLK
*.opin Q
*.opin QB
*.iopin VDD
*.iopin VSS
XMT t CLK VSS VSS nfet_03v3 L=0.28u W=8u nf=2 ad='int((nf+1)/2) * W/nf * 0.18u' as='int((nf+2)/2) * W/nf * 0.18u' pd='2*int((nf+1)/2) * (W/nf + 0.18u)'
+ ps='2*int((nf+2)/2) * (W/nf + 0.18u)' nrd='0.18u / W' nrs='0.18u / W' sa=0 sb=0 sd=0 m=1 par=1
XM1 x1 INP t VSS nfet_03v3 L=0.28u W=4u nf=1 ad='int((nf+1)/2) * W/nf * 0.18u' as='int((nf+2)/2) * W/nf * 0.18u' pd='2*int((nf+1)/2) * (W/nf + 0.18u)'
+ ps='2*int((nf+2)/2) * (W/nf + 0.18u)' nrd='0.18u / W' nrs='0.18u / W' sa=0 sb=0 sd=0 m=1 par=1
XM2 x2 INN t VSS nfet_03v3 L=0.28u W=4u nf=1 ad='int((nf+1)/2) * W/nf * 0.18u' as='int((nf+2)/2) * W/nf * 0.18u' pd='2*int((nf+1)/2) * (W/nf + 0.18u)'
+ ps='2*int((nf+2)/2) * (W/nf + 0.18u)' nrd='0.18u / W' nrs='0.18u / W' sa=0 sb=0 sd=0 m=1 par=1
XM3 x2 REFP t VSS nfet_03v3 L=0.28u W=4u nf=1 ad='int((nf+1)/2) * W/nf * 0.18u' as='int((nf+2)/2) * W/nf * 0.18u' pd='2*int((nf+1)/2) * (W/nf + 0.18u)'
+ ps='2*int((nf+2)/2) * (W/nf + 0.18u)' nrd='0.18u / W' nrs='0.18u / W' sa=0 sb=0 sd=0 m=1 par=1
XM4 x1 REFN t VSS nfet_03v3 L=0.28u W=4u nf=1 ad='int((nf+1)/2) * W/nf * 0.18u' as='int((nf+2)/2) * W/nf * 0.18u' pd='2*int((nf+1)/2) * (W/nf + 0.18u)'
+ ps='2*int((nf+2)/2) * (W/nf + 0.18u)' nrd='0.18u / W' nrs='0.18u / W' sa=0 sb=0 sd=0 m=1 par=1
XM5 on op x1 VSS nfet_03v3 L=0.28u W=2u nf=1 ad='int((nf+1)/2) * W/nf * 0.18u' as='int((nf+2)/2) * W/nf * 0.18u' pd='2*int((nf+1)/2) * (W/nf + 0.18u)'
+ ps='2*int((nf+2)/2) * (W/nf + 0.18u)' nrd='0.18u / W' nrs='0.18u / W' sa=0 sb=0 sd=0 m=1 par=1
XM6 op on x2 VSS nfet_03v3 L=0.28u W=2u nf=1 ad='int((nf+1)/2) * W/nf * 0.18u' as='int((nf+2)/2) * W/nf * 0.18u' pd='2*int((nf+1)/2) * (W/nf + 0.18u)'
+ ps='2*int((nf+2)/2) * (W/nf + 0.18u)' nrd='0.18u / W' nrs='0.18u / W' sa=0 sb=0 sd=0 m=1 par=1
XM7 on op VDD VDD pfet_03v3 L=0.28u W=2u nf=1 ad='int((nf+1)/2) * W/nf * 0.18u' as='int((nf+2)/2) * W/nf * 0.18u' pd='2*int((nf+1)/2) * (W/nf + 0.18u)'
+ ps='2*int((nf+2)/2) * (W/nf + 0.18u)' nrd='0.18u / W' nrs='0.18u / W' sa=0 sb=0 sd=0 m=1 par=1
XM8 op on VDD VDD pfet_03v3 L=0.28u W=2u nf=1 ad='int((nf+1)/2) * W/nf * 0.18u' as='int((nf+2)/2) * W/nf * 0.18u' pd='2*int((nf+1)/2) * (W/nf + 0.18u)'
+ ps='2*int((nf+2)/2) * (W/nf + 0.18u)' nrd='0.18u / W' nrs='0.18u / W' sa=0 sb=0 sd=0 m=1 par=1
XM9 on CLK VDD VDD pfet_03v3 L=0.28u W=1u nf=1 ad='int((nf+1)/2) * W/nf * 0.18u' as='int((nf+2)/2) * W/nf * 0.18u' pd='2*int((nf+1)/2) * (W/nf + 0.18u)'
+ ps='2*int((nf+2)/2) * (W/nf + 0.18u)' nrd='0.18u / W' nrs='0.18u / W' sa=0 sb=0 sd=0 m=1 par=1
XM10 op CLK VDD VDD pfet_03v3 L=0.28u W=1u nf=1 ad='int((nf+1)/2) * W/nf * 0.18u' as='int((nf+2)/2) * W/nf * 0.18u' pd='2*int((nf+1)/2) * (W/nf + 0.18u)'
+ ps='2*int((nf+2)/2) * (W/nf + 0.18u)' nrd='0.18u / W' nrs='0.18u / W' sa=0 sb=0 sd=0 m=1 par=1
XM11 x1 CLK VDD VDD pfet_03v3 L=0.28u W=1u nf=1 ad='int((nf+1)/2) * W/nf * 0.18u' as='int((nf+2)/2) * W/nf * 0.18u' pd='2*int((nf+1)/2) * (W/nf + 0.18u)'
+ ps='2*int((nf+2)/2) * (W/nf + 0.18u)' nrd='0.18u / W' nrs='0.18u / W' sa=0 sb=0 sd=0 m=1 par=1
XM12 x2 CLK VDD VDD pfet_03v3 L=0.28u W=1u nf=1 ad='int((nf+1)/2) * W/nf * 0.18u' as='int((nf+2)/2) * W/nf * 0.18u' pd='2*int((nf+1)/2) * (W/nf + 0.18u)'
+ ps='2*int((nf+2)/2) * (W/nf + 0.18u)' nrd='0.18u / W' nrs='0.18u / W' sa=0 sb=0 sd=0 m=1 par=1
XI1 op opb VDD VSS inv_dig
XI2 on onb VDD VSS inv_dig
XS1 opb QB Q VDD VSS nor2
XS2 onb Q QB VDD VSS nor2
.ends

* expanding   symbol:  nand2.sym # of pins=5
** sym_path: /home/noritsuna/GPS/xschem/nand2.sym
** sch_path: /home/noritsuna/GPS/xschem/nand2.sch
.subckt nand2 A B Y VDD VSS
*.ipin A
*.ipin B
*.opin Y
*.iopin VDD
*.iopin VSS
XMN1 Y A n1 VSS nfet_03v3 L=0.28u W=2u nf=1 ad='int((nf+1)/2) * W/nf * 0.18u' as='int((nf+2)/2) * W/nf * 0.18u' pd='2*int((nf+1)/2) * (W/nf + 0.18u)'
+ ps='2*int((nf+2)/2) * (W/nf + 0.18u)' nrd='0.18u / W' nrs='0.18u / W' sa=0 sb=0 sd=0 m=1 par=1
XMN2 n1 B VSS VSS nfet_03v3 L=0.28u W=2u nf=1 ad='int((nf+1)/2) * W/nf * 0.18u' as='int((nf+2)/2) * W/nf * 0.18u' pd='2*int((nf+1)/2) * (W/nf + 0.18u)'
+ ps='2*int((nf+2)/2) * (W/nf + 0.18u)' nrd='0.18u / W' nrs='0.18u / W' sa=0 sb=0 sd=0 m=1 par=1
XMP1 Y A VDD VDD pfet_03v3 L=0.28u W=2u nf=1 ad='int((nf+1)/2) * W/nf * 0.18u' as='int((nf+2)/2) * W/nf * 0.18u' pd='2*int((nf+1)/2) * (W/nf + 0.18u)'
+ ps='2*int((nf+2)/2) * (W/nf + 0.18u)' nrd='0.18u / W' nrs='0.18u / W' sa=0 sb=0 sd=0 m=1 par=1
XMP2 Y B VDD VDD pfet_03v3 L=0.28u W=2u nf=1 ad='int((nf+1)/2) * W/nf * 0.18u' as='int((nf+2)/2) * W/nf * 0.18u' pd='2*int((nf+1)/2) * (W/nf + 0.18u)'
+ ps='2*int((nf+2)/2) * (W/nf + 0.18u)' nrd='0.18u / W' nrs='0.18u / W' sa=0 sb=0 sd=0 m=1 par=1
.ends

* expanding   symbol:  inv_dig.sym # of pins=4
** sym_path: /home/noritsuna/GPS/xschem/inv_dig.sym
** sch_path: /home/noritsuna/GPS/xschem/inv_dig.sch
.subckt inv_dig A Y VDD VSS
*.ipin A
*.opin Y
*.iopin VDD
*.iopin VSS
XMN Y A VSS VSS nfet_03v3 L=0.28u W=1u nf=1 ad='int((nf+1)/2) * W/nf * 0.18u' as='int((nf+2)/2) * W/nf * 0.18u' pd='2*int((nf+1)/2) * (W/nf + 0.18u)'
+ ps='2*int((nf+2)/2) * (W/nf + 0.18u)' nrd='0.18u / W' nrs='0.18u / W' sa=0 sb=0 sd=0 m=1 par=1
XMP Y A VDD VDD pfet_03v3 L=0.28u W=2u nf=1 ad='int((nf+1)/2) * W/nf * 0.18u' as='int((nf+2)/2) * W/nf * 0.18u' pd='2*int((nf+1)/2) * (W/nf + 0.18u)'
+ ps='2*int((nf+2)/2) * (W/nf + 0.18u)' nrd='0.18u / W' nrs='0.18u / W' sa=0 sb=0 sd=0 m=1 par=1
.ends

* expanding   symbol:  nor2.sym # of pins=5
** sym_path: /home/noritsuna/GPS/xschem/nor2.sym
** sch_path: /home/noritsuna/GPS/xschem/nor2.sch
.subckt nor2 A B Y VDD VSS
*.ipin A
*.ipin B
*.opin Y
*.iopin VDD
*.iopin VSS
XMN1 Y A VSS VSS nfet_03v3 L=0.28u W=1u nf=1 ad='int((nf+1)/2) * W/nf * 0.18u' as='int((nf+2)/2) * W/nf * 0.18u' pd='2*int((nf+1)/2) * (W/nf + 0.18u)'
+ ps='2*int((nf+2)/2) * (W/nf + 0.18u)' nrd='0.18u / W' nrs='0.18u / W' sa=0 sb=0 sd=0 m=1 par=1
XMN2 Y B VSS VSS nfet_03v3 L=0.28u W=1u nf=1 ad='int((nf+1)/2) * W/nf * 0.18u' as='int((nf+2)/2) * W/nf * 0.18u' pd='2*int((nf+1)/2) * (W/nf + 0.18u)'
+ ps='2*int((nf+2)/2) * (W/nf + 0.18u)' nrd='0.18u / W' nrs='0.18u / W' sa=0 sb=0 sd=0 m=1 par=1
XMP1 n1 A VDD VDD pfet_03v3 L=0.28u W=4u nf=1 ad='int((nf+1)/2) * W/nf * 0.18u' as='int((nf+2)/2) * W/nf * 0.18u' pd='2*int((nf+1)/2) * (W/nf + 0.18u)'
+ ps='2*int((nf+2)/2) * (W/nf + 0.18u)' nrd='0.18u / W' nrs='0.18u / W' sa=0 sb=0 sd=0 m=1 par=1
XMP2 Y B n1 VDD pfet_03v3 L=0.28u W=4u nf=1 ad='int((nf+1)/2) * W/nf * 0.18u' as='int((nf+2)/2) * W/nf * 0.18u' pd='2*int((nf+1)/2) * (W/nf + 0.18u)'
+ ps='2*int((nf+2)/2) * (W/nf + 0.18u)' nrd='0.18u / W' nrs='0.18u / W' sa=0 sb=0 sd=0 m=1 par=1
.ends
* NGSPICE file created from adc2b_flat.ext - technology: gf180mcuD

.subckt adc2b_flat VSS VDD INP INN CLK SIGN MAG
X0 a_7285_33240# a_3807_33969# VDD VDD pfet_03v3 ad=1.78p pd=8.89u as=1.78p ps=8.89u w=4u l=0.28u
X1 a_24667_33969# a_27445_29040# VSS VSS nfet_03v3 ad=0.445p pd=2.89u as=0.445p ps=2.89u w=1u l=0.28u
X2 a_42285_33582# a_43847_33969# VSS VSS nfet_03v3 ad=0.445p pd=2.89u as=0.445p ps=2.89u w=1u l=0.28u
X3 a_22987_33969# a_22987_29769# VDD VDD pfet_03v3 ad=0.89p pd=4.89u as=0.89p ps=4.89u w=2u l=0.28u
X4 a_3925_16300# a_3807_17169# a_3780_16300# VSS nfet_03v3 ad=1.78p pd=8.89u as=1.78p ps=8.89u w=4u l=0.28u
X5 a_49840_33240# a_46625_29040# VDD VDD pfet_03v3 ad=1.78p pd=8.89u as=1.78p ps=8.89u w=4u l=0.28u
X6 a_43847_21229# a_42167_29769# a_46480_20640# VSS nfet_03v3 ad=0.89p pd=4.89u as=0.89p ps=4.89u w=2u l=0.28u
X7 VSS CLK.t4 a_3780_16300# VSS nfet_03v3 ad=1.78p pd=8.89u as=1.06p ps=4.53u w=4u l=0.28u
X8 a_3925_33582# a_3807_33969# VSS VSS nfet_03v3 ad=0.445p pd=2.89u as=0.445p ps=2.89u w=1u l=0.28u
X9 a_27445_29040# a_24667_21229# VSS VSS nfet_03v3 ad=0.445p pd=2.89u as=0.445p ps=2.89u w=1u l=0.28u
X10 a_3807_29769# CLK.t4 VDD VDD pfet_03v3 ad=0.445p pd=2.89u as=0.445p ps=2.89u w=1u l=0.28u
X11 a_8120_20640# INN a_3780_16300# VSS nfet_03v3 ad=1.78p pd=8.89u as=1.78p ps=8.89u w=4u l=0.28u
X12 VDD a_41280_1364# VSS ppolyf_u_1k r_width=10u r_length=8.02u
X13 a_8120_20640# a_3807_17169# a_3780_16300# VSS nfet_03v3 ad=1.78p pd=8.89u as=1.78p ps=8.89u w=4u l=0.28u
X14 MAG a_43847_33969# VDD VDD pfet_03v3 ad=0.89p pd=4.89u as=0.89p ps=4.89u w=2u l=0.28u
X15 a_5487_21229# a_3807_29769# a_8120_20640# VSS nfet_03v3 ad=0.89p pd=4.89u as=0.89p ps=4.89u w=2u l=0.28u
X16 a_42285_16300# a_29847_17169# a_42140_16300# VSS nfet_03v3 ad=1.78p pd=8.89u as=1.78p ps=8.89u w=4u l=0.28u
X17 a_8120_20640# CLK.t4 VDD VDD pfet_03v3 ad=0.445p pd=2.89u as=0.445p ps=2.89u w=1u l=0.28u
X18 a_39040_3090# a_36800_1364# VSS ppolyf_u_1k r_width=10u r_length=8.02u
X19 a_39040_3090# a_41280_1364# VSS ppolyf_u_1k r_width=10u r_length=8.02u
X20 a_42285_33582# a_42167_33969# VSS VSS nfet_03v3 ad=0.445p pd=2.89u as=0.445p ps=2.89u w=1u l=0.28u
X21 a_42167_29769# CLK.t10 VDD VDD pfet_03v3 ad=0.445p pd=2.89u as=0.445p ps=2.89u w=1u l=0.28u
X22 a_23105_16300# CLK.t8 VDD VDD pfet_03v3 ad=0.445p pd=2.89u as=0.445p ps=2.89u w=1u l=0.28u
X23 a_42167_29769# a_43847_21229# a_42285_16300# VSS nfet_03v3 ad=0.89p pd=4.89u as=0.89p ps=4.89u w=2u l=0.28u
X24 a_29847_17169# a_3807_17169# VSS ppolyf_u_1k r_width=10u r_length=1.4u
X25 a_3807_29769# a_5487_21229# VDD VDD pfet_03v3 ad=0.89p pd=4.89u as=0.89p ps=4.89u w=2u l=0.28u
X26 a_23105_16300# INP a_22960_16300# VSS nfet_03v3 ad=1.78p pd=8.89u as=1.78p ps=8.89u w=4u l=0.28u
X27 VSS CLK.t0 a_42140_16300# VSS nfet_03v3 ad=1.78p pd=8.89u as=1.06p ps=4.53u w=4u l=0.28u
X28 MAG a_23105_33582# VDD VDD pfet_03v3 ad=0.89p pd=4.89u as=0.89p ps=4.89u w=2u l=0.28u
X29 a_23105_33582# a_24667_33969# VSS VSS nfet_03v3 ad=0.445p pd=2.89u as=0.445p ps=2.89u w=1u l=0.28u
X30 a_3807_33969# a_3807_29769# VSS VSS nfet_03v3 ad=0.445p pd=2.89u as=0.445p ps=2.89u w=1u l=0.28u
X31 a_43847_21229# a_42167_29769# VDD VDD pfet_03v3 ad=0.89p pd=4.89u as=0.89p ps=4.89u w=2u l=0.28u
X32 a_24667_21229# a_22987_29769# a_27300_20640# VSS nfet_03v3 ad=0.89p pd=4.89u as=0.89p ps=4.89u w=2u l=0.28u
X33 a_46480_20640# CLK.t5 VDD VDD pfet_03v3 ad=0.445p pd=2.89u as=0.445p ps=2.89u w=1u l=0.28u
X34 a_29847_17169# VSS cap_mim_2f0_m4m5_noshield c_width=50u c_length=50u
X35 a_30660_33240# a_27445_29040# VDD VDD pfet_03v3 ad=1.78p pd=8.89u as=1.78p ps=8.89u w=4u l=0.28u
X36 a_42140_16300# CLK.t1 VSS VSS nfet_03v3 ad=1.06p pd=4.53u as=1.78p ps=8.89u w=4u l=0.28u
X37 a_46480_20640# INN a_42140_16300# VSS nfet_03v3 ad=1.78p pd=8.89u as=1.78p ps=8.89u w=4u l=0.28u
X38 a_23105_16300# a_22987_17169# a_22960_16300# VSS nfet_03v3 ad=1.78p pd=8.89u as=1.78p ps=8.89u w=4u l=0.28u
X39 MAG a_23105_33582# a_58800_15180# VSS nfet_03v3 ad=0.89p pd=4.89u as=0.89p ps=4.89u w=2u l=0.28u
X40 a_42167_33969# a_42167_29769# VSS VSS nfet_03v3 ad=0.445p pd=2.89u as=0.445p ps=2.89u w=1u l=0.28u
X41 a_5487_21229# a_3807_29769# VDD VDD pfet_03v3 ad=0.89p pd=4.89u as=0.89p ps=4.89u w=2u l=0.28u
X42 a_3780_16300# CLK.t4 VSS VSS nfet_03v3 ad=1.06p pd=4.53u as=1.78p ps=8.89u w=4u l=0.28u
X43 a_27300_20640# a_29847_17169# a_22960_16300# VSS nfet_03v3 ad=1.78p pd=8.89u as=1.78p ps=8.89u w=4u l=0.28u
X44 a_3807_17169# a_22987_17169# VSS ppolyf_u_1k r_width=10u r_length=1.4u
X45 a_23105_33582# a_22987_33969# VSS VSS nfet_03v3 ad=0.445p pd=2.89u as=0.445p ps=2.89u w=1u l=0.28u
X46 a_42167_29769# a_43847_21229# VDD VDD pfet_03v3 ad=0.89p pd=4.89u as=0.89p ps=4.89u w=2u l=0.28u
X47 a_22987_29769# a_24667_21229# a_23105_16300# VSS nfet_03v3 ad=0.89p pd=4.89u as=0.89p ps=4.89u w=2u l=0.28u
X48 a_50240_2973# VSS VSS ppolyf_u_1k r_width=10u r_length=7.435u
X49 a_22987_17169# a_52480_1364# VSS ppolyf_u_1k r_width=10u r_length=7.435u
X50 a_5487_21229# CLK.t4 VDD VDD pfet_03v3 ad=0.445p pd=2.89u as=0.445p ps=2.89u w=1u l=0.28u
X51 a_22987_29769# CLK.t12 VDD VDD pfet_03v3 ad=0.445p pd=2.89u as=0.445p ps=2.89u w=1u l=0.28u
X52 a_26465_33240# a_22987_33969# VDD VDD pfet_03v3 ad=1.78p pd=8.89u as=1.78p ps=8.89u w=4u l=0.28u
X53 a_24667_33969# a_23105_33582# VSS VSS nfet_03v3 ad=0.445p pd=2.89u as=0.445p ps=2.89u w=1u l=0.28u
X54 a_3807_33969# a_3807_29769# VDD VDD pfet_03v3 ad=0.89p pd=4.89u as=0.89p ps=4.89u w=2u l=0.28u
X55 VSS CLK.t2 a_22960_16300# VSS nfet_03v3 ad=1.78p pd=8.89u as=1.06p ps=4.53u w=4u l=0.28u
X56 a_58800_15180# a_43847_33969# VSS VSS nfet_03v3 ad=0.89p pd=4.89u as=0.89p ps=4.89u w=2u l=0.28u
X57 a_11480_33240# a_8265_29040# VDD VDD pfet_03v3 ad=1.78p pd=8.89u as=1.78p ps=8.89u w=4u l=0.28u
X58 a_46625_29040# a_43847_21229# VDD VDD pfet_03v3 ad=0.89p pd=4.89u as=0.89p ps=4.89u w=2u l=0.28u
X59 a_24667_21229# a_22987_29769# VDD VDD pfet_03v3 ad=0.89p pd=4.89u as=0.89p ps=4.89u w=2u l=0.28u
X60 a_43847_21229# CLK.t9 VDD VDD pfet_03v3 ad=0.445p pd=2.89u as=0.445p ps=2.89u w=1u l=0.28u
X61 a_27300_20640# CLK.t7 VDD VDD pfet_03v3 ad=0.445p pd=2.89u as=0.445p ps=2.89u w=1u l=0.28u
X62 a_27300_20640# INN a_22960_16300# VSS nfet_03v3 ad=1.78p pd=8.89u as=1.78p ps=8.89u w=4u l=0.28u
X63 a_50240_2973# a_52480_1364# VSS ppolyf_u_1k r_width=10u r_length=7.435u
X64 SIGN a_8265_29040# VSS VSS nfet_03v3 ad=0.445p pd=2.89u as=0.445p ps=2.89u w=1u l=0.28u
X65 a_24667_33969# a_23105_33582# a_30660_33240# VDD pfet_03v3 ad=1.78p pd=8.89u as=1.78p ps=8.89u w=4u l=0.28u
X66 a_42285_33582# a_43847_33969# a_45645_33240# VDD pfet_03v3 ad=1.78p pd=8.89u as=1.78p ps=8.89u w=4u l=0.28u
X67 a_8265_29040# a_5487_21229# VSS VSS nfet_03v3 ad=0.445p pd=2.89u as=0.445p ps=2.89u w=1u l=0.28u
X68 a_34560_3090# a_36800_1364# VSS ppolyf_u_1k r_width=10u r_length=8.02u
X69 a_8265_29040# a_5487_21229# VDD VDD pfet_03v3 ad=0.89p pd=4.89u as=0.89p ps=4.89u w=2u l=0.28u
X70 a_22987_33969# a_22987_29769# VSS VSS nfet_03v3 ad=0.445p pd=2.89u as=0.445p ps=2.89u w=1u l=0.28u
X71 a_46480_20640# a_22987_17169# a_42140_16300# VSS nfet_03v3 ad=1.78p pd=8.89u as=1.78p ps=8.89u w=4u l=0.28u
X72 a_22987_29769# a_24667_21229# VDD VDD pfet_03v3 ad=0.89p pd=4.89u as=0.89p ps=4.89u w=2u l=0.28u
X73 a_3925_16300# INP a_3780_16300# VSS nfet_03v3 ad=1.78p pd=8.89u as=1.78p ps=8.89u w=4u l=0.28u
X74 a_43847_33969# a_46625_29040# VSS VSS nfet_03v3 ad=0.445p pd=2.89u as=0.445p ps=2.89u w=1u l=0.28u
X75 a_42167_33969# a_42167_29769# VDD VDD pfet_03v3 ad=0.89p pd=4.89u as=0.89p ps=4.89u w=2u l=0.28u
X76 a_3807_17169# VSS cap_mim_2f0_m4m5_noshield c_width=50u c_length=50u
X77 a_3925_33582# SIGN VSS VSS nfet_03v3 ad=0.445p pd=2.89u as=0.445p ps=2.89u w=1u l=0.28u
X78 a_46625_29040# a_43847_21229# VSS VSS nfet_03v3 ad=0.445p pd=2.89u as=0.445p ps=2.89u w=1u l=0.28u
X79 a_3925_16300# CLK.t4 VDD VDD pfet_03v3 ad=0.445p pd=2.89u as=0.445p ps=2.89u w=1u l=0.28u
X80 a_34560_3090# a_29847_17169# VSS ppolyf_u_1k r_width=10u r_length=8.02u
X81 a_3925_33582# SIGN a_7285_33240# VDD pfet_03v3 ad=1.78p pd=8.89u as=1.78p ps=8.89u w=4u l=0.28u
X82 a_22987_17169# VSS cap_mim_2f0_m4m5_noshield c_width=50u c_length=50u
X83 SIGN a_3925_33582# a_11480_33240# VDD pfet_03v3 ad=1.78p pd=8.89u as=1.78p ps=8.89u w=4u l=0.28u
X84 a_27445_29040# a_24667_21229# VDD VDD pfet_03v3 ad=0.89p pd=4.89u as=0.89p ps=4.89u w=2u l=0.28u
X85 a_24667_21229# CLK.t11 VDD VDD pfet_03v3 ad=0.445p pd=2.89u as=0.445p ps=2.89u w=1u l=0.28u
X86 a_23105_33582# a_24667_33969# a_26465_33240# VDD pfet_03v3 ad=1.78p pd=8.89u as=1.78p ps=8.89u w=4u l=0.28u
X87 a_45645_33240# a_42167_33969# VDD VDD pfet_03v3 ad=1.78p pd=8.89u as=1.78p ps=8.89u w=4u l=0.28u
X88 SIGN a_3925_33582# VSS VSS nfet_03v3 ad=0.445p pd=2.89u as=0.445p ps=2.89u w=1u l=0.28u
X89 a_43847_33969# a_42285_33582# a_49840_33240# VDD pfet_03v3 ad=1.78p pd=8.89u as=1.78p ps=8.89u w=4u l=0.28u
X90 a_43847_33969# a_42285_33582# VSS VSS nfet_03v3 ad=0.445p pd=2.89u as=0.445p ps=2.89u w=1u l=0.28u
X91 a_42285_16300# CLK.t6 VDD VDD pfet_03v3 ad=0.445p pd=2.89u as=0.445p ps=2.89u w=1u l=0.28u
X92 a_22960_16300# CLK.t3 VSS VSS nfet_03v3 ad=1.06p pd=4.53u as=1.78p ps=8.89u w=4u l=0.28u
X93 a_3807_29769# a_5487_21229# a_3925_16300# VSS nfet_03v3 ad=0.89p pd=4.89u as=0.89p ps=4.89u w=2u l=0.28u
X94 a_42285_16300# INP a_42140_16300# VSS nfet_03v3 ad=1.78p pd=8.89u as=1.78p ps=8.89u w=4u l=0.28u
C0 a_5754_20580# a_3807_29769# 0.02871f
C1 a_43847_21229# a_46774_24780# 0.02223f
C2 a_42140_16300# a_42024_16240# 0.04076f
C3 a_11480_33240# SIGN 0.38275f
C4 a_23254_25122# VDD 0.21462f
C5 a_30544_33180# VDD 0.58317f
C6 a_8120_20640# a_10094_20922# 0.01149f
C7 a_3807_33969# a_5754_28980# 0.01988f
C8 a_42140_16300# INN 0.05829f
C9 a_23105_16300# a_24934_16240# 0.04066f
C10 INN a_23105_16300# 0.17994f
C11 a_4074_16240# a_3925_16300# 0.05124f
C12 a_42167_29769# a_44114_20580# 0.02871f
C13 a_42140_16300# CLK 0.13796f
C14 a_23105_16300# CLK 0.0187f
C15 a_7596_16240# a_3780_16300# 0.01072f
C16 INP a_42140_16300# 0.06179f
C17 INP a_23105_16300# 0.3073f
C18 a_11480_33240# VDD 0.94704f
C19 a_42285_16300# a_42434_20922# 0.01511f
C20 a_50134_33180# a_49724_33180# 0.0129f
C21 a_26465_33240# a_26614_33180# 0.04654f
C22 a_47064_33180# VDD 0.58253f
C23 a_46625_29040# a_43847_21229# 0.14279f
C24 a_11364_33180# SIGN 0.02214f
C25 a_3807_17169# a_41280_1364# 0.01008f
C26 a_23105_16300# VDD 0.67904f
C27 a_26776_16240# a_22960_16300# 0.01072f
C28 a_10524_16240# a_10934_16240# 0.0129f
C29 a_46480_20640# INN 0.11209f
C30 a_46480_20640# CLK 0.08625f
C31 a_5487_21229# a_8414_24780# 0.02223f
C32 a_11364_33180# VDD 0.58317f
C33 a_46480_20640# VDD 0.72081f
C34 a_24524_16240# a_22960_16300# 0.04956f
C35 a_23254_33522# a_23105_33582# 0.01511f
C36 a_3925_33582# a_8265_29040# 0.38327f
C37 a_7434_33180# VDD 0.60019f
C38 a_29847_17169# a_23105_33582# 0.18686f
C39 a_9684_20922# VDD 0.22418f
C40 a_34314_33522# a_24667_33969# 0.01296f
C41 a_45645_33240# a_43847_33969# 0.20754f
C42 a_29847_17169# a_22987_29769# 0.45854f
C43 a_46480_20640# a_48454_20922# 0.01149f
C44 a_46364_24780# VDD 0.36279f
C45 a_3780_16300# a_8120_20640# 0.58568f
C46 a_22987_33969# a_23105_33582# 0.19076f
C47 a_30660_33240# a_23105_33582# 0.16289f
C48 a_22987_33969# a_22987_29769# 0.11878f
C49 MAG a_23105_33582# 0.28356f
C50 a_47474_33180# a_47064_33180# 0.0129f
C51 INN a_23105_33582# 0.11119f
C52 a_23105_33582# CLK 0.03857f
C53 INN a_22987_29769# 0.53016f
C54 INP a_23105_33582# 0.05553f
C55 a_22987_29769# CLK 0.16378f
C56 a_43847_33969# a_53494_33522# 0.01296f
C57 a_24934_33522# a_23105_33582# 0.01595f
C58 a_8265_29040# a_5487_21229# 0.14279f
C59 a_42285_16300# a_43704_16240# 0.01552f
C60 a_46774_28980# VDD 0.3476f
C61 a_49840_33240# a_42285_33582# 0.16289f
C62 a_23105_33582# VDD 2.50026f
C63 a_3807_17169# a_3925_16300# 0.06928f
C64 a_10094_25122# a_5487_21229# 0.01149f
C65 a_22987_29769# VDD 2.99884f
C66 a_46480_20640# a_43847_21229# 0.20813f
C67 a_23254_20922# a_23105_16300# 0.01386f
C68 a_43847_21229# a_46364_24780# 0.0136f
C69 a_51814_33180# VDD 0.60275f
C70 a_27594_24780# VDD 0.35048f
C71 a_42285_16300# a_44114_16240# 0.04066f
C72 a_32224_33180# a_30660_33240# 0.01509f
C73 a_27445_29040# a_30660_33240# 0.06318f
C74 a_42167_33969# a_42434_29322# 0.01732f
C75 a_3807_17169# a_3807_29769# 0.41482f
C76 a_10934_16240# a_8120_20640# 0.04066f
C77 a_29704_16240# a_27300_20640# 0.01552f
C78 a_8414_28980# VDD 0.3476f
C79 a_22987_29769# a_27300_20640# 0.02617f
C80 a_30544_33180# a_24667_33969# 0.02214f
C81 a_27445_29040# CLK 0.04361f
C82 a_28294_33180# VDD 0.58394f
C83 a_43847_33969# MAG 0.06541f
C84 a_32224_33180# VDD 0.63223f
C85 a_3807_17169# a_5487_21229# 0.75417f
C86 a_27445_29040# VDD 1.32076f
C87 a_48884_16240# a_42140_16300# 0.04917f
C88 a_3925_33582# a_11480_33240# 0.16289f
C89 a_47614_16240# a_42140_16300# 0.01037f
C90 a_42140_16300# a_47204_16240# 0.05544f
C91 a_49840_33240# a_49724_33180# 0.04076f
C92 a_8704_33180# SIGN 0.01306f
C93 a_45645_33240# VDD 0.88551f
C94 a_43847_33969# VDD 2.38686f
C95 a_48454_25122# VDD 0.21693f
C96 a_30114_16240# a_27300_20640# 0.04066f
C97 a_26465_33240# a_23105_33582# 0.37231f
C98 a_42140_16300# a_45384_16240# 0.0178f
C99 a_45956_16240# a_42140_16300# 0.01072f
C100 a_27184_20580# a_27300_20640# 0.01998f
C101 a_46480_20640# a_48884_16240# 0.01552f
C102 a_46480_20640# a_49294_16240# 0.04066f
C103 a_8704_33180# VDD 0.58253f
C104 a_3925_33582# a_11364_33180# 0.01581f
C105 a_42434_16240# a_42140_16300# 0.01483f
C106 a_46480_20640# a_47614_16240# 0.05266f
C107 a_26204_16240# a_22960_16300# 0.0178f
C108 a_46625_29040# a_42285_33582# 0.38327f
C109 a_46625_29040# a_48454_29322# 0.0139f
C110 a_48044_20922# VDD 0.22431f
C111 a_8844_16240# a_3780_16300# 0.05544f
C112 a_22844_16240# a_22960_16300# 0.04076f
C113 a_58800_15180# a_23105_33582# 0.03463f
C114 a_46774_20580# a_43847_21229# 0.01993f
C115 a_29847_17169# INN 0.22379f
C116 a_22987_17169# a_42167_29769# 0.41482f
C117 a_29847_17169# CLK 0.16885f
C118 a_50134_33180# a_49840_33240# 0.01648f
C119 a_29847_17169# INP 0.23221f
C120 a_47474_33180# a_43847_33969# 0.01283f
C121 a_29847_17169# SIGN 0.08637f
C122 a_43847_21229# a_48454_25122# 0.01149f
C123 a_49840_33240# a_51404_33180# 0.01509f
C124 a_27445_29040# a_27594_28980# 0.02481f
C125 a_24667_33969# a_23105_33582# 0.69522f
C126 a_22987_33969# CLK 0.07709f
C127 a_24667_21229# a_23105_16300# 0.02337f
C128 a_42285_16300# a_42167_29769# 0.10361f
C129 a_45384_33180# VDD 0.63479f
C130 a_28434_16240# a_27300_20640# 0.05266f
C131 a_42024_20922# VDD 0.22745f
C132 a_44114_16240# a_43704_16240# 0.0129f
C133 a_29847_17169# VDD 4.15518f
C134 a_28024_16240# a_22960_16300# 0.05544f
C135 a_27184_24780# VDD 0.36279f
C136 a_26204_33180# VDD 0.63479f
C137 INN CLK 4.92168f
C138 a_47064_33180# a_42285_33582# 0.01772f
C139 INP INN 0.07874f
C140 INN SIGN 0.15483f
C141 INP CLK 0.18052f
C142 a_22987_33969# VDD 1.21426f
C143 SIGN CLK 0.04361f
C144 INP SIGN 0.059f
C145 a_30660_33240# VDD 0.94704f
C146 MAG VDD 1.18186f
C147 INN VDD 2.17441f
C148 CLK VDD 14.3163f
C149 a_23254_16240# a_22960_16300# 0.01483f
C150 INP VDD 2.96245f
C151 a_22987_17169# a_3807_17169# 5.21144f
C152 a_3807_17169# a_8120_20640# 0.56211f
C153 SIGN VDD 4.60965f
C154 a_13454_33180# a_13044_33180# 0.0129f
C155 a_9114_33180# a_8704_33180# 0.0129f
C156 a_29847_17169# a_27300_20640# 0.56211f
C157 a_43704_24780# VDD 0.36665f
C158 a_42167_29769# a_44114_24780# 0.02853f
C159 a_46480_20640# a_46364_20580# 0.01998f
C160 a_28294_33180# a_24667_33969# 0.01283f
C161 a_3780_16300# a_4074_16240# 0.01483f
C162 a_27445_29040# a_24667_33969# 0.10869f
C163 a_42024_25122# VDD 0.22745f
C164 a_48454_20922# VDD 0.21693f
C165 INN a_27300_20640# 0.28139f
C166 a_58800_15180# a_43847_33969# 0.05288f
C167 a_42167_33969# a_42167_29769# 0.11878f
C168 a_23105_16300# a_22960_16300# 0.66682f
C169 a_27300_20640# CLK 0.08117f
C170 INP a_27300_20640# 0.0412f
C171 a_24524_24780# VDD 0.36665f
C172 a_36800_1364# a_29847_17169# 0.0156f
C173 a_24667_21229# a_22987_29769# 0.62414f
C174 a_27300_20640# VDD 0.70883f
C175 a_7434_33180# a_7285_33240# 0.04654f
C176 INN a_43847_21229# 0.19161f
C177 a_29847_17169# a_34560_3090# 0.01715f
C178 a_43847_21229# CLK 0.12136f
C179 a_22987_17169# a_42140_16300# 0.05974f
C180 a_22987_17169# a_23105_16300# 0.06928f
C181 a_42167_33969# a_44114_28980# 0.01988f
C182 a_45645_33240# a_45794_33180# 0.04654f
C183 a_24667_21229# a_27594_24780# 0.02223f
C184 a_3925_33582# a_8704_33180# 0.01772f
C185 a_26465_33240# a_22987_33969# 0.05138f
C186 a_42285_16300# a_42140_16300# 0.66682f
C187 a_8004_24780# VDD 0.36279f
C188 a_24934_28980# a_22987_29769# 0.01094f
C189 a_64134_15120# MAG 0.0228f
C190 a_47474_33180# VDD 0.58394f
C191 a_43847_21229# VDD 3.11155f
C192 a_42167_29769# a_42434_25122# 0.01511f
C193 a_63724_15120# MAG 0.01113f
C194 a_62454_15120# MAG 0.0228f
C195 a_39040_3090# VDD 0.01044f
C196 a_22987_17169# a_46480_20640# 0.56518f
C197 a_62044_15120# MAG 0.01113f
C198 a_5344_24780# VDD 0.36665f
C199 a_11774_33180# a_11480_33240# 0.01648f
C200 a_24667_21229# a_27184_20580# 0.0137f
C201 a_9114_33180# SIGN 0.01283f
C202 a_3925_33582# a_4074_33522# 0.01511f
C203 a_27594_28980# VDD 0.3476f
C204 a_27445_29040# a_24667_21229# 0.14279f
C205 a_64134_15120# VDD 0.35048f
C206 a_26465_33240# VDD 0.88551f
C207 a_63724_15120# VDD 0.36293f
C208 a_62454_15120# VDD 0.35048f
C209 a_62044_15120# VDD 0.36279f
C210 a_9114_33180# VDD 0.58394f
C211 a_23254_20922# VDD 0.21366f
C212 a_5487_21229# a_8414_20580# 0.01993f
C213 a_29704_16240# a_22960_16300# 0.04917f
C214 a_3780_16300# a_3807_17169# 0.12103f
C215 a_11364_33180# a_11774_33180# 0.0129f
C216 a_29847_17169# a_24667_33969# 0.04359f
C217 a_5344_16240# a_5754_16240# 0.0129f
C218 MAG a_59094_15120# 0.02496f
C219 a_58800_15180# MAG 0.39581f
C220 a_22987_33969# a_24667_33969# 0.11516f
C221 a_4074_25122# VDD 0.21462f
C222 a_24667_33969# a_30660_33240# 0.38275f
C223 INN a_3925_16300# 0.17994f
C224 a_45384_33180# a_45794_33180# 0.0129f
C225 a_3925_16300# CLK 0.0187f
C226 INP a_3925_16300# 0.3073f
C227 a_22987_17169# a_23105_33582# 1.08098f
C228 a_45645_33240# a_42285_33582# 0.37231f
C229 a_22987_17169# a_22987_29769# 0.04644f
C230 INN a_24667_33969# 0.01409f
C231 a_42285_33582# a_43847_33969# 0.69483f
C232 a_24667_33969# CLK 0.04361f
C233 a_3925_16300# VDD 0.67904f
C234 a_3925_33582# CLK 0.03853f
C235 a_13044_33180# a_11480_33240# 0.01509f
C236 a_42434_16240# a_42024_16240# 0.0129f
C237 a_3925_33582# SIGN 0.69483f
C238 a_5754_16240# a_3925_16300# 0.04066f
C239 a_24667_33969# VDD 1.58447f
C240 INN a_3807_29769# 0.53016f
C241 a_3807_29769# CLK 0.16378f
C242 a_3925_33582# VDD 1.67089f
C243 a_27184_28980# VDD 0.36665f
C244 a_45794_33180# VDD 0.60019f
C245 a_3807_29769# VDD 2.99884f
C246 a_7285_33240# a_8704_33180# 0.04961f
C247 a_27445_29040# a_29274_29322# 0.0139f
C248 INN a_5487_21229# 0.65417f
C249 a_24524_16240# a_23105_16300# 0.01552f
C250 a_5487_21229# CLK 0.12136f
C251 a_42140_16300# a_43704_16240# 0.04956f
C252 a_27445_29040# a_22987_17169# 0.03191f
C253 a_29847_17169# a_24667_21229# 0.79341f
C254 a_24667_21229# a_27184_24780# 0.0136f
C255 a_24934_24780# a_22987_29769# 0.02853f
C256 a_5487_21229# VDD 3.11155f
C257 a_43847_33969# a_49724_33180# 0.02214f
C258 a_27594_20580# a_27300_20640# 0.01311f
C259 INN a_24667_21229# 0.65417f
C260 a_24667_21229# CLK 0.12136f
C261 a_28434_16240# a_22960_16300# 0.01037f
C262 a_42140_16300# a_44114_16240# 0.01384f
C263 a_46625_29040# a_49840_33240# 0.06318f
C264 a_30954_33180# a_30544_33180# 0.0129f
C265 a_16814_33522# SIGN 0.01296f
C266 a_51814_33180# a_51404_33180# 0.0129f
C267 a_29274_25122# VDD 0.21693f
C268 a_22987_33969# a_24934_28980# 0.01988f
C269 a_9684_25122# VDD 0.22431f
C270 a_8120_20640# a_8414_20580# 0.01311f
C271 a_24667_21229# VDD 3.10706f
C272 a_48044_25122# VDD 0.22431f
C273 a_26465_33240# a_24667_33969# 0.20754f
C274 a_5344_16240# a_3925_16300# 0.01552f
C275 a_42285_33582# VDD 1.67089f
C276 a_60774_15120# a_58800_15180# 0.01988f
C277 a_8265_29040# a_10094_29322# 0.0139f
C278 a_29847_17169# a_22960_16300# 0.05974f
C279 a_22987_29769# a_24934_20580# 0.02871f
C280 a_8004_24780# a_5487_21229# 0.0136f
C281 a_13454_33180# a_11480_33240# 0.04066f
C282 a_24934_28980# VDD 0.34967f
C283 a_42167_29769# a_44114_28980# 0.01094f
C284 a_9114_33180# a_3925_33582# 0.04484f
C285 a_24667_21229# a_27300_20640# 0.20813f
C286 a_50134_33180# a_43847_33969# 0.04353f
C287 a_28864_20922# VDD 0.22418f
C288 a_7285_33240# SIGN 0.20754f
C289 a_3664_16240# a_3780_16300# 0.04076f
C290 a_58800_15180# a_58684_15120# 0.01998f
C291 a_24934_16240# a_22960_16300# 0.01384f
C292 INN a_22960_16300# 0.05829f
C293 a_3780_16300# a_7024_16240# 0.0178f
C294 CLK a_22960_16300# 0.13796f
C295 INP a_22960_16300# 0.06179f
C296 a_22987_17169# a_29847_17169# 0.40218f
C297 a_45645_33240# a_42167_33969# 0.05138f
C298 a_7285_33240# VDD 0.88551f
C299 a_42167_33969# a_43847_33969# 0.11516f
C300 a_48884_16240# a_49294_16240# 0.0129f
C301 a_3807_29769# a_4074_25122# 0.01511f
C302 a_22987_17169# a_22987_33969# 0.03237f
C303 a_29847_17169# a_42285_16300# 0.06928f
C304 a_22987_17169# INN 0.26387f
C305 a_35994_33522# a_24667_33969# 0.01296f
C306 a_8265_29040# a_11480_33240# 0.06318f
C307 INN a_8120_20640# 0.28139f
C308 a_27884_33180# a_23105_33582# 0.01772f
C309 a_47614_16240# a_47204_16240# 0.0129f
C310 a_22987_17169# CLK 0.18523f
C311 a_8120_20640# CLK 0.08117f
C312 a_47474_33180# a_42285_33582# 0.04484f
C313 a_22987_17169# INP 0.29792f
C314 INP a_8120_20640# 0.0412f
C315 a_22987_17169# SIGN 2.0632f
C316 a_3807_29769# a_3925_16300# 0.10361f
C317 a_46364_20580# a_43847_21229# 0.01371f
C318 a_42285_16300# INN 0.01807f
C319 a_22844_16240# a_23254_16240# 0.0129f
C320 a_42285_16300# CLK 0.02299f
C321 INP a_42285_16300# 0.27323f
C322 a_30954_33180# a_23105_33582# 0.01288f
C323 a_49724_33180# VDD 0.58317f
C324 a_5754_24780# VDD 0.3476f
C325 a_22987_17169# VDD 2.83651f
C326 a_8120_20640# VDD 0.70883f
C327 a_5754_28980# VDD 0.34967f
C328 a_32634_33180# a_32224_33180# 0.0129f
C329 a_27300_20640# a_22960_16300# 0.58568f
C330 a_42285_16300# VDD 0.68858f
C331 a_5487_21229# a_3925_16300# 0.02337f
C332 a_9254_16240# a_8120_20640# 0.05266f
C333 a_24524_28980# VDD 0.36377f
C334 a_23105_16300# a_24524_20580# 0.02887f
C335 a_42285_33582# a_44114_33522# 0.01595f
C336 a_3807_33969# CLK 0.07709f
C337 a_11774_33180# SIGN 0.04353f
C338 a_28294_33180# a_27884_33180# 0.0129f
C339 a_3807_33969# SIGN 0.11516f
C340 a_46480_20640# a_42167_29769# 0.02886f
C341 a_22987_17169# a_50240_2973# 0.11614f
C342 a_11774_33180# VDD 0.58329f
C343 a_3807_29769# a_5487_21229# 0.62414f
C344 a_42434_20922# VDD 0.21379f
C345 a_10094_20922# VDD 0.21617f
C346 a_3807_33969# VDD 1.21426f
C347 a_51814_33180# a_49840_33240# 0.04066f
C348 a_44114_24780# VDD 0.3476f
C349 a_22987_17169# a_43847_21229# 0.75417f
C350 a_22987_33969# a_23254_29322# 0.01732f
C351 a_50134_33180# VDD 0.58329f
C352 a_42167_33969# CLK 0.03709f
C353 a_24934_24780# VDD 0.3476f
C354 a_51404_33180# VDD 0.63223f
C355 a_3664_16240# a_4074_16240# 0.0129f
C356 a_24667_21229# a_27594_20580# 0.01993f
C357 a_8004_28980# VDD 0.36665f
C358 a_42285_16300# a_43847_21229# 0.02512f
C359 a_5344_20580# a_3925_16300# 0.02887f
C360 a_42167_33969# VDD 1.21426f
C361 a_23105_16300# a_23254_16240# 0.05124f
C362 a_3780_16300# INN 0.05829f
C363 a_7434_33180# a_7024_33180# 0.0129f
C364 a_3780_16300# CLK 0.13796f
C365 a_3780_16300# INP 0.06179f
C366 a_22844_25122# VDD 0.22745f
C367 a_24524_16240# a_24934_16240# 0.0129f
C368 a_49840_33240# a_43847_33969# 0.38275f
C369 a_8265_29040# a_8414_28980# 0.02481f
C370 a_13044_33180# VDD 0.63223f
C371 a_11364_33180# a_11480_33240# 0.04076f
C372 a_3925_33582# a_7285_33240# 0.37231f
C373 a_32634_33180# a_30660_33240# 0.04066f
C374 a_24667_21229# a_29274_25122# 0.01149f
C375 a_5344_28980# VDD 0.36377f
C376 a_3780_16300# a_5754_16240# 0.01384f
C377 a_42434_25122# VDD 0.21462f
C378 a_46625_29040# a_46774_28980# 0.02481f
C379 a_3780_16300# a_9254_16240# 0.01037f
C380 a_42285_33582# a_42434_33522# 0.01511f
C381 a_46480_20640# a_42140_16300# 0.58568f
C382 a_22987_17169# a_24667_33969# 0.04457f
C383 a_32634_33180# VDD 0.60275f
C384 a_3664_25122# VDD 0.22745f
C385 a_30954_33180# a_30660_33240# 0.01648f
C386 a_43704_20580# a_42285_16300# 0.02887f
C387 a_30544_33180# a_23105_33582# 0.01581f
C388 a_22987_29769# a_23254_25122# 0.01511f
C389 a_3807_29769# a_5754_24780# 0.02853f
C390 a_3807_29769# a_8120_20640# 0.02617f
C391 a_3807_29769# a_5754_28980# 0.01094f
C392 a_8844_16240# a_9254_16240# 0.0129f
C393 a_28864_25122# VDD 0.22431f
C394 a_27884_33180# VDD 0.58253f
C395 a_42434_16240# a_42285_16300# 0.05124f
C396 a_30954_33180# VDD 0.58329f
C397 a_43847_33969# a_55174_33522# 0.01296f
C398 a_5487_21229# a_8120_20640# 0.20813f
C399 a_43704_28980# VDD 0.36377f
C400 a_22987_29769# a_23105_16300# 0.10361f
C401 a_3925_33582# a_11774_33180# 0.01288f
C402 a_3925_33582# a_3807_33969# 0.19076f
C403 a_8414_24780# VDD 0.35048f
C404 a_10524_16240# a_8120_20640# 0.01552f
C405 a_46625_29040# a_43847_33969# 0.10869f
C406 a_3780_16300# a_5344_16240# 0.04956f
C407 a_4074_20922# VDD 0.21366f
C408 a_29274_20922# VDD 0.21617f
C409 a_3807_33969# a_3807_29769# 0.11878f
C410 a_8004_20580# a_5487_21229# 0.0137f
C411 a_22987_17169# a_24667_21229# 0.04563f
C412 a_13454_33180# VDD 0.60275f
C413 a_49840_33240# VDD 0.94704f
C414 a_22844_20922# VDD 0.22669f
C415 a_42285_33582# a_49724_33180# 0.01581f
C416 a_28024_16240# a_28434_16240# 0.0129f
C417 a_29274_20922# a_27300_20640# 0.01149f
C418 a_8265_29040# CLK 0.04361f
C419 a_3780_16300# a_3925_16300# 0.66682f
C420 a_8265_29040# SIGN 0.10869f
C421 a_26614_33180# a_26204_33180# 0.0129f
C422 a_46364_28980# VDD 0.36665f
C423 a_26465_33240# a_27884_33180# 0.04961f
C424 INN a_42167_29769# 0.10995f
C425 a_47064_33180# a_45645_33240# 0.04961f
C426 a_8265_29040# VDD 1.32076f
C427 a_42167_29769# CLK 0.16378f
C428 a_47064_33180# a_43847_33969# 0.01306f
C429 a_3807_33969# a_4074_29322# 0.01732f
C430 a_10094_25122# VDD 0.21693f
C431 a_3664_20922# VDD 0.22669f
C432 a_42167_29769# VDD 2.99884f
C433 a_29847_17169# a_3807_17169# 3.25127f
C434 a_22987_17169# a_22960_16300# 0.06129f
C435 a_3925_33582# a_5754_33522# 0.01595f
C436 a_46774_20580# a_46480_20640# 0.01311f
C437 a_26614_33180# VDD 0.60019f
C438 a_46774_24780# VDD 0.35048f
C439 a_50134_33180# a_42285_33582# 0.01288f
C440 a_3807_17169# INN 0.33831f
C441 a_44114_28980# VDD 0.34967f
C442 a_3807_17169# CLK 0.13794f
C443 INP a_3807_17169# 0.40079f
C444 a_15134_33522# SIGN 0.01296f
C445 a_3807_17169# SIGN 0.91528f
C446 a_42285_33582# a_42167_33969# 0.19076f
C447 a_30114_16240# a_29704_16240# 0.0129f
C448 a_3780_16300# a_10524_16240# 0.04917f
C449 a_24667_33969# a_27884_33180# 0.01306f
C450 a_28294_33180# a_23105_33582# 0.04484f
C451 a_7285_33240# a_3807_33969# 0.05138f
C452 a_46625_29040# VDD 1.32076f
C453 a_27445_29040# a_23105_33582# 0.38327f
C454 a_3807_17169# VDD 1.8767f
C455 a_30544_33180# a_30660_33240# 0.04076f
C456 a_30954_33180# a_24667_33969# 0.04353f
C457 a_7024_33180# VDD 0.63479f
C458 a_8004_20580# a_8120_20640# 0.01998f
C459 a_42167_29769# a_43847_21229# 0.76576f
C460 a_29847_17169# a_42140_16300# 0.06129f
C461 a_4074_20922# a_3925_16300# 0.01386f
C462 a_43847_33969# a_23105_33582# 0.39629f
R0 CLK.n1 CLK.t0 66.9351
R1 CLK.n1 CLK.t1 66.9351
R2 CLK.n6 CLK.t2 66.9351
R3 CLK.n6 CLK.t3 66.9351
R4 CLK.n0 CLK.t9 64.0265
R5 CLK.n5 CLK.t11 64.0265
R6 CLK.n3 CLK.t6 57.3995
R7 CLK.n8 CLK.t8 57.3995
R8 CLK.n10 CLK.n4 57.1085
R9 CLK.n4 CLK.t10 52.5086
R10 CLK.n9 CLK.t12 52.5086
R11 CLK.n0 CLK.t5 48.7505
R12 CLK.n5 CLK.t7 48.7505
R13 CLK.t4 CLK.n10 37.7465
R14 CLK.n10 CLK.n9 28.3625
R15 CLK CLK.t4 19.3805
R16 CLK.n2 CLK.n1 19.2009
R17 CLK.n7 CLK.n6 19.2009
R18 CLK.n3 CLK.n2 11.4065
R19 CLK.n8 CLK.n7 11.4065
R20 CLK.n4 CLK.n3 11.1725
R21 CLK.n9 CLK.n8 11.1725
R22 CLK.n2 CLK.n0 5.3165
R23 CLK.n7 CLK.n5 5.3165
C463 MAG VSS 5.09102f
C464 INN VSS 23.363f
C465 INP VSS 22.377f
C466 CLK VSS 48.9496f
C467 SIGN VSS 26.0087f
C468 VDD VSS 0.4169p
C469 a_52480_1364# VSS 4.72673f ; **FLOATING
C470 a_50240_2973# VSS 4.72932f ; **FLOATING
C471 a_41280_1364# VSS 4.56758f ; **FLOATING
C472 a_39040_3090# VSS 4.38724f ; **FLOATING
C473 a_36800_1364# VSS 4.5722f ; **FLOATING
C474 a_34560_3090# VSS 4.40625f ; **FLOATING
C475 a_64134_15120# VSS 0.04368f
C476 a_63724_15120# VSS 0.04368f
C477 a_62454_15120# VSS 0.04368f
C478 a_62044_15120# VSS 0.04368f
C479 a_60774_15120# VSS 0.39521f
C480 a_60364_15120# VSS 0.40738f ; **FLOATING
C481 a_59094_15120# VSS 0.38453f
C482 a_58800_15180# VSS 0.97755f ; **FLOATING
C483 a_58684_15120# VSS 0.38639f
C484 a_49294_16240# VSS 0.65976f
C485 a_48884_16240# VSS 0.65678f
C486 a_47614_16240# VSS 0.65976f
C487 a_47204_16240# VSS 0.65831f
C488 a_45956_16240# VSS 0.74137f
C489 a_45384_16240# VSS 0.74082f
C490 a_44114_16240# VSS 0.65976f
C491 a_43704_16240# VSS 0.65678f
C492 a_42434_16240# VSS 0.65882f
C493 a_42140_16300# VSS 4.01893f ; **FLOATING
C494 a_42024_16240# VSS 0.65773f
C495 a_30114_16240# VSS 0.65977f
C496 a_29704_16240# VSS 0.65679f
C497 a_29847_17169# VSS 99.80229f ; **FLOATING
C498 a_28434_16240# VSS 0.65977f
C499 a_28024_16240# VSS 0.65832f
C500 a_26776_16240# VSS 0.74138f
C501 a_26204_16240# VSS 0.74083f
C502 a_24934_16240# VSS 0.65977f
C503 a_24524_16240# VSS 0.65679f
C504 a_23254_16240# VSS 0.65883f
C505 a_22960_16300# VSS 4.01893f ; **FLOATING
C506 a_22844_16240# VSS 0.65774f
C507 a_22987_17169# VSS 86.9465f ; **FLOATING
C508 a_10934_16240# VSS 0.65977f
C509 a_10524_16240# VSS 0.65679f
C510 a_9254_16240# VSS 0.65977f
C511 a_8844_16240# VSS 0.65832f
C512 a_7596_16240# VSS 0.74138f
C513 a_7024_16240# VSS 0.74083f
C514 a_5754_16240# VSS 0.65977f
C515 a_5344_16240# VSS 0.65679f
C516 a_4074_16240# VSS 0.65883f
C517 a_3780_16300# VSS 4.01893f ; **FLOATING
C518 a_3664_16240# VSS 0.65774f
C519 a_3807_17169# VSS 91.1175f ; **FLOATING
C520 a_48454_20922# VSS 0.02717f
C521 a_48044_20922# VSS 0.02717f
C522 a_46774_20580# VSS 0.38483f
C523 a_46480_20640# VSS 2.70745f ; **FLOATING
C524 a_46364_20580# VSS 0.38539f
C525 a_44114_20580# VSS 0.38545f
C526 a_43704_20580# VSS 0.38483f
C527 a_42434_20922# VSS 0.02717f
C528 a_42285_16300# VSS 2.94014f ; **FLOATING
C529 a_42024_20922# VSS 0.02717f
C530 a_29274_20922# VSS 0.02717f
C531 a_28864_20922# VSS 0.02717f
C532 a_27594_20580# VSS 0.38401f
C533 a_27300_20640# VSS 2.49409f ; **FLOATING
C534 a_27184_20580# VSS 0.38539f
C535 a_24934_20580# VSS 0.38545f
C536 a_24524_20580# VSS 0.38401f
C537 a_23254_20922# VSS 0.02717f
C538 a_23105_16300# VSS 2.73077f ; **FLOATING
C539 a_22844_20922# VSS 0.02717f
C540 a_10094_20922# VSS 0.02717f
C541 a_9684_20922# VSS 0.02717f
C542 a_8414_20580# VSS 0.38401f
C543 a_8120_20640# VSS 2.49409f ; **FLOATING
C544 a_8004_20580# VSS 0.38539f
C545 a_5754_20580# VSS 0.38545f
C546 a_5344_20580# VSS 0.38401f
C547 a_4074_20922# VSS 0.02717f
C548 a_3925_16300# VSS 2.73077f ; **FLOATING
C549 a_3664_20922# VSS 0.02717f
C550 a_48454_25122# VSS 0.02717f
C551 a_48044_25122# VSS 0.02717f
C552 a_46774_24780# VSS 0.04368f
C553 a_46364_24780# VSS 0.04368f
C554 a_44114_24780# VSS 0.04368f
C555 a_43704_24780# VSS 0.04368f
C556 a_42434_25122# VSS 0.02717f
C557 a_42024_25122# VSS 0.02717f
C558 a_29274_25122# VSS 0.02717f
C559 a_28864_25122# VSS 0.02717f
C560 a_27594_24780# VSS 0.04368f
C561 a_27184_24780# VSS 0.04368f
C562 a_24934_24780# VSS 0.04368f
C563 a_24524_24780# VSS 0.04368f
C564 a_23254_25122# VSS 0.02717f
C565 a_22844_25122# VSS 0.02717f
C566 a_10094_25122# VSS 0.02717f
C567 a_9684_25122# VSS 0.02717f
C568 a_8414_24780# VSS 0.04368f
C569 a_8004_24780# VSS 0.04368f
C570 a_5754_24780# VSS 0.04368f
C571 a_5344_24780# VSS 0.04368f
C572 a_4074_25122# VSS 0.02717f
C573 a_3664_25122# VSS 0.02717f
C574 a_48454_29322# VSS 0.24358f
C575 a_48044_29322# VSS 0.25096f ; **FLOATING
C576 a_46774_28980# VSS 0.04368f
C577 a_46364_28980# VSS 0.04368f
C578 a_43847_21229# VSS 6.34344f ; **FLOATING
C579 a_44114_28980# VSS 0.04368f
C580 a_43704_28980# VSS 0.04368f
C581 a_42434_29322# VSS 0.24044f
C582 a_42024_29322# VSS 0.2541f ; **FLOATING
C583 a_42167_29769# VSS 7.20592f ; **FLOATING
C584 a_29274_29322# VSS 0.24358f
C585 a_28864_29322# VSS 0.25096f ; **FLOATING
C586 a_27594_28980# VSS 0.04368f
C587 a_27184_28980# VSS 0.04368f
C588 a_24667_21229# VSS 6.23571f ; **FLOATING
C589 a_24934_28980# VSS 0.04368f
C590 a_24524_28980# VSS 0.04368f
C591 a_23254_29322# VSS 0.24044f
C592 a_22844_29322# VSS 0.2541f ; **FLOATING
C593 a_22987_29769# VSS 7.05699f ; **FLOATING
C594 a_10094_29322# VSS 0.24358f
C595 a_9684_29322# VSS 0.25096f ; **FLOATING
C596 a_8414_28980# VSS 0.04368f
C597 a_8004_28980# VSS 0.04368f
C598 a_5487_21229# VSS 6.24102f ; **FLOATING
C599 a_5754_28980# VSS 0.04368f
C600 a_5344_28980# VSS 0.04368f
C601 a_4074_29322# VSS 0.24044f
C602 a_3664_29322# VSS 0.2541f ; **FLOATING
C603 a_3807_29769# VSS 7.06229f ; **FLOATING
C604 a_55174_33522# VSS 0.24358f
C605 a_54764_33522# VSS 0.25096f ; **FLOATING
C606 a_53494_33522# VSS 0.24358f
C607 a_53084_33522# VSS 0.25096f ; **FLOATING
C608 a_51814_33180# VSS 0.07326f
C609 a_51404_33180# VSS 0.07326f
C610 a_46625_29040# VSS 5.1927f ; **FLOATING
C611 a_50134_33180# VSS 0.07326f
C612 a_49840_33240# VSS 0.55804f ; **FLOATING
C613 a_49724_33180# VSS 0.07326f
C614 a_47474_33180# VSS 0.07326f
C615 a_47064_33180# VSS 0.07326f
C616 a_45794_33180# VSS 0.07326f
C617 a_45645_33240# VSS 0.40798f ; **FLOATING
C618 a_45384_33180# VSS 0.07326f
C619 a_44114_33522# VSS 0.24275f
C620 a_43704_33522# VSS 0.2518f ; **FLOATING
C621 a_43847_33969# VSS 13.5187f ; **FLOATING
C622 a_42434_33522# VSS 0.24044f
C623 a_42285_33582# VSS 7.34435f ; **FLOATING
C624 a_42024_33522# VSS 0.2541f ; **FLOATING
C625 a_42167_33969# VSS 4.0535f ; **FLOATING
C626 a_35994_33522# VSS 0.24358f
C627 a_35584_33522# VSS 0.25096f ; **FLOATING
C628 a_34314_33522# VSS 0.24358f
C629 a_33904_33522# VSS 0.25096f ; **FLOATING
C630 a_32634_33180# VSS 0.07326f
C631 a_32224_33180# VSS 0.07326f
C632 a_27445_29040# VSS 5.18739f ; **FLOATING
C633 a_30954_33180# VSS 0.07326f
C634 a_30660_33240# VSS 0.55804f ; **FLOATING
C635 a_30544_33180# VSS 0.07326f
C636 a_28294_33180# VSS 0.07326f
C637 a_27884_33180# VSS 0.07326f
C638 a_26614_33180# VSS 0.07326f
C639 a_26465_33240# VSS 0.40798f ; **FLOATING
C640 a_26204_33180# VSS 0.07326f
C641 a_24934_33522# VSS 0.24275f
C642 a_24524_33522# VSS 0.2518f ; **FLOATING
C643 a_24667_33969# VSS 9.28594f ; **FLOATING
C644 a_23254_33522# VSS 0.24044f
C645 a_23105_33582# VSS 20.3533f ; **FLOATING
C646 a_22844_33522# VSS 0.2541f ; **FLOATING
C647 a_22987_33969# VSS 4.04942f ; **FLOATING
C648 a_16814_33522# VSS 0.24358f
C649 a_16404_33522# VSS 0.25096f ; **FLOATING
C650 a_15134_33522# VSS 0.24358f
C651 a_14724_33522# VSS 0.25096f ; **FLOATING
C652 a_13454_33180# VSS 0.07326f
C653 a_13044_33180# VSS 0.07326f
C654 a_8265_29040# VSS 5.18739f ; **FLOATING
C655 a_11774_33180# VSS 0.07326f
C656 a_11480_33240# VSS 0.55804f ; **FLOATING
C657 a_11364_33180# VSS 0.07326f
C658 a_9114_33180# VSS 0.07326f
C659 a_8704_33180# VSS 0.07326f
C660 a_7434_33180# VSS 0.07326f
C661 a_7285_33240# VSS 0.40798f ; **FLOATING
C662 a_7024_33180# VSS 0.07326f
C663 a_5754_33522# VSS 0.24275f
C664 a_5344_33522# VSS 0.2518f ; **FLOATING
C665 a_4074_33522# VSS 0.24044f
C666 a_3925_33582# VSS 7.34053f ; **FLOATING
C667 a_3664_33522# VSS 0.2541f ; **FLOATING
C668 a_3807_33969# VSS 4.04942f ; **FLOATING
C669 CLK.t5 VSS 0.05456f ; **FLOATING
C670 CLK.t9 VSS 0.16391f ; **FLOATING
C671 CLK.n0 VSS 0.87833f ; **FLOATING
C672 CLK.t0 VSS 0.09138f ; **FLOATING
C673 CLK.t1 VSS 0.09138f ; **FLOATING
C674 CLK.n1 VSS 0.38177f ; **FLOATING
C675 CLK.n2 VSS 0.78097f ; **FLOATING
C676 CLK.t6 VSS 0.07617f ; **FLOATING
C677 CLK.n3 VSS 0.77427f ; **FLOATING
C678 CLK.t10 VSS 0.06124f ; **FLOATING
C679 CLK.n4 VSS 2.36845f ; **FLOATING
C680 CLK.t7 VSS 0.05456f ; **FLOATING
C681 CLK.t11 VSS 0.16391f ; **FLOATING
C682 CLK.n5 VSS 0.87833f ; **FLOATING
C683 CLK.t2 VSS 0.09138f ; **FLOATING
C684 CLK.t3 VSS 0.09138f ; **FLOATING
C685 CLK.n6 VSS 0.38177f ; **FLOATING
C686 CLK.n7 VSS 0.78097f ; **FLOATING
C687 CLK.t8 VSS 0.07617f ; **FLOATING
C688 CLK.n8 VSS 0.77427f ; **FLOATING
C689 CLK.t12 VSS 0.06124f ; **FLOATING
C690 CLK.n9 VSS 1.47035f ; **FLOATING
C691 CLK.n10 VSS 4.26422f ; **FLOATING
C692 CLK.t4 VSS 6.82361f ; **FLOATING
.ends

.subckt adc2b INP INN CLK SIGN MAG VDD VSS
XPEX VSS VDD INP INN CLK SIGN MAG adc2b_flat
.ends
.end
