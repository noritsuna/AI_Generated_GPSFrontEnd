* NGSPICE file created from decap.ext - technology: gf180mcuD

.subckt decap_CD5 VDD VSS
X0 VDD VSS cap_mim_2f0_m4m5_noshield c_width=5u c_length=5u
X1 VDD VSS cap_mim_2f0_m4m5_noshield c_width=5u c_length=5u
X2 VDD VSS cap_mim_2f0_m4m5_noshield c_width=5u c_length=5u
X3 VDD VSS cap_mim_2f0_m4m5_noshield c_width=5u c_length=5u
X4 VDD VSS cap_mim_2f0_m4m5_noshield c_width=5u c_length=5u
X5 VDD VSS cap_mim_2f0_m4m5_noshield c_width=5u c_length=5u
X6 VDD VSS cap_mim_2f0_m4m5_noshield c_width=5u c_length=5u
X7 VDD VSS cap_mim_2f0_m4m5_noshield c_width=5u c_length=5u
X8 VDD VSS cap_mim_2f0_m4m5_noshield c_width=5u c_length=5u
X9 VDD VSS cap_mim_2f0_m4m5_noshield c_width=5u c_length=5u
X10 VDD VSS cap_mim_2f0_m4m5_noshield c_width=5u c_length=5u
X11 VDD VSS cap_mim_2f0_m4m5_noshield c_width=5u c_length=5u
X12 VDD VSS cap_mim_2f0_m4m5_noshield c_width=5u c_length=5u
X13 VDD VSS cap_mim_2f0_m4m5_noshield c_width=5u c_length=5u
X14 VDD VSS cap_mim_2f0_m4m5_noshield c_width=5u c_length=5u
X15 VDD VSS cap_mim_2f0_m4m5_noshield c_width=5u c_length=5u
X16 VDD VSS cap_mim_2f0_m4m5_noshield c_width=5u c_length=5u
X17 VDD VSS cap_mim_2f0_m4m5_noshield c_width=5u c_length=5u
X18 VDD VSS cap_mim_2f0_m4m5_noshield c_width=5u c_length=5u
X19 VDD VSS cap_mim_2f0_m4m5_noshield c_width=5u c_length=5u
X20 VDD VSS cap_mim_2f0_m4m5_noshield c_width=5u c_length=5u
X21 VDD VSS cap_mim_2f0_m4m5_noshield c_width=5u c_length=5u
X22 VDD VSS cap_mim_2f0_m4m5_noshield c_width=5u c_length=5u
X23 VDD VSS cap_mim_2f0_m4m5_noshield c_width=5u c_length=5u
X24 VDD VSS cap_mim_2f0_m4m5_noshield c_width=5u c_length=5u
X25 VDD VSS cap_mim_2f0_m4m5_noshield c_width=5u c_length=5u
X26 VDD VSS cap_mim_2f0_m4m5_noshield c_width=5u c_length=5u
X27 VDD VSS cap_mim_2f0_m4m5_noshield c_width=5u c_length=5u
X28 VDD VSS cap_mim_2f0_m4m5_noshield c_width=5u c_length=5u
X29 VDD VSS cap_mim_2f0_m4m5_noshield c_width=5u c_length=5u
X30 VDD VSS cap_mim_2f0_m4m5_noshield c_width=5u c_length=5u
X31 VDD VSS cap_mim_2f0_m4m5_noshield c_width=5u c_length=5u
X32 VDD VSS cap_mim_2f0_m4m5_noshield c_width=5u c_length=5u
X33 VDD VSS cap_mim_2f0_m4m5_noshield c_width=5u c_length=5u
X34 VDD VSS cap_mim_2f0_m4m5_noshield c_width=5u c_length=5u
X35 VDD VSS cap_mim_2f0_m4m5_noshield c_width=5u c_length=5u
X36 VDD VSS cap_mim_2f0_m4m5_noshield c_width=5u c_length=5u
X37 VDD VSS cap_mim_2f0_m4m5_noshield c_width=5u c_length=5u
X38 VDD VSS cap_mim_2f0_m4m5_noshield c_width=5u c_length=5u
X39 VDD VSS cap_mim_2f0_m4m5_noshield c_width=5u c_length=5u
X40 VDD VSS cap_mim_2f0_m4m5_noshield c_width=5u c_length=5u
X41 VDD VSS cap_mim_2f0_m4m5_noshield c_width=5u c_length=5u
X42 VDD VSS cap_mim_2f0_m4m5_noshield c_width=5u c_length=5u
X43 VDD VSS cap_mim_2f0_m4m5_noshield c_width=5u c_length=5u
X44 VDD VSS cap_mim_2f0_m4m5_noshield c_width=5u c_length=5u
X45 VDD VSS cap_mim_2f0_m4m5_noshield c_width=5u c_length=5u
X46 VDD VSS cap_mim_2f0_m4m5_noshield c_width=5u c_length=5u
X47 VDD VSS cap_mim_2f0_m4m5_noshield c_width=5u c_length=5u
X48 VDD VSS cap_mim_2f0_m4m5_noshield c_width=5u c_length=5u
X49 VDD VSS cap_mim_2f0_m4m5_noshield c_width=5u c_length=5u
X50 VDD VSS cap_mim_2f0_m4m5_noshield c_width=5u c_length=5u
X51 VDD VSS cap_mim_2f0_m4m5_noshield c_width=5u c_length=5u
X52 VDD VSS cap_mim_2f0_m4m5_noshield c_width=5u c_length=5u
X53 VDD VSS cap_mim_2f0_m4m5_noshield c_width=5u c_length=5u
X54 VDD VSS cap_mim_2f0_m4m5_noshield c_width=5u c_length=5u
X55 VDD VSS cap_mim_2f0_m4m5_noshield c_width=5u c_length=5u
X56 VDD VSS cap_mim_2f0_m4m5_noshield c_width=5u c_length=5u
X57 VDD VSS cap_mim_2f0_m4m5_noshield c_width=5u c_length=5u
X58 VDD VSS cap_mim_2f0_m4m5_noshield c_width=5u c_length=5u
X59 VDD VSS cap_mim_2f0_m4m5_noshield c_width=5u c_length=5u
X60 VDD VSS cap_mim_2f0_m4m5_noshield c_width=5u c_length=5u
X61 VDD VSS cap_mim_2f0_m4m5_noshield c_width=5u c_length=5u
X62 VDD VSS cap_mim_2f0_m4m5_noshield c_width=5u c_length=5u
X63 VDD VSS cap_mim_2f0_m4m5_noshield c_width=5u c_length=5u
X64 VDD VSS cap_mim_2f0_m4m5_noshield c_width=5u c_length=5u
X65 VDD VSS cap_mim_2f0_m4m5_noshield c_width=5u c_length=5u
X66 VDD VSS cap_mim_2f0_m4m5_noshield c_width=5u c_length=5u
X67 VDD VSS cap_mim_2f0_m4m5_noshield c_width=5u c_length=5u
X68 VDD VSS cap_mim_2f0_m4m5_noshield c_width=5u c_length=5u
X69 VDD VSS cap_mim_2f0_m4m5_noshield c_width=5u c_length=5u
X70 VDD VSS cap_mim_2f0_m4m5_noshield c_width=5u c_length=5u
X71 VDD VSS cap_mim_2f0_m4m5_noshield c_width=5u c_length=5u
X72 VDD VSS cap_mim_2f0_m4m5_noshield c_width=5u c_length=5u
X73 VDD VSS cap_mim_2f0_m4m5_noshield c_width=5u c_length=5u
X74 VDD VSS cap_mim_2f0_m4m5_noshield c_width=5u c_length=5u
X75 VDD VSS cap_mim_2f0_m4m5_noshield c_width=5u c_length=5u
X76 VDD VSS cap_mim_2f0_m4m5_noshield c_width=5u c_length=5u
X77 VDD VSS cap_mim_2f0_m4m5_noshield c_width=5u c_length=5u
X78 VDD VSS cap_mim_2f0_m4m5_noshield c_width=5u c_length=5u
X79 VDD VSS cap_mim_2f0_m4m5_noshield c_width=5u c_length=5u
X80 VDD VSS cap_mim_2f0_m4m5_noshield c_width=5u c_length=5u
X81 VDD VSS cap_mim_2f0_m4m5_noshield c_width=5u c_length=5u
X82 VDD VSS cap_mim_2f0_m4m5_noshield c_width=5u c_length=5u
X83 VDD VSS cap_mim_2f0_m4m5_noshield c_width=5u c_length=5u
X84 VDD VSS cap_mim_2f0_m4m5_noshield c_width=5u c_length=5u
X85 VDD VSS cap_mim_2f0_m4m5_noshield c_width=5u c_length=5u
X86 VDD VSS cap_mim_2f0_m4m5_noshield c_width=5u c_length=5u
X87 VDD VSS cap_mim_2f0_m4m5_noshield c_width=5u c_length=5u
X88 VDD VSS cap_mim_2f0_m4m5_noshield c_width=5u c_length=5u
X89 VDD VSS cap_mim_2f0_m4m5_noshield c_width=5u c_length=5u
X90 VDD VSS cap_mim_2f0_m4m5_noshield c_width=5u c_length=5u
X91 VDD VSS cap_mim_2f0_m4m5_noshield c_width=5u c_length=5u
X92 VDD VSS cap_mim_2f0_m4m5_noshield c_width=5u c_length=5u
X93 VDD VSS cap_mim_2f0_m4m5_noshield c_width=5u c_length=5u
X94 VDD VSS cap_mim_2f0_m4m5_noshield c_width=5u c_length=5u
X95 VDD VSS cap_mim_2f0_m4m5_noshield c_width=5u c_length=5u
X96 VDD VSS cap_mim_2f0_m4m5_noshield c_width=5u c_length=5u
X97 VDD VSS cap_mim_2f0_m4m5_noshield c_width=5u c_length=5u
X98 VDD VSS cap_mim_2f0_m4m5_noshield c_width=5u c_length=5u
X99 VDD VSS cap_mim_2f0_m4m5_noshield c_width=5u c_length=5u
X100 VDD VSS cap_mim_2f0_m4m5_noshield c_width=5u c_length=5u
X101 VDD VSS cap_mim_2f0_m4m5_noshield c_width=5u c_length=5u
X102 VDD VSS cap_mim_2f0_m4m5_noshield c_width=5u c_length=5u
X103 VDD VSS cap_mim_2f0_m4m5_noshield c_width=5u c_length=5u
X104 VDD VSS cap_mim_2f0_m4m5_noshield c_width=5u c_length=5u
X105 VDD VSS cap_mim_2f0_m4m5_noshield c_width=5u c_length=5u
X106 VDD VSS cap_mim_2f0_m4m5_noshield c_width=5u c_length=5u
X107 VDD VSS cap_mim_2f0_m4m5_noshield c_width=5u c_length=5u
X108 VDD VSS cap_mim_2f0_m4m5_noshield c_width=5u c_length=5u
X109 VDD VSS cap_mim_2f0_m4m5_noshield c_width=5u c_length=5u
X110 VDD VSS cap_mim_2f0_m4m5_noshield c_width=5u c_length=5u
X111 VDD VSS cap_mim_2f0_m4m5_noshield c_width=5u c_length=5u
X112 VDD VSS cap_mim_2f0_m4m5_noshield c_width=5u c_length=5u
X113 VDD VSS cap_mim_2f0_m4m5_noshield c_width=5u c_length=5u
X114 VDD VSS cap_mim_2f0_m4m5_noshield c_width=5u c_length=5u
X115 VDD VSS cap_mim_2f0_m4m5_noshield c_width=5u c_length=5u
X116 VDD VSS cap_mim_2f0_m4m5_noshield c_width=5u c_length=5u
X117 VDD VSS cap_mim_2f0_m4m5_noshield c_width=5u c_length=5u
X118 VDD VSS cap_mim_2f0_m4m5_noshield c_width=5u c_length=5u
X119 VDD VSS cap_mim_2f0_m4m5_noshield c_width=5u c_length=5u
X120 VDD VSS cap_mim_2f0_m4m5_noshield c_width=5u c_length=5u
X121 VDD VSS cap_mim_2f0_m4m5_noshield c_width=5u c_length=5u
X122 VDD VSS cap_mim_2f0_m4m5_noshield c_width=5u c_length=5u
X123 VDD VSS cap_mim_2f0_m4m5_noshield c_width=5u c_length=5u
X124 VDD VSS cap_mim_2f0_m4m5_noshield c_width=5u c_length=5u
X125 VDD VSS cap_mim_2f0_m4m5_noshield c_width=5u c_length=5u
X126 VDD VSS cap_mim_2f0_m4m5_noshield c_width=5u c_length=5u
X127 VDD VSS cap_mim_2f0_m4m5_noshield c_width=5u c_length=5u
X128 VDD VSS cap_mim_2f0_m4m5_noshield c_width=5u c_length=5u
X129 VDD VSS cap_mim_2f0_m4m5_noshield c_width=5u c_length=5u
X130 VDD VSS cap_mim_2f0_m4m5_noshield c_width=5u c_length=5u
X131 VDD VSS cap_mim_2f0_m4m5_noshield c_width=5u c_length=5u
X132 VDD VSS cap_mim_2f0_m4m5_noshield c_width=5u c_length=5u
X133 VDD VSS cap_mim_2f0_m4m5_noshield c_width=5u c_length=5u
X134 VDD VSS cap_mim_2f0_m4m5_noshield c_width=5u c_length=5u
X135 VDD VSS cap_mim_2f0_m4m5_noshield c_width=5u c_length=5u
X136 VDD VSS cap_mim_2f0_m4m5_noshield c_width=5u c_length=5u
X137 VDD VSS cap_mim_2f0_m4m5_noshield c_width=5u c_length=5u
X138 VDD VSS cap_mim_2f0_m4m5_noshield c_width=5u c_length=5u
X139 VDD VSS cap_mim_2f0_m4m5_noshield c_width=5u c_length=5u
X140 VDD VSS cap_mim_2f0_m4m5_noshield c_width=5u c_length=5u
X141 VDD VSS cap_mim_2f0_m4m5_noshield c_width=5u c_length=5u
X142 VDD VSS cap_mim_2f0_m4m5_noshield c_width=5u c_length=5u
X143 VDD VSS cap_mim_2f0_m4m5_noshield c_width=5u c_length=5u
X144 VDD VSS cap_mim_2f0_m4m5_noshield c_width=5u c_length=5u
X145 VDD VSS cap_mim_2f0_m4m5_noshield c_width=5u c_length=5u
X146 VDD VSS cap_mim_2f0_m4m5_noshield c_width=5u c_length=5u
X147 VDD VSS cap_mim_2f0_m4m5_noshield c_width=5u c_length=5u
X148 VDD VSS cap_mim_2f0_m4m5_noshield c_width=5u c_length=5u
X149 VDD VSS cap_mim_2f0_m4m5_noshield c_width=5u c_length=5u
X150 VDD VSS cap_mim_2f0_m4m5_noshield c_width=5u c_length=5u
X151 VDD VSS cap_mim_2f0_m4m5_noshield c_width=5u c_length=5u
X152 VDD VSS cap_mim_2f0_m4m5_noshield c_width=5u c_length=5u
X153 VDD VSS cap_mim_2f0_m4m5_noshield c_width=5u c_length=5u
X154 VDD VSS cap_mim_2f0_m4m5_noshield c_width=5u c_length=5u
X155 VDD VSS cap_mim_2f0_m4m5_noshield c_width=5u c_length=5u
X156 VDD VSS cap_mim_2f0_m4m5_noshield c_width=5u c_length=5u
X157 VDD VSS cap_mim_2f0_m4m5_noshield c_width=5u c_length=5u
X158 VDD VSS cap_mim_2f0_m4m5_noshield c_width=5u c_length=5u
X159 VDD VSS cap_mim_2f0_m4m5_noshield c_width=5u c_length=5u
X160 VDD VSS cap_mim_2f0_m4m5_noshield c_width=5u c_length=5u
X161 VDD VSS cap_mim_2f0_m4m5_noshield c_width=5u c_length=5u
X162 VDD VSS cap_mim_2f0_m4m5_noshield c_width=5u c_length=5u
X163 VDD VSS cap_mim_2f0_m4m5_noshield c_width=5u c_length=5u
X164 VDD VSS cap_mim_2f0_m4m5_noshield c_width=5u c_length=5u
X165 VDD VSS cap_mim_2f0_m4m5_noshield c_width=5u c_length=5u
X166 VDD VSS cap_mim_2f0_m4m5_noshield c_width=5u c_length=5u
X167 VDD VSS cap_mim_2f0_m4m5_noshield c_width=5u c_length=5u
X168 VDD VSS cap_mim_2f0_m4m5_noshield c_width=5u c_length=5u
X169 VDD VSS cap_mim_2f0_m4m5_noshield c_width=5u c_length=5u
X170 VDD VSS cap_mim_2f0_m4m5_noshield c_width=5u c_length=5u
X171 VDD VSS cap_mim_2f0_m4m5_noshield c_width=5u c_length=5u
X172 VDD VSS cap_mim_2f0_m4m5_noshield c_width=5u c_length=5u
X173 VDD VSS cap_mim_2f0_m4m5_noshield c_width=5u c_length=5u
X174 VDD VSS cap_mim_2f0_m4m5_noshield c_width=5u c_length=5u
X175 VDD VSS cap_mim_2f0_m4m5_noshield c_width=5u c_length=5u
X176 VDD VSS cap_mim_2f0_m4m5_noshield c_width=5u c_length=5u
X177 VDD VSS cap_mim_2f0_m4m5_noshield c_width=5u c_length=5u
X178 VDD VSS cap_mim_2f0_m4m5_noshield c_width=5u c_length=5u
X179 VDD VSS cap_mim_2f0_m4m5_noshield c_width=5u c_length=5u
X180 VDD VSS cap_mim_2f0_m4m5_noshield c_width=5u c_length=5u
X181 VDD VSS cap_mim_2f0_m4m5_noshield c_width=5u c_length=5u
X182 VDD VSS cap_mim_2f0_m4m5_noshield c_width=5u c_length=5u
X183 VDD VSS cap_mim_2f0_m4m5_noshield c_width=5u c_length=5u
X184 VDD VSS cap_mim_2f0_m4m5_noshield c_width=5u c_length=5u
X185 VDD VSS cap_mim_2f0_m4m5_noshield c_width=5u c_length=5u
X186 VDD VSS cap_mim_2f0_m4m5_noshield c_width=5u c_length=5u
X187 VDD VSS cap_mim_2f0_m4m5_noshield c_width=5u c_length=5u
X188 VDD VSS cap_mim_2f0_m4m5_noshield c_width=5u c_length=5u
X189 VDD VSS cap_mim_2f0_m4m5_noshield c_width=5u c_length=5u
X190 VDD VSS cap_mim_2f0_m4m5_noshield c_width=5u c_length=5u
X191 VDD VSS cap_mim_2f0_m4m5_noshield c_width=5u c_length=5u
X192 VDD VSS cap_mim_2f0_m4m5_noshield c_width=5u c_length=5u
X193 VDD VSS cap_mim_2f0_m4m5_noshield c_width=5u c_length=5u
X194 VDD VSS cap_mim_2f0_m4m5_noshield c_width=5u c_length=5u
X195 VDD VSS cap_mim_2f0_m4m5_noshield c_width=5u c_length=5u
X196 VDD VSS cap_mim_2f0_m4m5_noshield c_width=5u c_length=5u
X197 VDD VSS cap_mim_2f0_m4m5_noshield c_width=5u c_length=5u
X198 VDD VSS cap_mim_2f0_m4m5_noshield c_width=5u c_length=5u
X199 VDD VSS cap_mim_2f0_m4m5_noshield c_width=5u c_length=5u
X200 VDD VSS cap_mim_2f0_m4m5_noshield c_width=5u c_length=5u
X201 VDD VSS cap_mim_2f0_m4m5_noshield c_width=5u c_length=5u
X202 VDD VSS cap_mim_2f0_m4m5_noshield c_width=5u c_length=5u
X203 VDD VSS cap_mim_2f0_m4m5_noshield c_width=5u c_length=5u
X204 VDD VSS cap_mim_2f0_m4m5_noshield c_width=5u c_length=5u
X205 VDD VSS cap_mim_2f0_m4m5_noshield c_width=5u c_length=5u
X206 VDD VSS cap_mim_2f0_m4m5_noshield c_width=5u c_length=5u
X207 VDD VSS cap_mim_2f0_m4m5_noshield c_width=5u c_length=5u
X208 VDD VSS cap_mim_2f0_m4m5_noshield c_width=5u c_length=5u
X209 VDD VSS cap_mim_2f0_m4m5_noshield c_width=5u c_length=5u
X210 VDD VSS cap_mim_2f0_m4m5_noshield c_width=5u c_length=5u
X211 VDD VSS cap_mim_2f0_m4m5_noshield c_width=5u c_length=5u
X212 VDD VSS cap_mim_2f0_m4m5_noshield c_width=5u c_length=5u
X213 VDD VSS cap_mim_2f0_m4m5_noshield c_width=5u c_length=5u
X214 VDD VSS cap_mim_2f0_m4m5_noshield c_width=5u c_length=5u
X215 VDD VSS cap_mim_2f0_m4m5_noshield c_width=5u c_length=5u
X216 VDD VSS cap_mim_2f0_m4m5_noshield c_width=5u c_length=5u
X217 VDD VSS cap_mim_2f0_m4m5_noshield c_width=5u c_length=5u
X218 VDD VSS cap_mim_2f0_m4m5_noshield c_width=5u c_length=5u
X219 VDD VSS cap_mim_2f0_m4m5_noshield c_width=5u c_length=5u
X220 VDD VSS cap_mim_2f0_m4m5_noshield c_width=5u c_length=5u
X221 VDD VSS cap_mim_2f0_m4m5_noshield c_width=5u c_length=5u
X222 VDD VSS cap_mim_2f0_m4m5_noshield c_width=5u c_length=5u
X223 VDD VSS cap_mim_2f0_m4m5_noshield c_width=5u c_length=5u
X224 VDD VSS cap_mim_2f0_m4m5_noshield c_width=5u c_length=5u
X225 VDD VSS cap_mim_2f0_m4m5_noshield c_width=5u c_length=5u
X226 VDD VSS cap_mim_2f0_m4m5_noshield c_width=5u c_length=5u
X227 VDD VSS cap_mim_2f0_m4m5_noshield c_width=5u c_length=5u
X228 VDD VSS cap_mim_2f0_m4m5_noshield c_width=5u c_length=5u
X229 VDD VSS cap_mim_2f0_m4m5_noshield c_width=5u c_length=5u
X230 VDD VSS cap_mim_2f0_m4m5_noshield c_width=5u c_length=5u
X231 VDD VSS cap_mim_2f0_m4m5_noshield c_width=5u c_length=5u
X232 VDD VSS cap_mim_2f0_m4m5_noshield c_width=5u c_length=5u
X233 VDD VSS cap_mim_2f0_m4m5_noshield c_width=5u c_length=5u
X234 VDD VSS cap_mim_2f0_m4m5_noshield c_width=5u c_length=5u
X235 VDD VSS cap_mim_2f0_m4m5_noshield c_width=5u c_length=5u
X236 VDD VSS cap_mim_2f0_m4m5_noshield c_width=5u c_length=5u
X237 VDD VSS cap_mim_2f0_m4m5_noshield c_width=5u c_length=5u
X238 VDD VSS cap_mim_2f0_m4m5_noshield c_width=5u c_length=5u
X239 VDD VSS cap_mim_2f0_m4m5_noshield c_width=5u c_length=5u
X240 VDD VSS cap_mim_2f0_m4m5_noshield c_width=5u c_length=5u
X241 VDD VSS cap_mim_2f0_m4m5_noshield c_width=5u c_length=5u
X242 VDD VSS cap_mim_2f0_m4m5_noshield c_width=5u c_length=5u
X243 VDD VSS cap_mim_2f0_m4m5_noshield c_width=5u c_length=5u
X244 VDD VSS cap_mim_2f0_m4m5_noshield c_width=5u c_length=5u
X245 VDD VSS cap_mim_2f0_m4m5_noshield c_width=5u c_length=5u
X246 VDD VSS cap_mim_2f0_m4m5_noshield c_width=5u c_length=5u
X247 VDD VSS cap_mim_2f0_m4m5_noshield c_width=5u c_length=5u
X248 VDD VSS cap_mim_2f0_m4m5_noshield c_width=5u c_length=5u
X249 VDD VSS cap_mim_2f0_m4m5_noshield c_width=5u c_length=5u
X250 VDD VSS cap_mim_2f0_m4m5_noshield c_width=5u c_length=5u
X251 VDD VSS cap_mim_2f0_m4m5_noshield c_width=5u c_length=5u
X252 VDD VSS cap_mim_2f0_m4m5_noshield c_width=5u c_length=5u
X253 VDD VSS cap_mim_2f0_m4m5_noshield c_width=5u c_length=5u
X254 VDD VSS cap_mim_2f0_m4m5_noshield c_width=5u c_length=5u
X255 VDD VSS cap_mim_2f0_m4m5_noshield c_width=5u c_length=5u
X256 VDD VSS cap_mim_2f0_m4m5_noshield c_width=5u c_length=5u
X257 VDD VSS cap_mim_2f0_m4m5_noshield c_width=5u c_length=5u
X258 VDD VSS cap_mim_2f0_m4m5_noshield c_width=5u c_length=5u
X259 VDD VSS cap_mim_2f0_m4m5_noshield c_width=5u c_length=5u
X260 VDD VSS cap_mim_2f0_m4m5_noshield c_width=5u c_length=5u
X261 VDD VSS cap_mim_2f0_m4m5_noshield c_width=5u c_length=5u
X262 VDD VSS cap_mim_2f0_m4m5_noshield c_width=5u c_length=5u
X263 VDD VSS cap_mim_2f0_m4m5_noshield c_width=5u c_length=5u
X264 VDD VSS cap_mim_2f0_m4m5_noshield c_width=5u c_length=5u
X265 VDD VSS cap_mim_2f0_m4m5_noshield c_width=5u c_length=5u
X266 VDD VSS cap_mim_2f0_m4m5_noshield c_width=5u c_length=5u
X267 VDD VSS cap_mim_2f0_m4m5_noshield c_width=5u c_length=5u
X268 VDD VSS cap_mim_2f0_m4m5_noshield c_width=5u c_length=5u
X269 VDD VSS cap_mim_2f0_m4m5_noshield c_width=5u c_length=5u
X270 VDD VSS cap_mim_2f0_m4m5_noshield c_width=5u c_length=5u
X271 VDD VSS cap_mim_2f0_m4m5_noshield c_width=5u c_length=5u
X272 VDD VSS cap_mim_2f0_m4m5_noshield c_width=5u c_length=5u
X273 VDD VSS cap_mim_2f0_m4m5_noshield c_width=5u c_length=5u
X274 VDD VSS cap_mim_2f0_m4m5_noshield c_width=5u c_length=5u
X275 VDD VSS cap_mim_2f0_m4m5_noshield c_width=5u c_length=5u
X276 VDD VSS cap_mim_2f0_m4m5_noshield c_width=5u c_length=5u
X277 VDD VSS cap_mim_2f0_m4m5_noshield c_width=5u c_length=5u
X278 VDD VSS cap_mim_2f0_m4m5_noshield c_width=5u c_length=5u
X279 VDD VSS cap_mim_2f0_m4m5_noshield c_width=5u c_length=5u
X280 VDD VSS cap_mim_2f0_m4m5_noshield c_width=5u c_length=5u
X281 VDD VSS cap_mim_2f0_m4m5_noshield c_width=5u c_length=5u
X282 VDD VSS cap_mim_2f0_m4m5_noshield c_width=5u c_length=5u
X283 VDD VSS cap_mim_2f0_m4m5_noshield c_width=5u c_length=5u
X284 VDD VSS cap_mim_2f0_m4m5_noshield c_width=5u c_length=5u
X285 VDD VSS cap_mim_2f0_m4m5_noshield c_width=5u c_length=5u
X286 VDD VSS cap_mim_2f0_m4m5_noshield c_width=5u c_length=5u
X287 VDD VSS cap_mim_2f0_m4m5_noshield c_width=5u c_length=5u
X288 VDD VSS cap_mim_2f0_m4m5_noshield c_width=5u c_length=5u
X289 VDD VSS cap_mim_2f0_m4m5_noshield c_width=5u c_length=5u
X290 VDD VSS cap_mim_2f0_m4m5_noshield c_width=5u c_length=5u
X291 VDD VSS cap_mim_2f0_m4m5_noshield c_width=5u c_length=5u
X292 VDD VSS cap_mim_2f0_m4m5_noshield c_width=5u c_length=5u
X293 VDD VSS cap_mim_2f0_m4m5_noshield c_width=5u c_length=5u
X294 VDD VSS cap_mim_2f0_m4m5_noshield c_width=5u c_length=5u
X295 VDD VSS cap_mim_2f0_m4m5_noshield c_width=5u c_length=5u
X296 VDD VSS cap_mim_2f0_m4m5_noshield c_width=5u c_length=5u
X297 VDD VSS cap_mim_2f0_m4m5_noshield c_width=5u c_length=5u
X298 VDD VSS cap_mim_2f0_m4m5_noshield c_width=5u c_length=5u
X299 VDD VSS cap_mim_2f0_m4m5_noshield c_width=5u c_length=5u
X300 VDD VSS cap_mim_2f0_m4m5_noshield c_width=5u c_length=5u
X301 VDD VSS cap_mim_2f0_m4m5_noshield c_width=5u c_length=5u
X302 VDD VSS cap_mim_2f0_m4m5_noshield c_width=5u c_length=5u
X303 VDD VSS cap_mim_2f0_m4m5_noshield c_width=5u c_length=5u
X304 VDD VSS cap_mim_2f0_m4m5_noshield c_width=5u c_length=5u
X305 VDD VSS cap_mim_2f0_m4m5_noshield c_width=5u c_length=5u
X306 VDD VSS cap_mim_2f0_m4m5_noshield c_width=5u c_length=5u
X307 VDD VSS cap_mim_2f0_m4m5_noshield c_width=5u c_length=5u
X308 VDD VSS cap_mim_2f0_m4m5_noshield c_width=5u c_length=5u
X309 VDD VSS cap_mim_2f0_m4m5_noshield c_width=5u c_length=5u
X310 VDD VSS cap_mim_2f0_m4m5_noshield c_width=5u c_length=5u
X311 VDD VSS cap_mim_2f0_m4m5_noshield c_width=5u c_length=5u
X312 VDD VSS cap_mim_2f0_m4m5_noshield c_width=5u c_length=5u
X313 VDD VSS cap_mim_2f0_m4m5_noshield c_width=5u c_length=5u
X314 VDD VSS cap_mim_2f0_m4m5_noshield c_width=5u c_length=5u
X315 VDD VSS cap_mim_2f0_m4m5_noshield c_width=5u c_length=5u
X316 VDD VSS cap_mim_2f0_m4m5_noshield c_width=5u c_length=5u
X317 VDD VSS cap_mim_2f0_m4m5_noshield c_width=5u c_length=5u
X318 VDD VSS cap_mim_2f0_m4m5_noshield c_width=5u c_length=5u
X319 VDD VSS cap_mim_2f0_m4m5_noshield c_width=5u c_length=5u
X320 VDD VSS cap_mim_2f0_m4m5_noshield c_width=5u c_length=5u
X321 VDD VSS cap_mim_2f0_m4m5_noshield c_width=5u c_length=5u
X322 VDD VSS cap_mim_2f0_m4m5_noshield c_width=5u c_length=5u
X323 VDD VSS cap_mim_2f0_m4m5_noshield c_width=5u c_length=5u
X324 VDD VSS cap_mim_2f0_m4m5_noshield c_width=5u c_length=5u
X325 VDD VSS cap_mim_2f0_m4m5_noshield c_width=5u c_length=5u
X326 VDD VSS cap_mim_2f0_m4m5_noshield c_width=5u c_length=5u
X327 VDD VSS cap_mim_2f0_m4m5_noshield c_width=5u c_length=5u
X328 VDD VSS cap_mim_2f0_m4m5_noshield c_width=5u c_length=5u
X329 VDD VSS cap_mim_2f0_m4m5_noshield c_width=5u c_length=5u
X330 VDD VSS cap_mim_2f0_m4m5_noshield c_width=5u c_length=5u
X331 VDD VSS cap_mim_2f0_m4m5_noshield c_width=5u c_length=5u
X332 VDD VSS cap_mim_2f0_m4m5_noshield c_width=5u c_length=5u
X333 VDD VSS cap_mim_2f0_m4m5_noshield c_width=5u c_length=5u
X334 VDD VSS cap_mim_2f0_m4m5_noshield c_width=5u c_length=5u
X335 VDD VSS cap_mim_2f0_m4m5_noshield c_width=5u c_length=5u
X336 VDD VSS cap_mim_2f0_m4m5_noshield c_width=5u c_length=5u
X337 VDD VSS cap_mim_2f0_m4m5_noshield c_width=5u c_length=5u
X338 VDD VSS cap_mim_2f0_m4m5_noshield c_width=5u c_length=5u
X339 VDD VSS cap_mim_2f0_m4m5_noshield c_width=5u c_length=5u
X340 VDD VSS cap_mim_2f0_m4m5_noshield c_width=5u c_length=5u
X341 VDD VSS cap_mim_2f0_m4m5_noshield c_width=5u c_length=5u
X342 VDD VSS cap_mim_2f0_m4m5_noshield c_width=5u c_length=5u
X343 VDD VSS cap_mim_2f0_m4m5_noshield c_width=5u c_length=5u
X344 VDD VSS cap_mim_2f0_m4m5_noshield c_width=5u c_length=5u
X345 VDD VSS cap_mim_2f0_m4m5_noshield c_width=5u c_length=5u
X346 VDD VSS cap_mim_2f0_m4m5_noshield c_width=5u c_length=5u
X347 VDD VSS cap_mim_2f0_m4m5_noshield c_width=5u c_length=5u
X348 VDD VSS cap_mim_2f0_m4m5_noshield c_width=5u c_length=5u
X349 VDD VSS cap_mim_2f0_m4m5_noshield c_width=5u c_length=5u
X350 VDD VSS cap_mim_2f0_m4m5_noshield c_width=5u c_length=5u
X351 VDD VSS cap_mim_2f0_m4m5_noshield c_width=5u c_length=5u
X352 VDD VSS cap_mim_2f0_m4m5_noshield c_width=5u c_length=5u
X353 VDD VSS cap_mim_2f0_m4m5_noshield c_width=5u c_length=5u
X354 VDD VSS cap_mim_2f0_m4m5_noshield c_width=5u c_length=5u
X355 VDD VSS cap_mim_2f0_m4m5_noshield c_width=5u c_length=5u
X356 VDD VSS cap_mim_2f0_m4m5_noshield c_width=5u c_length=5u
X357 VDD VSS cap_mim_2f0_m4m5_noshield c_width=5u c_length=5u
X358 VDD VSS cap_mim_2f0_m4m5_noshield c_width=5u c_length=5u
X359 VDD VSS cap_mim_2f0_m4m5_noshield c_width=5u c_length=5u
X360 VDD VSS cap_mim_2f0_m4m5_noshield c_width=5u c_length=5u
.ends

.subckt decap_CD6 VDD VSS
X0 VDD VSS cap_mim_2f0_m4m5_noshield c_width=5u c_length=5u
X1 VDD VSS cap_mim_2f0_m4m5_noshield c_width=5u c_length=5u
X2 VDD VSS cap_mim_2f0_m4m5_noshield c_width=5u c_length=5u
X3 VDD VSS cap_mim_2f0_m4m5_noshield c_width=5u c_length=5u
X4 VDD VSS cap_mim_2f0_m4m5_noshield c_width=5u c_length=5u
X5 VDD VSS cap_mim_2f0_m4m5_noshield c_width=5u c_length=5u
X6 VDD VSS cap_mim_2f0_m4m5_noshield c_width=5u c_length=5u
X7 VDD VSS cap_mim_2f0_m4m5_noshield c_width=5u c_length=5u
X8 VDD VSS cap_mim_2f0_m4m5_noshield c_width=5u c_length=5u
X9 VDD VSS cap_mim_2f0_m4m5_noshield c_width=5u c_length=5u
X10 VDD VSS cap_mim_2f0_m4m5_noshield c_width=5u c_length=5u
X11 VDD VSS cap_mim_2f0_m4m5_noshield c_width=5u c_length=5u
X12 VDD VSS cap_mim_2f0_m4m5_noshield c_width=5u c_length=5u
X13 VDD VSS cap_mim_2f0_m4m5_noshield c_width=5u c_length=5u
X14 VDD VSS cap_mim_2f0_m4m5_noshield c_width=5u c_length=5u
X15 VDD VSS cap_mim_2f0_m4m5_noshield c_width=5u c_length=5u
X16 VDD VSS cap_mim_2f0_m4m5_noshield c_width=5u c_length=5u
X17 VDD VSS cap_mim_2f0_m4m5_noshield c_width=5u c_length=5u
X18 VDD VSS cap_mim_2f0_m4m5_noshield c_width=5u c_length=5u
X19 VDD VSS cap_mim_2f0_m4m5_noshield c_width=5u c_length=5u
X20 VDD VSS cap_mim_2f0_m4m5_noshield c_width=5u c_length=5u
X21 VDD VSS cap_mim_2f0_m4m5_noshield c_width=5u c_length=5u
X22 VDD VSS cap_mim_2f0_m4m5_noshield c_width=5u c_length=5u
X23 VDD VSS cap_mim_2f0_m4m5_noshield c_width=5u c_length=5u
X24 VDD VSS cap_mim_2f0_m4m5_noshield c_width=5u c_length=5u
X25 VDD VSS cap_mim_2f0_m4m5_noshield c_width=5u c_length=5u
X26 VDD VSS cap_mim_2f0_m4m5_noshield c_width=5u c_length=5u
X27 VDD VSS cap_mim_2f0_m4m5_noshield c_width=5u c_length=5u
X28 VDD VSS cap_mim_2f0_m4m5_noshield c_width=5u c_length=5u
X29 VDD VSS cap_mim_2f0_m4m5_noshield c_width=5u c_length=5u
X30 VDD VSS cap_mim_2f0_m4m5_noshield c_width=5u c_length=5u
X31 VDD VSS cap_mim_2f0_m4m5_noshield c_width=5u c_length=5u
X32 VDD VSS cap_mim_2f0_m4m5_noshield c_width=5u c_length=5u
X33 VDD VSS cap_mim_2f0_m4m5_noshield c_width=5u c_length=5u
X34 VDD VSS cap_mim_2f0_m4m5_noshield c_width=5u c_length=5u
X35 VDD VSS cap_mim_2f0_m4m5_noshield c_width=5u c_length=5u
X36 VDD VSS cap_mim_2f0_m4m5_noshield c_width=5u c_length=5u
X37 VDD VSS cap_mim_2f0_m4m5_noshield c_width=5u c_length=5u
X38 VDD VSS cap_mim_2f0_m4m5_noshield c_width=5u c_length=5u
X39 VDD VSS cap_mim_2f0_m4m5_noshield c_width=5u c_length=5u
X40 VDD VSS cap_mim_2f0_m4m5_noshield c_width=5u c_length=5u
X41 VDD VSS cap_mim_2f0_m4m5_noshield c_width=5u c_length=5u
X42 VDD VSS cap_mim_2f0_m4m5_noshield c_width=5u c_length=5u
X43 VDD VSS cap_mim_2f0_m4m5_noshield c_width=5u c_length=5u
X44 VDD VSS cap_mim_2f0_m4m5_noshield c_width=5u c_length=5u
X45 VDD VSS cap_mim_2f0_m4m5_noshield c_width=5u c_length=5u
X46 VDD VSS cap_mim_2f0_m4m5_noshield c_width=5u c_length=5u
X47 VDD VSS cap_mim_2f0_m4m5_noshield c_width=5u c_length=5u
X48 VDD VSS cap_mim_2f0_m4m5_noshield c_width=5u c_length=5u
X49 VDD VSS cap_mim_2f0_m4m5_noshield c_width=5u c_length=5u
X50 VDD VSS cap_mim_2f0_m4m5_noshield c_width=5u c_length=5u
X51 VDD VSS cap_mim_2f0_m4m5_noshield c_width=5u c_length=5u
X52 VDD VSS cap_mim_2f0_m4m5_noshield c_width=5u c_length=5u
X53 VDD VSS cap_mim_2f0_m4m5_noshield c_width=5u c_length=5u
X54 VDD VSS cap_mim_2f0_m4m5_noshield c_width=5u c_length=5u
X55 VDD VSS cap_mim_2f0_m4m5_noshield c_width=5u c_length=5u
X56 VDD VSS cap_mim_2f0_m4m5_noshield c_width=5u c_length=5u
X57 VDD VSS cap_mim_2f0_m4m5_noshield c_width=5u c_length=5u
X58 VDD VSS cap_mim_2f0_m4m5_noshield c_width=5u c_length=5u
X59 VDD VSS cap_mim_2f0_m4m5_noshield c_width=5u c_length=5u
X60 VDD VSS cap_mim_2f0_m4m5_noshield c_width=5u c_length=5u
X61 VDD VSS cap_mim_2f0_m4m5_noshield c_width=5u c_length=5u
X62 VDD VSS cap_mim_2f0_m4m5_noshield c_width=5u c_length=5u
X63 VDD VSS cap_mim_2f0_m4m5_noshield c_width=5u c_length=5u
X64 VDD VSS cap_mim_2f0_m4m5_noshield c_width=5u c_length=5u
X65 VDD VSS cap_mim_2f0_m4m5_noshield c_width=5u c_length=5u
X66 VDD VSS cap_mim_2f0_m4m5_noshield c_width=5u c_length=5u
X67 VDD VSS cap_mim_2f0_m4m5_noshield c_width=5u c_length=5u
X68 VDD VSS cap_mim_2f0_m4m5_noshield c_width=5u c_length=5u
X69 VDD VSS cap_mim_2f0_m4m5_noshield c_width=5u c_length=5u
X70 VDD VSS cap_mim_2f0_m4m5_noshield c_width=5u c_length=5u
X71 VDD VSS cap_mim_2f0_m4m5_noshield c_width=5u c_length=5u
X72 VDD VSS cap_mim_2f0_m4m5_noshield c_width=5u c_length=5u
X73 VDD VSS cap_mim_2f0_m4m5_noshield c_width=5u c_length=5u
X74 VDD VSS cap_mim_2f0_m4m5_noshield c_width=5u c_length=5u
X75 VDD VSS cap_mim_2f0_m4m5_noshield c_width=5u c_length=5u
X76 VDD VSS cap_mim_2f0_m4m5_noshield c_width=5u c_length=5u
X77 VDD VSS cap_mim_2f0_m4m5_noshield c_width=5u c_length=5u
X78 VDD VSS cap_mim_2f0_m4m5_noshield c_width=5u c_length=5u
X79 VDD VSS cap_mim_2f0_m4m5_noshield c_width=5u c_length=5u
X80 VDD VSS cap_mim_2f0_m4m5_noshield c_width=5u c_length=5u
X81 VDD VSS cap_mim_2f0_m4m5_noshield c_width=5u c_length=5u
X82 VDD VSS cap_mim_2f0_m4m5_noshield c_width=5u c_length=5u
X83 VDD VSS cap_mim_2f0_m4m5_noshield c_width=5u c_length=5u
X84 VDD VSS cap_mim_2f0_m4m5_noshield c_width=5u c_length=5u
X85 VDD VSS cap_mim_2f0_m4m5_noshield c_width=5u c_length=5u
X86 VDD VSS cap_mim_2f0_m4m5_noshield c_width=5u c_length=5u
X87 VDD VSS cap_mim_2f0_m4m5_noshield c_width=5u c_length=5u
X88 VDD VSS cap_mim_2f0_m4m5_noshield c_width=5u c_length=5u
X89 VDD VSS cap_mim_2f0_m4m5_noshield c_width=5u c_length=5u
X90 VDD VSS cap_mim_2f0_m4m5_noshield c_width=5u c_length=5u
X91 VDD VSS cap_mim_2f0_m4m5_noshield c_width=5u c_length=5u
X92 VDD VSS cap_mim_2f0_m4m5_noshield c_width=5u c_length=5u
X93 VDD VSS cap_mim_2f0_m4m5_noshield c_width=5u c_length=5u
X94 VDD VSS cap_mim_2f0_m4m5_noshield c_width=5u c_length=5u
X95 VDD VSS cap_mim_2f0_m4m5_noshield c_width=5u c_length=5u
X96 VDD VSS cap_mim_2f0_m4m5_noshield c_width=5u c_length=5u
X97 VDD VSS cap_mim_2f0_m4m5_noshield c_width=5u c_length=5u
X98 VDD VSS cap_mim_2f0_m4m5_noshield c_width=5u c_length=5u
X99 VDD VSS cap_mim_2f0_m4m5_noshield c_width=5u c_length=5u
X100 VDD VSS cap_mim_2f0_m4m5_noshield c_width=5u c_length=5u
X101 VDD VSS cap_mim_2f0_m4m5_noshield c_width=5u c_length=5u
X102 VDD VSS cap_mim_2f0_m4m5_noshield c_width=5u c_length=5u
X103 VDD VSS cap_mim_2f0_m4m5_noshield c_width=5u c_length=5u
X104 VDD VSS cap_mim_2f0_m4m5_noshield c_width=5u c_length=5u
X105 VDD VSS cap_mim_2f0_m4m5_noshield c_width=5u c_length=5u
X106 VDD VSS cap_mim_2f0_m4m5_noshield c_width=5u c_length=5u
X107 VDD VSS cap_mim_2f0_m4m5_noshield c_width=5u c_length=5u
X108 VDD VSS cap_mim_2f0_m4m5_noshield c_width=5u c_length=5u
X109 VDD VSS cap_mim_2f0_m4m5_noshield c_width=5u c_length=5u
X110 VDD VSS cap_mim_2f0_m4m5_noshield c_width=5u c_length=5u
X111 VDD VSS cap_mim_2f0_m4m5_noshield c_width=5u c_length=5u
X112 VDD VSS cap_mim_2f0_m4m5_noshield c_width=5u c_length=5u
X113 VDD VSS cap_mim_2f0_m4m5_noshield c_width=5u c_length=5u
X114 VDD VSS cap_mim_2f0_m4m5_noshield c_width=5u c_length=5u
X115 VDD VSS cap_mim_2f0_m4m5_noshield c_width=5u c_length=5u
X116 VDD VSS cap_mim_2f0_m4m5_noshield c_width=5u c_length=5u
X117 VDD VSS cap_mim_2f0_m4m5_noshield c_width=5u c_length=5u
X118 VDD VSS cap_mim_2f0_m4m5_noshield c_width=5u c_length=5u
X119 VDD VSS cap_mim_2f0_m4m5_noshield c_width=5u c_length=5u
X120 VDD VSS cap_mim_2f0_m4m5_noshield c_width=5u c_length=5u
X121 VDD VSS cap_mim_2f0_m4m5_noshield c_width=5u c_length=5u
X122 VDD VSS cap_mim_2f0_m4m5_noshield c_width=5u c_length=5u
X123 VDD VSS cap_mim_2f0_m4m5_noshield c_width=5u c_length=5u
X124 VDD VSS cap_mim_2f0_m4m5_noshield c_width=5u c_length=5u
X125 VDD VSS cap_mim_2f0_m4m5_noshield c_width=5u c_length=5u
X126 VDD VSS cap_mim_2f0_m4m5_noshield c_width=5u c_length=5u
X127 VDD VSS cap_mim_2f0_m4m5_noshield c_width=5u c_length=5u
X128 VDD VSS cap_mim_2f0_m4m5_noshield c_width=5u c_length=5u
X129 VDD VSS cap_mim_2f0_m4m5_noshield c_width=5u c_length=5u
X130 VDD VSS cap_mim_2f0_m4m5_noshield c_width=5u c_length=5u
X131 VDD VSS cap_mim_2f0_m4m5_noshield c_width=5u c_length=5u
X132 VDD VSS cap_mim_2f0_m4m5_noshield c_width=5u c_length=5u
X133 VDD VSS cap_mim_2f0_m4m5_noshield c_width=5u c_length=5u
X134 VDD VSS cap_mim_2f0_m4m5_noshield c_width=5u c_length=5u
X135 VDD VSS cap_mim_2f0_m4m5_noshield c_width=5u c_length=5u
X136 VDD VSS cap_mim_2f0_m4m5_noshield c_width=5u c_length=5u
X137 VDD VSS cap_mim_2f0_m4m5_noshield c_width=5u c_length=5u
X138 VDD VSS cap_mim_2f0_m4m5_noshield c_width=5u c_length=5u
X139 VDD VSS cap_mim_2f0_m4m5_noshield c_width=5u c_length=5u
X140 VDD VSS cap_mim_2f0_m4m5_noshield c_width=5u c_length=5u
X141 VDD VSS cap_mim_2f0_m4m5_noshield c_width=5u c_length=5u
X142 VDD VSS cap_mim_2f0_m4m5_noshield c_width=5u c_length=5u
X143 VDD VSS cap_mim_2f0_m4m5_noshield c_width=5u c_length=5u
X144 VDD VSS cap_mim_2f0_m4m5_noshield c_width=5u c_length=5u
X145 VDD VSS cap_mim_2f0_m4m5_noshield c_width=5u c_length=5u
X146 VDD VSS cap_mim_2f0_m4m5_noshield c_width=5u c_length=5u
X147 VDD VSS cap_mim_2f0_m4m5_noshield c_width=5u c_length=5u
X148 VDD VSS cap_mim_2f0_m4m5_noshield c_width=5u c_length=5u
X149 VDD VSS cap_mim_2f0_m4m5_noshield c_width=5u c_length=5u
X150 VDD VSS cap_mim_2f0_m4m5_noshield c_width=5u c_length=5u
X151 VDD VSS cap_mim_2f0_m4m5_noshield c_width=5u c_length=5u
X152 VDD VSS cap_mim_2f0_m4m5_noshield c_width=5u c_length=5u
X153 VDD VSS cap_mim_2f0_m4m5_noshield c_width=5u c_length=5u
X154 VDD VSS cap_mim_2f0_m4m5_noshield c_width=5u c_length=5u
X155 VDD VSS cap_mim_2f0_m4m5_noshield c_width=5u c_length=5u
X156 VDD VSS cap_mim_2f0_m4m5_noshield c_width=5u c_length=5u
X157 VDD VSS cap_mim_2f0_m4m5_noshield c_width=5u c_length=5u
X158 VDD VSS cap_mim_2f0_m4m5_noshield c_width=5u c_length=5u
X159 VDD VSS cap_mim_2f0_m4m5_noshield c_width=5u c_length=5u
X160 VDD VSS cap_mim_2f0_m4m5_noshield c_width=5u c_length=5u
X161 VDD VSS cap_mim_2f0_m4m5_noshield c_width=5u c_length=5u
X162 VDD VSS cap_mim_2f0_m4m5_noshield c_width=5u c_length=5u
X163 VDD VSS cap_mim_2f0_m4m5_noshield c_width=5u c_length=5u
X164 VDD VSS cap_mim_2f0_m4m5_noshield c_width=5u c_length=5u
X165 VDD VSS cap_mim_2f0_m4m5_noshield c_width=5u c_length=5u
X166 VDD VSS cap_mim_2f0_m4m5_noshield c_width=5u c_length=5u
X167 VDD VSS cap_mim_2f0_m4m5_noshield c_width=5u c_length=5u
X168 VDD VSS cap_mim_2f0_m4m5_noshield c_width=5u c_length=5u
X169 VDD VSS cap_mim_2f0_m4m5_noshield c_width=5u c_length=5u
X170 VDD VSS cap_mim_2f0_m4m5_noshield c_width=5u c_length=5u
X171 VDD VSS cap_mim_2f0_m4m5_noshield c_width=5u c_length=5u
X172 VDD VSS cap_mim_2f0_m4m5_noshield c_width=5u c_length=5u
X173 VDD VSS cap_mim_2f0_m4m5_noshield c_width=5u c_length=5u
X174 VDD VSS cap_mim_2f0_m4m5_noshield c_width=5u c_length=5u
X175 VDD VSS cap_mim_2f0_m4m5_noshield c_width=5u c_length=5u
X176 VDD VSS cap_mim_2f0_m4m5_noshield c_width=5u c_length=5u
X177 VDD VSS cap_mim_2f0_m4m5_noshield c_width=5u c_length=5u
X178 VDD VSS cap_mim_2f0_m4m5_noshield c_width=5u c_length=5u
X179 VDD VSS cap_mim_2f0_m4m5_noshield c_width=5u c_length=5u
X180 VDD VSS cap_mim_2f0_m4m5_noshield c_width=5u c_length=5u
X181 VDD VSS cap_mim_2f0_m4m5_noshield c_width=5u c_length=5u
X182 VDD VSS cap_mim_2f0_m4m5_noshield c_width=5u c_length=5u
X183 VDD VSS cap_mim_2f0_m4m5_noshield c_width=5u c_length=5u
X184 VDD VSS cap_mim_2f0_m4m5_noshield c_width=5u c_length=5u
X185 VDD VSS cap_mim_2f0_m4m5_noshield c_width=5u c_length=5u
X186 VDD VSS cap_mim_2f0_m4m5_noshield c_width=5u c_length=5u
X187 VDD VSS cap_mim_2f0_m4m5_noshield c_width=5u c_length=5u
X188 VDD VSS cap_mim_2f0_m4m5_noshield c_width=5u c_length=5u
X189 VDD VSS cap_mim_2f0_m4m5_noshield c_width=5u c_length=5u
X190 VDD VSS cap_mim_2f0_m4m5_noshield c_width=5u c_length=5u
X191 VDD VSS cap_mim_2f0_m4m5_noshield c_width=5u c_length=5u
X192 VDD VSS cap_mim_2f0_m4m5_noshield c_width=5u c_length=5u
X193 VDD VSS cap_mim_2f0_m4m5_noshield c_width=5u c_length=5u
X194 VDD VSS cap_mim_2f0_m4m5_noshield c_width=5u c_length=5u
X195 VDD VSS cap_mim_2f0_m4m5_noshield c_width=5u c_length=5u
X196 VDD VSS cap_mim_2f0_m4m5_noshield c_width=5u c_length=5u
X197 VDD VSS cap_mim_2f0_m4m5_noshield c_width=5u c_length=5u
X198 VDD VSS cap_mim_2f0_m4m5_noshield c_width=5u c_length=5u
X199 VDD VSS cap_mim_2f0_m4m5_noshield c_width=5u c_length=5u
X200 VDD VSS cap_mim_2f0_m4m5_noshield c_width=5u c_length=5u
X201 VDD VSS cap_mim_2f0_m4m5_noshield c_width=5u c_length=5u
X202 VDD VSS cap_mim_2f0_m4m5_noshield c_width=5u c_length=5u
X203 VDD VSS cap_mim_2f0_m4m5_noshield c_width=5u c_length=5u
X204 VDD VSS cap_mim_2f0_m4m5_noshield c_width=5u c_length=5u
X205 VDD VSS cap_mim_2f0_m4m5_noshield c_width=5u c_length=5u
X206 VDD VSS cap_mim_2f0_m4m5_noshield c_width=5u c_length=5u
X207 VDD VSS cap_mim_2f0_m4m5_noshield c_width=5u c_length=5u
X208 VDD VSS cap_mim_2f0_m4m5_noshield c_width=5u c_length=5u
X209 VDD VSS cap_mim_2f0_m4m5_noshield c_width=5u c_length=5u
X210 VDD VSS cap_mim_2f0_m4m5_noshield c_width=5u c_length=5u
X211 VDD VSS cap_mim_2f0_m4m5_noshield c_width=5u c_length=5u
X212 VDD VSS cap_mim_2f0_m4m5_noshield c_width=5u c_length=5u
X213 VDD VSS cap_mim_2f0_m4m5_noshield c_width=5u c_length=5u
X214 VDD VSS cap_mim_2f0_m4m5_noshield c_width=5u c_length=5u
X215 VDD VSS cap_mim_2f0_m4m5_noshield c_width=5u c_length=5u
X216 VDD VSS cap_mim_2f0_m4m5_noshield c_width=5u c_length=5u
X217 VDD VSS cap_mim_2f0_m4m5_noshield c_width=5u c_length=5u
X218 VDD VSS cap_mim_2f0_m4m5_noshield c_width=5u c_length=5u
X219 VDD VSS cap_mim_2f0_m4m5_noshield c_width=5u c_length=5u
X220 VDD VSS cap_mim_2f0_m4m5_noshield c_width=5u c_length=5u
X221 VDD VSS cap_mim_2f0_m4m5_noshield c_width=5u c_length=5u
X222 VDD VSS cap_mim_2f0_m4m5_noshield c_width=5u c_length=5u
X223 VDD VSS cap_mim_2f0_m4m5_noshield c_width=5u c_length=5u
X224 VDD VSS cap_mim_2f0_m4m5_noshield c_width=5u c_length=5u
X225 VDD VSS cap_mim_2f0_m4m5_noshield c_width=5u c_length=5u
X226 VDD VSS cap_mim_2f0_m4m5_noshield c_width=5u c_length=5u
X227 VDD VSS cap_mim_2f0_m4m5_noshield c_width=5u c_length=5u
X228 VDD VSS cap_mim_2f0_m4m5_noshield c_width=5u c_length=5u
X229 VDD VSS cap_mim_2f0_m4m5_noshield c_width=5u c_length=5u
X230 VDD VSS cap_mim_2f0_m4m5_noshield c_width=5u c_length=5u
X231 VDD VSS cap_mim_2f0_m4m5_noshield c_width=5u c_length=5u
X232 VDD VSS cap_mim_2f0_m4m5_noshield c_width=5u c_length=5u
X233 VDD VSS cap_mim_2f0_m4m5_noshield c_width=5u c_length=5u
X234 VDD VSS cap_mim_2f0_m4m5_noshield c_width=5u c_length=5u
X235 VDD VSS cap_mim_2f0_m4m5_noshield c_width=5u c_length=5u
X236 VDD VSS cap_mim_2f0_m4m5_noshield c_width=5u c_length=5u
X237 VDD VSS cap_mim_2f0_m4m5_noshield c_width=5u c_length=5u
X238 VDD VSS cap_mim_2f0_m4m5_noshield c_width=5u c_length=5u
X239 VDD VSS cap_mim_2f0_m4m5_noshield c_width=5u c_length=5u
X240 VDD VSS cap_mim_2f0_m4m5_noshield c_width=5u c_length=5u
X241 VDD VSS cap_mim_2f0_m4m5_noshield c_width=5u c_length=5u
X242 VDD VSS cap_mim_2f0_m4m5_noshield c_width=5u c_length=5u
X243 VDD VSS cap_mim_2f0_m4m5_noshield c_width=5u c_length=5u
X244 VDD VSS cap_mim_2f0_m4m5_noshield c_width=5u c_length=5u
X245 VDD VSS cap_mim_2f0_m4m5_noshield c_width=5u c_length=5u
X246 VDD VSS cap_mim_2f0_m4m5_noshield c_width=5u c_length=5u
X247 VDD VSS cap_mim_2f0_m4m5_noshield c_width=5u c_length=5u
X248 VDD VSS cap_mim_2f0_m4m5_noshield c_width=5u c_length=5u
X249 VDD VSS cap_mim_2f0_m4m5_noshield c_width=5u c_length=5u
X250 VDD VSS cap_mim_2f0_m4m5_noshield c_width=5u c_length=5u
X251 VDD VSS cap_mim_2f0_m4m5_noshield c_width=5u c_length=5u
X252 VDD VSS cap_mim_2f0_m4m5_noshield c_width=5u c_length=5u
X253 VDD VSS cap_mim_2f0_m4m5_noshield c_width=5u c_length=5u
X254 VDD VSS cap_mim_2f0_m4m5_noshield c_width=5u c_length=5u
X255 VDD VSS cap_mim_2f0_m4m5_noshield c_width=5u c_length=5u
X256 VDD VSS cap_mim_2f0_m4m5_noshield c_width=5u c_length=5u
X257 VDD VSS cap_mim_2f0_m4m5_noshield c_width=5u c_length=5u
X258 VDD VSS cap_mim_2f0_m4m5_noshield c_width=5u c_length=5u
X259 VDD VSS cap_mim_2f0_m4m5_noshield c_width=5u c_length=5u
X260 VDD VSS cap_mim_2f0_m4m5_noshield c_width=5u c_length=5u
X261 VDD VSS cap_mim_2f0_m4m5_noshield c_width=5u c_length=5u
X262 VDD VSS cap_mim_2f0_m4m5_noshield c_width=5u c_length=5u
X263 VDD VSS cap_mim_2f0_m4m5_noshield c_width=5u c_length=5u
X264 VDD VSS cap_mim_2f0_m4m5_noshield c_width=5u c_length=5u
X265 VDD VSS cap_mim_2f0_m4m5_noshield c_width=5u c_length=5u
X266 VDD VSS cap_mim_2f0_m4m5_noshield c_width=5u c_length=5u
X267 VDD VSS cap_mim_2f0_m4m5_noshield c_width=5u c_length=5u
X268 VDD VSS cap_mim_2f0_m4m5_noshield c_width=5u c_length=5u
X269 VDD VSS cap_mim_2f0_m4m5_noshield c_width=5u c_length=5u
X270 VDD VSS cap_mim_2f0_m4m5_noshield c_width=5u c_length=5u
X271 VDD VSS cap_mim_2f0_m4m5_noshield c_width=5u c_length=5u
X272 VDD VSS cap_mim_2f0_m4m5_noshield c_width=5u c_length=5u
X273 VDD VSS cap_mim_2f0_m4m5_noshield c_width=5u c_length=5u
X274 VDD VSS cap_mim_2f0_m4m5_noshield c_width=5u c_length=5u
X275 VDD VSS cap_mim_2f0_m4m5_noshield c_width=5u c_length=5u
X276 VDD VSS cap_mim_2f0_m4m5_noshield c_width=5u c_length=5u
X277 VDD VSS cap_mim_2f0_m4m5_noshield c_width=5u c_length=5u
X278 VDD VSS cap_mim_2f0_m4m5_noshield c_width=5u c_length=5u
X279 VDD VSS cap_mim_2f0_m4m5_noshield c_width=5u c_length=5u
X280 VDD VSS cap_mim_2f0_m4m5_noshield c_width=5u c_length=5u
X281 VDD VSS cap_mim_2f0_m4m5_noshield c_width=5u c_length=5u
X282 VDD VSS cap_mim_2f0_m4m5_noshield c_width=5u c_length=5u
X283 VDD VSS cap_mim_2f0_m4m5_noshield c_width=5u c_length=5u
X284 VDD VSS cap_mim_2f0_m4m5_noshield c_width=5u c_length=5u
X285 VDD VSS cap_mim_2f0_m4m5_noshield c_width=5u c_length=5u
X286 VDD VSS cap_mim_2f0_m4m5_noshield c_width=5u c_length=5u
X287 VDD VSS cap_mim_2f0_m4m5_noshield c_width=5u c_length=5u
X288 VDD VSS cap_mim_2f0_m4m5_noshield c_width=5u c_length=5u
X289 VDD VSS cap_mim_2f0_m4m5_noshield c_width=5u c_length=5u
X290 VDD VSS cap_mim_2f0_m4m5_noshield c_width=5u c_length=5u
X291 VDD VSS cap_mim_2f0_m4m5_noshield c_width=5u c_length=5u
X292 VDD VSS cap_mim_2f0_m4m5_noshield c_width=5u c_length=5u
X293 VDD VSS cap_mim_2f0_m4m5_noshield c_width=5u c_length=5u
X294 VDD VSS cap_mim_2f0_m4m5_noshield c_width=5u c_length=5u
X295 VDD VSS cap_mim_2f0_m4m5_noshield c_width=5u c_length=5u
X296 VDD VSS cap_mim_2f0_m4m5_noshield c_width=5u c_length=5u
X297 VDD VSS cap_mim_2f0_m4m5_noshield c_width=5u c_length=5u
X298 VDD VSS cap_mim_2f0_m4m5_noshield c_width=5u c_length=5u
X299 VDD VSS cap_mim_2f0_m4m5_noshield c_width=5u c_length=5u
X300 VDD VSS cap_mim_2f0_m4m5_noshield c_width=5u c_length=5u
X301 VDD VSS cap_mim_2f0_m4m5_noshield c_width=5u c_length=5u
X302 VDD VSS cap_mim_2f0_m4m5_noshield c_width=5u c_length=5u
X303 VDD VSS cap_mim_2f0_m4m5_noshield c_width=5u c_length=5u
X304 VDD VSS cap_mim_2f0_m4m5_noshield c_width=5u c_length=5u
X305 VDD VSS cap_mim_2f0_m4m5_noshield c_width=5u c_length=5u
X306 VDD VSS cap_mim_2f0_m4m5_noshield c_width=5u c_length=5u
X307 VDD VSS cap_mim_2f0_m4m5_noshield c_width=5u c_length=5u
X308 VDD VSS cap_mim_2f0_m4m5_noshield c_width=5u c_length=5u
X309 VDD VSS cap_mim_2f0_m4m5_noshield c_width=5u c_length=5u
X310 VDD VSS cap_mim_2f0_m4m5_noshield c_width=5u c_length=5u
X311 VDD VSS cap_mim_2f0_m4m5_noshield c_width=5u c_length=5u
X312 VDD VSS cap_mim_2f0_m4m5_noshield c_width=5u c_length=5u
X313 VDD VSS cap_mim_2f0_m4m5_noshield c_width=5u c_length=5u
X314 VDD VSS cap_mim_2f0_m4m5_noshield c_width=5u c_length=5u
X315 VDD VSS cap_mim_2f0_m4m5_noshield c_width=5u c_length=5u
X316 VDD VSS cap_mim_2f0_m4m5_noshield c_width=5u c_length=5u
X317 VDD VSS cap_mim_2f0_m4m5_noshield c_width=5u c_length=5u
X318 VDD VSS cap_mim_2f0_m4m5_noshield c_width=5u c_length=5u
X319 VDD VSS cap_mim_2f0_m4m5_noshield c_width=5u c_length=5u
X320 VDD VSS cap_mim_2f0_m4m5_noshield c_width=5u c_length=5u
X321 VDD VSS cap_mim_2f0_m4m5_noshield c_width=5u c_length=5u
X322 VDD VSS cap_mim_2f0_m4m5_noshield c_width=5u c_length=5u
X323 VDD VSS cap_mim_2f0_m4m5_noshield c_width=5u c_length=5u
X324 VDD VSS cap_mim_2f0_m4m5_noshield c_width=5u c_length=5u
X325 VDD VSS cap_mim_2f0_m4m5_noshield c_width=5u c_length=5u
X326 VDD VSS cap_mim_2f0_m4m5_noshield c_width=5u c_length=5u
X327 VDD VSS cap_mim_2f0_m4m5_noshield c_width=5u c_length=5u
X328 VDD VSS cap_mim_2f0_m4m5_noshield c_width=5u c_length=5u
X329 VDD VSS cap_mim_2f0_m4m5_noshield c_width=5u c_length=5u
X330 VDD VSS cap_mim_2f0_m4m5_noshield c_width=5u c_length=5u
X331 VDD VSS cap_mim_2f0_m4m5_noshield c_width=5u c_length=5u
X332 VDD VSS cap_mim_2f0_m4m5_noshield c_width=5u c_length=5u
X333 VDD VSS cap_mim_2f0_m4m5_noshield c_width=5u c_length=5u
X334 VDD VSS cap_mim_2f0_m4m5_noshield c_width=5u c_length=5u
X335 VDD VSS cap_mim_2f0_m4m5_noshield c_width=5u c_length=5u
X336 VDD VSS cap_mim_2f0_m4m5_noshield c_width=5u c_length=5u
X337 VDD VSS cap_mim_2f0_m4m5_noshield c_width=5u c_length=5u
X338 VDD VSS cap_mim_2f0_m4m5_noshield c_width=5u c_length=5u
X339 VDD VSS cap_mim_2f0_m4m5_noshield c_width=5u c_length=5u
X340 VDD VSS cap_mim_2f0_m4m5_noshield c_width=5u c_length=5u
X341 VDD VSS cap_mim_2f0_m4m5_noshield c_width=5u c_length=5u
X342 VDD VSS cap_mim_2f0_m4m5_noshield c_width=5u c_length=5u
X343 VDD VSS cap_mim_2f0_m4m5_noshield c_width=5u c_length=5u
X344 VDD VSS cap_mim_2f0_m4m5_noshield c_width=5u c_length=5u
X345 VDD VSS cap_mim_2f0_m4m5_noshield c_width=5u c_length=5u
X346 VDD VSS cap_mim_2f0_m4m5_noshield c_width=5u c_length=5u
X347 VDD VSS cap_mim_2f0_m4m5_noshield c_width=5u c_length=5u
X348 VDD VSS cap_mim_2f0_m4m5_noshield c_width=5u c_length=5u
X349 VDD VSS cap_mim_2f0_m4m5_noshield c_width=5u c_length=5u
X350 VDD VSS cap_mim_2f0_m4m5_noshield c_width=5u c_length=5u
X351 VDD VSS cap_mim_2f0_m4m5_noshield c_width=5u c_length=5u
X352 VDD VSS cap_mim_2f0_m4m5_noshield c_width=5u c_length=5u
X353 VDD VSS cap_mim_2f0_m4m5_noshield c_width=5u c_length=5u
X354 VDD VSS cap_mim_2f0_m4m5_noshield c_width=5u c_length=5u
X355 VDD VSS cap_mim_2f0_m4m5_noshield c_width=5u c_length=5u
X356 VDD VSS cap_mim_2f0_m4m5_noshield c_width=5u c_length=5u
X357 VDD VSS cap_mim_2f0_m4m5_noshield c_width=5u c_length=5u
X358 VDD VSS cap_mim_2f0_m4m5_noshield c_width=5u c_length=5u
X359 VDD VSS cap_mim_2f0_m4m5_noshield c_width=5u c_length=5u
X360 VDD VSS cap_mim_2f0_m4m5_noshield c_width=5u c_length=5u
.ends

.subckt decap_CD0 VDD VSS
X0 VDD VSS cap_mim_2f0_m4m5_noshield c_width=5u c_length=5u
X1 VDD VSS cap_mim_2f0_m4m5_noshield c_width=5u c_length=5u
X2 VDD VSS cap_mim_2f0_m4m5_noshield c_width=5u c_length=5u
X3 VDD VSS cap_mim_2f0_m4m5_noshield c_width=5u c_length=5u
X4 VDD VSS cap_mim_2f0_m4m5_noshield c_width=5u c_length=5u
X5 VDD VSS cap_mim_2f0_m4m5_noshield c_width=5u c_length=5u
X6 VDD VSS cap_mim_2f0_m4m5_noshield c_width=5u c_length=5u
X7 VDD VSS cap_mim_2f0_m4m5_noshield c_width=5u c_length=5u
X8 VDD VSS cap_mim_2f0_m4m5_noshield c_width=5u c_length=5u
X9 VDD VSS cap_mim_2f0_m4m5_noshield c_width=5u c_length=5u
X10 VDD VSS cap_mim_2f0_m4m5_noshield c_width=5u c_length=5u
X11 VDD VSS cap_mim_2f0_m4m5_noshield c_width=5u c_length=5u
X12 VDD VSS cap_mim_2f0_m4m5_noshield c_width=5u c_length=5u
X13 VDD VSS cap_mim_2f0_m4m5_noshield c_width=5u c_length=5u
X14 VDD VSS cap_mim_2f0_m4m5_noshield c_width=5u c_length=5u
X15 VDD VSS cap_mim_2f0_m4m5_noshield c_width=5u c_length=5u
X16 VDD VSS cap_mim_2f0_m4m5_noshield c_width=5u c_length=5u
X17 VDD VSS cap_mim_2f0_m4m5_noshield c_width=5u c_length=5u
X18 VDD VSS cap_mim_2f0_m4m5_noshield c_width=5u c_length=5u
X19 VDD VSS cap_mim_2f0_m4m5_noshield c_width=5u c_length=5u
X20 VDD VSS cap_mim_2f0_m4m5_noshield c_width=5u c_length=5u
X21 VDD VSS cap_mim_2f0_m4m5_noshield c_width=5u c_length=5u
X22 VDD VSS cap_mim_2f0_m4m5_noshield c_width=5u c_length=5u
X23 VDD VSS cap_mim_2f0_m4m5_noshield c_width=5u c_length=5u
X24 VDD VSS cap_mim_2f0_m4m5_noshield c_width=5u c_length=5u
X25 VDD VSS cap_mim_2f0_m4m5_noshield c_width=5u c_length=5u
X26 VDD VSS cap_mim_2f0_m4m5_noshield c_width=5u c_length=5u
X27 VDD VSS cap_mim_2f0_m4m5_noshield c_width=5u c_length=5u
X28 VDD VSS cap_mim_2f0_m4m5_noshield c_width=5u c_length=5u
X29 VDD VSS cap_mim_2f0_m4m5_noshield c_width=5u c_length=5u
X30 VDD VSS cap_mim_2f0_m4m5_noshield c_width=5u c_length=5u
X31 VDD VSS cap_mim_2f0_m4m5_noshield c_width=5u c_length=5u
X32 VDD VSS cap_mim_2f0_m4m5_noshield c_width=5u c_length=5u
X33 VDD VSS cap_mim_2f0_m4m5_noshield c_width=5u c_length=5u
X34 VDD VSS cap_mim_2f0_m4m5_noshield c_width=5u c_length=5u
X35 VDD VSS cap_mim_2f0_m4m5_noshield c_width=5u c_length=5u
X36 VDD VSS cap_mim_2f0_m4m5_noshield c_width=5u c_length=5u
X37 VDD VSS cap_mim_2f0_m4m5_noshield c_width=5u c_length=5u
X38 VDD VSS cap_mim_2f0_m4m5_noshield c_width=5u c_length=5u
X39 VDD VSS cap_mim_2f0_m4m5_noshield c_width=5u c_length=5u
X40 VDD VSS cap_mim_2f0_m4m5_noshield c_width=5u c_length=5u
X41 VDD VSS cap_mim_2f0_m4m5_noshield c_width=5u c_length=5u
X42 VDD VSS cap_mim_2f0_m4m5_noshield c_width=5u c_length=5u
X43 VDD VSS cap_mim_2f0_m4m5_noshield c_width=5u c_length=5u
X44 VDD VSS cap_mim_2f0_m4m5_noshield c_width=5u c_length=5u
X45 VDD VSS cap_mim_2f0_m4m5_noshield c_width=5u c_length=5u
X46 VDD VSS cap_mim_2f0_m4m5_noshield c_width=5u c_length=5u
X47 VDD VSS cap_mim_2f0_m4m5_noshield c_width=5u c_length=5u
X48 VDD VSS cap_mim_2f0_m4m5_noshield c_width=5u c_length=5u
X49 VDD VSS cap_mim_2f0_m4m5_noshield c_width=5u c_length=5u
X50 VDD VSS cap_mim_2f0_m4m5_noshield c_width=5u c_length=5u
X51 VDD VSS cap_mim_2f0_m4m5_noshield c_width=5u c_length=5u
X52 VDD VSS cap_mim_2f0_m4m5_noshield c_width=5u c_length=5u
X53 VDD VSS cap_mim_2f0_m4m5_noshield c_width=5u c_length=5u
X54 VDD VSS cap_mim_2f0_m4m5_noshield c_width=5u c_length=5u
X55 VDD VSS cap_mim_2f0_m4m5_noshield c_width=5u c_length=5u
X56 VDD VSS cap_mim_2f0_m4m5_noshield c_width=5u c_length=5u
X57 VDD VSS cap_mim_2f0_m4m5_noshield c_width=5u c_length=5u
X58 VDD VSS cap_mim_2f0_m4m5_noshield c_width=5u c_length=5u
X59 VDD VSS cap_mim_2f0_m4m5_noshield c_width=5u c_length=5u
X60 VDD VSS cap_mim_2f0_m4m5_noshield c_width=5u c_length=5u
X61 VDD VSS cap_mim_2f0_m4m5_noshield c_width=5u c_length=5u
X62 VDD VSS cap_mim_2f0_m4m5_noshield c_width=5u c_length=5u
X63 VDD VSS cap_mim_2f0_m4m5_noshield c_width=5u c_length=5u
X64 VDD VSS cap_mim_2f0_m4m5_noshield c_width=5u c_length=5u
X65 VDD VSS cap_mim_2f0_m4m5_noshield c_width=5u c_length=5u
X66 VDD VSS cap_mim_2f0_m4m5_noshield c_width=5u c_length=5u
X67 VDD VSS cap_mim_2f0_m4m5_noshield c_width=5u c_length=5u
X68 VDD VSS cap_mim_2f0_m4m5_noshield c_width=5u c_length=5u
X69 VDD VSS cap_mim_2f0_m4m5_noshield c_width=5u c_length=5u
X70 VDD VSS cap_mim_2f0_m4m5_noshield c_width=5u c_length=5u
X71 VDD VSS cap_mim_2f0_m4m5_noshield c_width=5u c_length=5u
X72 VDD VSS cap_mim_2f0_m4m5_noshield c_width=5u c_length=5u
X73 VDD VSS cap_mim_2f0_m4m5_noshield c_width=5u c_length=5u
X74 VDD VSS cap_mim_2f0_m4m5_noshield c_width=5u c_length=5u
X75 VDD VSS cap_mim_2f0_m4m5_noshield c_width=5u c_length=5u
X76 VDD VSS cap_mim_2f0_m4m5_noshield c_width=5u c_length=5u
X77 VDD VSS cap_mim_2f0_m4m5_noshield c_width=5u c_length=5u
X78 VDD VSS cap_mim_2f0_m4m5_noshield c_width=5u c_length=5u
X79 VDD VSS cap_mim_2f0_m4m5_noshield c_width=5u c_length=5u
X80 VDD VSS cap_mim_2f0_m4m5_noshield c_width=5u c_length=5u
X81 VDD VSS cap_mim_2f0_m4m5_noshield c_width=5u c_length=5u
X82 VDD VSS cap_mim_2f0_m4m5_noshield c_width=5u c_length=5u
X83 VDD VSS cap_mim_2f0_m4m5_noshield c_width=5u c_length=5u
X84 VDD VSS cap_mim_2f0_m4m5_noshield c_width=5u c_length=5u
X85 VDD VSS cap_mim_2f0_m4m5_noshield c_width=5u c_length=5u
X86 VDD VSS cap_mim_2f0_m4m5_noshield c_width=5u c_length=5u
X87 VDD VSS cap_mim_2f0_m4m5_noshield c_width=5u c_length=5u
X88 VDD VSS cap_mim_2f0_m4m5_noshield c_width=5u c_length=5u
X89 VDD VSS cap_mim_2f0_m4m5_noshield c_width=5u c_length=5u
X90 VDD VSS cap_mim_2f0_m4m5_noshield c_width=5u c_length=5u
X91 VDD VSS cap_mim_2f0_m4m5_noshield c_width=5u c_length=5u
X92 VDD VSS cap_mim_2f0_m4m5_noshield c_width=5u c_length=5u
X93 VDD VSS cap_mim_2f0_m4m5_noshield c_width=5u c_length=5u
X94 VDD VSS cap_mim_2f0_m4m5_noshield c_width=5u c_length=5u
X95 VDD VSS cap_mim_2f0_m4m5_noshield c_width=5u c_length=5u
X96 VDD VSS cap_mim_2f0_m4m5_noshield c_width=5u c_length=5u
X97 VDD VSS cap_mim_2f0_m4m5_noshield c_width=5u c_length=5u
X98 VDD VSS cap_mim_2f0_m4m5_noshield c_width=5u c_length=5u
X99 VDD VSS cap_mim_2f0_m4m5_noshield c_width=5u c_length=5u
X100 VDD VSS cap_mim_2f0_m4m5_noshield c_width=5u c_length=5u
X101 VDD VSS cap_mim_2f0_m4m5_noshield c_width=5u c_length=5u
X102 VDD VSS cap_mim_2f0_m4m5_noshield c_width=5u c_length=5u
X103 VDD VSS cap_mim_2f0_m4m5_noshield c_width=5u c_length=5u
X104 VDD VSS cap_mim_2f0_m4m5_noshield c_width=5u c_length=5u
X105 VDD VSS cap_mim_2f0_m4m5_noshield c_width=5u c_length=5u
X106 VDD VSS cap_mim_2f0_m4m5_noshield c_width=5u c_length=5u
X107 VDD VSS cap_mim_2f0_m4m5_noshield c_width=5u c_length=5u
X108 VDD VSS cap_mim_2f0_m4m5_noshield c_width=5u c_length=5u
X109 VDD VSS cap_mim_2f0_m4m5_noshield c_width=5u c_length=5u
X110 VDD VSS cap_mim_2f0_m4m5_noshield c_width=5u c_length=5u
X111 VDD VSS cap_mim_2f0_m4m5_noshield c_width=5u c_length=5u
X112 VDD VSS cap_mim_2f0_m4m5_noshield c_width=5u c_length=5u
X113 VDD VSS cap_mim_2f0_m4m5_noshield c_width=5u c_length=5u
X114 VDD VSS cap_mim_2f0_m4m5_noshield c_width=5u c_length=5u
X115 VDD VSS cap_mim_2f0_m4m5_noshield c_width=5u c_length=5u
X116 VDD VSS cap_mim_2f0_m4m5_noshield c_width=5u c_length=5u
X117 VDD VSS cap_mim_2f0_m4m5_noshield c_width=5u c_length=5u
X118 VDD VSS cap_mim_2f0_m4m5_noshield c_width=5u c_length=5u
X119 VDD VSS cap_mim_2f0_m4m5_noshield c_width=5u c_length=5u
X120 VDD VSS cap_mim_2f0_m4m5_noshield c_width=5u c_length=5u
X121 VDD VSS cap_mim_2f0_m4m5_noshield c_width=5u c_length=5u
X122 VDD VSS cap_mim_2f0_m4m5_noshield c_width=5u c_length=5u
X123 VDD VSS cap_mim_2f0_m4m5_noshield c_width=5u c_length=5u
X124 VDD VSS cap_mim_2f0_m4m5_noshield c_width=5u c_length=5u
X125 VDD VSS cap_mim_2f0_m4m5_noshield c_width=5u c_length=5u
X126 VDD VSS cap_mim_2f0_m4m5_noshield c_width=5u c_length=5u
X127 VDD VSS cap_mim_2f0_m4m5_noshield c_width=5u c_length=5u
X128 VDD VSS cap_mim_2f0_m4m5_noshield c_width=5u c_length=5u
X129 VDD VSS cap_mim_2f0_m4m5_noshield c_width=5u c_length=5u
X130 VDD VSS cap_mim_2f0_m4m5_noshield c_width=5u c_length=5u
X131 VDD VSS cap_mim_2f0_m4m5_noshield c_width=5u c_length=5u
X132 VDD VSS cap_mim_2f0_m4m5_noshield c_width=5u c_length=5u
X133 VDD VSS cap_mim_2f0_m4m5_noshield c_width=5u c_length=5u
X134 VDD VSS cap_mim_2f0_m4m5_noshield c_width=5u c_length=5u
X135 VDD VSS cap_mim_2f0_m4m5_noshield c_width=5u c_length=5u
X136 VDD VSS cap_mim_2f0_m4m5_noshield c_width=5u c_length=5u
X137 VDD VSS cap_mim_2f0_m4m5_noshield c_width=5u c_length=5u
X138 VDD VSS cap_mim_2f0_m4m5_noshield c_width=5u c_length=5u
X139 VDD VSS cap_mim_2f0_m4m5_noshield c_width=5u c_length=5u
X140 VDD VSS cap_mim_2f0_m4m5_noshield c_width=5u c_length=5u
X141 VDD VSS cap_mim_2f0_m4m5_noshield c_width=5u c_length=5u
X142 VDD VSS cap_mim_2f0_m4m5_noshield c_width=5u c_length=5u
X143 VDD VSS cap_mim_2f0_m4m5_noshield c_width=5u c_length=5u
X144 VDD VSS cap_mim_2f0_m4m5_noshield c_width=5u c_length=5u
X145 VDD VSS cap_mim_2f0_m4m5_noshield c_width=5u c_length=5u
X146 VDD VSS cap_mim_2f0_m4m5_noshield c_width=5u c_length=5u
X147 VDD VSS cap_mim_2f0_m4m5_noshield c_width=5u c_length=5u
X148 VDD VSS cap_mim_2f0_m4m5_noshield c_width=5u c_length=5u
X149 VDD VSS cap_mim_2f0_m4m5_noshield c_width=5u c_length=5u
X150 VDD VSS cap_mim_2f0_m4m5_noshield c_width=5u c_length=5u
X151 VDD VSS cap_mim_2f0_m4m5_noshield c_width=5u c_length=5u
X152 VDD VSS cap_mim_2f0_m4m5_noshield c_width=5u c_length=5u
X153 VDD VSS cap_mim_2f0_m4m5_noshield c_width=5u c_length=5u
X154 VDD VSS cap_mim_2f0_m4m5_noshield c_width=5u c_length=5u
X155 VDD VSS cap_mim_2f0_m4m5_noshield c_width=5u c_length=5u
X156 VDD VSS cap_mim_2f0_m4m5_noshield c_width=5u c_length=5u
X157 VDD VSS cap_mim_2f0_m4m5_noshield c_width=5u c_length=5u
X158 VDD VSS cap_mim_2f0_m4m5_noshield c_width=5u c_length=5u
X159 VDD VSS cap_mim_2f0_m4m5_noshield c_width=5u c_length=5u
X160 VDD VSS cap_mim_2f0_m4m5_noshield c_width=5u c_length=5u
X161 VDD VSS cap_mim_2f0_m4m5_noshield c_width=5u c_length=5u
X162 VDD VSS cap_mim_2f0_m4m5_noshield c_width=5u c_length=5u
X163 VDD VSS cap_mim_2f0_m4m5_noshield c_width=5u c_length=5u
X164 VDD VSS cap_mim_2f0_m4m5_noshield c_width=5u c_length=5u
X165 VDD VSS cap_mim_2f0_m4m5_noshield c_width=5u c_length=5u
X166 VDD VSS cap_mim_2f0_m4m5_noshield c_width=5u c_length=5u
X167 VDD VSS cap_mim_2f0_m4m5_noshield c_width=5u c_length=5u
X168 VDD VSS cap_mim_2f0_m4m5_noshield c_width=5u c_length=5u
X169 VDD VSS cap_mim_2f0_m4m5_noshield c_width=5u c_length=5u
X170 VDD VSS cap_mim_2f0_m4m5_noshield c_width=5u c_length=5u
X171 VDD VSS cap_mim_2f0_m4m5_noshield c_width=5u c_length=5u
X172 VDD VSS cap_mim_2f0_m4m5_noshield c_width=5u c_length=5u
X173 VDD VSS cap_mim_2f0_m4m5_noshield c_width=5u c_length=5u
X174 VDD VSS cap_mim_2f0_m4m5_noshield c_width=5u c_length=5u
X175 VDD VSS cap_mim_2f0_m4m5_noshield c_width=5u c_length=5u
X176 VDD VSS cap_mim_2f0_m4m5_noshield c_width=5u c_length=5u
X177 VDD VSS cap_mim_2f0_m4m5_noshield c_width=5u c_length=5u
X178 VDD VSS cap_mim_2f0_m4m5_noshield c_width=5u c_length=5u
X179 VDD VSS cap_mim_2f0_m4m5_noshield c_width=5u c_length=5u
X180 VDD VSS cap_mim_2f0_m4m5_noshield c_width=5u c_length=5u
X181 VDD VSS cap_mim_2f0_m4m5_noshield c_width=5u c_length=5u
X182 VDD VSS cap_mim_2f0_m4m5_noshield c_width=5u c_length=5u
X183 VDD VSS cap_mim_2f0_m4m5_noshield c_width=5u c_length=5u
X184 VDD VSS cap_mim_2f0_m4m5_noshield c_width=5u c_length=5u
X185 VDD VSS cap_mim_2f0_m4m5_noshield c_width=5u c_length=5u
X186 VDD VSS cap_mim_2f0_m4m5_noshield c_width=5u c_length=5u
X187 VDD VSS cap_mim_2f0_m4m5_noshield c_width=5u c_length=5u
X188 VDD VSS cap_mim_2f0_m4m5_noshield c_width=5u c_length=5u
X189 VDD VSS cap_mim_2f0_m4m5_noshield c_width=5u c_length=5u
X190 VDD VSS cap_mim_2f0_m4m5_noshield c_width=5u c_length=5u
X191 VDD VSS cap_mim_2f0_m4m5_noshield c_width=5u c_length=5u
X192 VDD VSS cap_mim_2f0_m4m5_noshield c_width=5u c_length=5u
X193 VDD VSS cap_mim_2f0_m4m5_noshield c_width=5u c_length=5u
X194 VDD VSS cap_mim_2f0_m4m5_noshield c_width=5u c_length=5u
X195 VDD VSS cap_mim_2f0_m4m5_noshield c_width=5u c_length=5u
X196 VDD VSS cap_mim_2f0_m4m5_noshield c_width=5u c_length=5u
X197 VDD VSS cap_mim_2f0_m4m5_noshield c_width=5u c_length=5u
X198 VDD VSS cap_mim_2f0_m4m5_noshield c_width=5u c_length=5u
X199 VDD VSS cap_mim_2f0_m4m5_noshield c_width=5u c_length=5u
X200 VDD VSS cap_mim_2f0_m4m5_noshield c_width=5u c_length=5u
X201 VDD VSS cap_mim_2f0_m4m5_noshield c_width=5u c_length=5u
X202 VDD VSS cap_mim_2f0_m4m5_noshield c_width=5u c_length=5u
X203 VDD VSS cap_mim_2f0_m4m5_noshield c_width=5u c_length=5u
X204 VDD VSS cap_mim_2f0_m4m5_noshield c_width=5u c_length=5u
X205 VDD VSS cap_mim_2f0_m4m5_noshield c_width=5u c_length=5u
X206 VDD VSS cap_mim_2f0_m4m5_noshield c_width=5u c_length=5u
X207 VDD VSS cap_mim_2f0_m4m5_noshield c_width=5u c_length=5u
X208 VDD VSS cap_mim_2f0_m4m5_noshield c_width=5u c_length=5u
X209 VDD VSS cap_mim_2f0_m4m5_noshield c_width=5u c_length=5u
X210 VDD VSS cap_mim_2f0_m4m5_noshield c_width=5u c_length=5u
X211 VDD VSS cap_mim_2f0_m4m5_noshield c_width=5u c_length=5u
X212 VDD VSS cap_mim_2f0_m4m5_noshield c_width=5u c_length=5u
X213 VDD VSS cap_mim_2f0_m4m5_noshield c_width=5u c_length=5u
X214 VDD VSS cap_mim_2f0_m4m5_noshield c_width=5u c_length=5u
X215 VDD VSS cap_mim_2f0_m4m5_noshield c_width=5u c_length=5u
X216 VDD VSS cap_mim_2f0_m4m5_noshield c_width=5u c_length=5u
X217 VDD VSS cap_mim_2f0_m4m5_noshield c_width=5u c_length=5u
X218 VDD VSS cap_mim_2f0_m4m5_noshield c_width=5u c_length=5u
X219 VDD VSS cap_mim_2f0_m4m5_noshield c_width=5u c_length=5u
X220 VDD VSS cap_mim_2f0_m4m5_noshield c_width=5u c_length=5u
X221 VDD VSS cap_mim_2f0_m4m5_noshield c_width=5u c_length=5u
X222 VDD VSS cap_mim_2f0_m4m5_noshield c_width=5u c_length=5u
X223 VDD VSS cap_mim_2f0_m4m5_noshield c_width=5u c_length=5u
X224 VDD VSS cap_mim_2f0_m4m5_noshield c_width=5u c_length=5u
X225 VDD VSS cap_mim_2f0_m4m5_noshield c_width=5u c_length=5u
X226 VDD VSS cap_mim_2f0_m4m5_noshield c_width=5u c_length=5u
X227 VDD VSS cap_mim_2f0_m4m5_noshield c_width=5u c_length=5u
X228 VDD VSS cap_mim_2f0_m4m5_noshield c_width=5u c_length=5u
X229 VDD VSS cap_mim_2f0_m4m5_noshield c_width=5u c_length=5u
X230 VDD VSS cap_mim_2f0_m4m5_noshield c_width=5u c_length=5u
X231 VDD VSS cap_mim_2f0_m4m5_noshield c_width=5u c_length=5u
X232 VDD VSS cap_mim_2f0_m4m5_noshield c_width=5u c_length=5u
X233 VDD VSS cap_mim_2f0_m4m5_noshield c_width=5u c_length=5u
X234 VDD VSS cap_mim_2f0_m4m5_noshield c_width=5u c_length=5u
X235 VDD VSS cap_mim_2f0_m4m5_noshield c_width=5u c_length=5u
X236 VDD VSS cap_mim_2f0_m4m5_noshield c_width=5u c_length=5u
X237 VDD VSS cap_mim_2f0_m4m5_noshield c_width=5u c_length=5u
X238 VDD VSS cap_mim_2f0_m4m5_noshield c_width=5u c_length=5u
X239 VDD VSS cap_mim_2f0_m4m5_noshield c_width=5u c_length=5u
X240 VDD VSS cap_mim_2f0_m4m5_noshield c_width=5u c_length=5u
X241 VDD VSS cap_mim_2f0_m4m5_noshield c_width=5u c_length=5u
X242 VDD VSS cap_mim_2f0_m4m5_noshield c_width=5u c_length=5u
X243 VDD VSS cap_mim_2f0_m4m5_noshield c_width=5u c_length=5u
X244 VDD VSS cap_mim_2f0_m4m5_noshield c_width=5u c_length=5u
X245 VDD VSS cap_mim_2f0_m4m5_noshield c_width=5u c_length=5u
X246 VDD VSS cap_mim_2f0_m4m5_noshield c_width=5u c_length=5u
X247 VDD VSS cap_mim_2f0_m4m5_noshield c_width=5u c_length=5u
X248 VDD VSS cap_mim_2f0_m4m5_noshield c_width=5u c_length=5u
X249 VDD VSS cap_mim_2f0_m4m5_noshield c_width=5u c_length=5u
X250 VDD VSS cap_mim_2f0_m4m5_noshield c_width=5u c_length=5u
X251 VDD VSS cap_mim_2f0_m4m5_noshield c_width=5u c_length=5u
X252 VDD VSS cap_mim_2f0_m4m5_noshield c_width=5u c_length=5u
X253 VDD VSS cap_mim_2f0_m4m5_noshield c_width=5u c_length=5u
X254 VDD VSS cap_mim_2f0_m4m5_noshield c_width=5u c_length=5u
X255 VDD VSS cap_mim_2f0_m4m5_noshield c_width=5u c_length=5u
X256 VDD VSS cap_mim_2f0_m4m5_noshield c_width=5u c_length=5u
X257 VDD VSS cap_mim_2f0_m4m5_noshield c_width=5u c_length=5u
X258 VDD VSS cap_mim_2f0_m4m5_noshield c_width=5u c_length=5u
X259 VDD VSS cap_mim_2f0_m4m5_noshield c_width=5u c_length=5u
X260 VDD VSS cap_mim_2f0_m4m5_noshield c_width=5u c_length=5u
X261 VDD VSS cap_mim_2f0_m4m5_noshield c_width=5u c_length=5u
X262 VDD VSS cap_mim_2f0_m4m5_noshield c_width=5u c_length=5u
X263 VDD VSS cap_mim_2f0_m4m5_noshield c_width=5u c_length=5u
X264 VDD VSS cap_mim_2f0_m4m5_noshield c_width=5u c_length=5u
X265 VDD VSS cap_mim_2f0_m4m5_noshield c_width=5u c_length=5u
X266 VDD VSS cap_mim_2f0_m4m5_noshield c_width=5u c_length=5u
X267 VDD VSS cap_mim_2f0_m4m5_noshield c_width=5u c_length=5u
X268 VDD VSS cap_mim_2f0_m4m5_noshield c_width=5u c_length=5u
X269 VDD VSS cap_mim_2f0_m4m5_noshield c_width=5u c_length=5u
X270 VDD VSS cap_mim_2f0_m4m5_noshield c_width=5u c_length=5u
X271 VDD VSS cap_mim_2f0_m4m5_noshield c_width=5u c_length=5u
X272 VDD VSS cap_mim_2f0_m4m5_noshield c_width=5u c_length=5u
X273 VDD VSS cap_mim_2f0_m4m5_noshield c_width=5u c_length=5u
X274 VDD VSS cap_mim_2f0_m4m5_noshield c_width=5u c_length=5u
X275 VDD VSS cap_mim_2f0_m4m5_noshield c_width=5u c_length=5u
X276 VDD VSS cap_mim_2f0_m4m5_noshield c_width=5u c_length=5u
X277 VDD VSS cap_mim_2f0_m4m5_noshield c_width=5u c_length=5u
X278 VDD VSS cap_mim_2f0_m4m5_noshield c_width=5u c_length=5u
X279 VDD VSS cap_mim_2f0_m4m5_noshield c_width=5u c_length=5u
X280 VDD VSS cap_mim_2f0_m4m5_noshield c_width=5u c_length=5u
X281 VDD VSS cap_mim_2f0_m4m5_noshield c_width=5u c_length=5u
X282 VDD VSS cap_mim_2f0_m4m5_noshield c_width=5u c_length=5u
X283 VDD VSS cap_mim_2f0_m4m5_noshield c_width=5u c_length=5u
X284 VDD VSS cap_mim_2f0_m4m5_noshield c_width=5u c_length=5u
X285 VDD VSS cap_mim_2f0_m4m5_noshield c_width=5u c_length=5u
X286 VDD VSS cap_mim_2f0_m4m5_noshield c_width=5u c_length=5u
X287 VDD VSS cap_mim_2f0_m4m5_noshield c_width=5u c_length=5u
X288 VDD VSS cap_mim_2f0_m4m5_noshield c_width=5u c_length=5u
X289 VDD VSS cap_mim_2f0_m4m5_noshield c_width=5u c_length=5u
X290 VDD VSS cap_mim_2f0_m4m5_noshield c_width=5u c_length=5u
X291 VDD VSS cap_mim_2f0_m4m5_noshield c_width=5u c_length=5u
X292 VDD VSS cap_mim_2f0_m4m5_noshield c_width=5u c_length=5u
X293 VDD VSS cap_mim_2f0_m4m5_noshield c_width=5u c_length=5u
X294 VDD VSS cap_mim_2f0_m4m5_noshield c_width=5u c_length=5u
X295 VDD VSS cap_mim_2f0_m4m5_noshield c_width=5u c_length=5u
X296 VDD VSS cap_mim_2f0_m4m5_noshield c_width=5u c_length=5u
X297 VDD VSS cap_mim_2f0_m4m5_noshield c_width=5u c_length=5u
X298 VDD VSS cap_mim_2f0_m4m5_noshield c_width=5u c_length=5u
X299 VDD VSS cap_mim_2f0_m4m5_noshield c_width=5u c_length=5u
X300 VDD VSS cap_mim_2f0_m4m5_noshield c_width=5u c_length=5u
X301 VDD VSS cap_mim_2f0_m4m5_noshield c_width=5u c_length=5u
X302 VDD VSS cap_mim_2f0_m4m5_noshield c_width=5u c_length=5u
X303 VDD VSS cap_mim_2f0_m4m5_noshield c_width=5u c_length=5u
X304 VDD VSS cap_mim_2f0_m4m5_noshield c_width=5u c_length=5u
X305 VDD VSS cap_mim_2f0_m4m5_noshield c_width=5u c_length=5u
X306 VDD VSS cap_mim_2f0_m4m5_noshield c_width=5u c_length=5u
X307 VDD VSS cap_mim_2f0_m4m5_noshield c_width=5u c_length=5u
X308 VDD VSS cap_mim_2f0_m4m5_noshield c_width=5u c_length=5u
X309 VDD VSS cap_mim_2f0_m4m5_noshield c_width=5u c_length=5u
X310 VDD VSS cap_mim_2f0_m4m5_noshield c_width=5u c_length=5u
X311 VDD VSS cap_mim_2f0_m4m5_noshield c_width=5u c_length=5u
X312 VDD VSS cap_mim_2f0_m4m5_noshield c_width=5u c_length=5u
X313 VDD VSS cap_mim_2f0_m4m5_noshield c_width=5u c_length=5u
X314 VDD VSS cap_mim_2f0_m4m5_noshield c_width=5u c_length=5u
X315 VDD VSS cap_mim_2f0_m4m5_noshield c_width=5u c_length=5u
X316 VDD VSS cap_mim_2f0_m4m5_noshield c_width=5u c_length=5u
X317 VDD VSS cap_mim_2f0_m4m5_noshield c_width=5u c_length=5u
X318 VDD VSS cap_mim_2f0_m4m5_noshield c_width=5u c_length=5u
X319 VDD VSS cap_mim_2f0_m4m5_noshield c_width=5u c_length=5u
X320 VDD VSS cap_mim_2f0_m4m5_noshield c_width=5u c_length=5u
X321 VDD VSS cap_mim_2f0_m4m5_noshield c_width=5u c_length=5u
X322 VDD VSS cap_mim_2f0_m4m5_noshield c_width=5u c_length=5u
X323 VDD VSS cap_mim_2f0_m4m5_noshield c_width=5u c_length=5u
X324 VDD VSS cap_mim_2f0_m4m5_noshield c_width=5u c_length=5u
X325 VDD VSS cap_mim_2f0_m4m5_noshield c_width=5u c_length=5u
X326 VDD VSS cap_mim_2f0_m4m5_noshield c_width=5u c_length=5u
X327 VDD VSS cap_mim_2f0_m4m5_noshield c_width=5u c_length=5u
X328 VDD VSS cap_mim_2f0_m4m5_noshield c_width=5u c_length=5u
X329 VDD VSS cap_mim_2f0_m4m5_noshield c_width=5u c_length=5u
X330 VDD VSS cap_mim_2f0_m4m5_noshield c_width=5u c_length=5u
X331 VDD VSS cap_mim_2f0_m4m5_noshield c_width=5u c_length=5u
X332 VDD VSS cap_mim_2f0_m4m5_noshield c_width=5u c_length=5u
X333 VDD VSS cap_mim_2f0_m4m5_noshield c_width=5u c_length=5u
X334 VDD VSS cap_mim_2f0_m4m5_noshield c_width=5u c_length=5u
X335 VDD VSS cap_mim_2f0_m4m5_noshield c_width=5u c_length=5u
X336 VDD VSS cap_mim_2f0_m4m5_noshield c_width=5u c_length=5u
X337 VDD VSS cap_mim_2f0_m4m5_noshield c_width=5u c_length=5u
X338 VDD VSS cap_mim_2f0_m4m5_noshield c_width=5u c_length=5u
X339 VDD VSS cap_mim_2f0_m4m5_noshield c_width=5u c_length=5u
X340 VDD VSS cap_mim_2f0_m4m5_noshield c_width=5u c_length=5u
X341 VDD VSS cap_mim_2f0_m4m5_noshield c_width=5u c_length=5u
X342 VDD VSS cap_mim_2f0_m4m5_noshield c_width=5u c_length=5u
X343 VDD VSS cap_mim_2f0_m4m5_noshield c_width=5u c_length=5u
X344 VDD VSS cap_mim_2f0_m4m5_noshield c_width=5u c_length=5u
X345 VDD VSS cap_mim_2f0_m4m5_noshield c_width=5u c_length=5u
X346 VDD VSS cap_mim_2f0_m4m5_noshield c_width=5u c_length=5u
X347 VDD VSS cap_mim_2f0_m4m5_noshield c_width=5u c_length=5u
X348 VDD VSS cap_mim_2f0_m4m5_noshield c_width=5u c_length=5u
X349 VDD VSS cap_mim_2f0_m4m5_noshield c_width=5u c_length=5u
X350 VDD VSS cap_mim_2f0_m4m5_noshield c_width=5u c_length=5u
X351 VDD VSS cap_mim_2f0_m4m5_noshield c_width=5u c_length=5u
X352 VDD VSS cap_mim_2f0_m4m5_noshield c_width=5u c_length=5u
X353 VDD VSS cap_mim_2f0_m4m5_noshield c_width=5u c_length=5u
X354 VDD VSS cap_mim_2f0_m4m5_noshield c_width=5u c_length=5u
X355 VDD VSS cap_mim_2f0_m4m5_noshield c_width=5u c_length=5u
X356 VDD VSS cap_mim_2f0_m4m5_noshield c_width=5u c_length=5u
X357 VDD VSS cap_mim_2f0_m4m5_noshield c_width=5u c_length=5u
X358 VDD VSS cap_mim_2f0_m4m5_noshield c_width=5u c_length=5u
X359 VDD VSS cap_mim_2f0_m4m5_noshield c_width=5u c_length=5u
X360 VDD VSS cap_mim_2f0_m4m5_noshield c_width=5u c_length=5u
.ends

.subckt decap_CD1 VDD VSS
X0 VDD VSS cap_mim_2f0_m4m5_noshield c_width=5u c_length=5u
X1 VDD VSS cap_mim_2f0_m4m5_noshield c_width=5u c_length=5u
X2 VDD VSS cap_mim_2f0_m4m5_noshield c_width=5u c_length=5u
X3 VDD VSS cap_mim_2f0_m4m5_noshield c_width=5u c_length=5u
X4 VDD VSS cap_mim_2f0_m4m5_noshield c_width=5u c_length=5u
X5 VDD VSS cap_mim_2f0_m4m5_noshield c_width=5u c_length=5u
X6 VDD VSS cap_mim_2f0_m4m5_noshield c_width=5u c_length=5u
X7 VDD VSS cap_mim_2f0_m4m5_noshield c_width=5u c_length=5u
X8 VDD VSS cap_mim_2f0_m4m5_noshield c_width=5u c_length=5u
X9 VDD VSS cap_mim_2f0_m4m5_noshield c_width=5u c_length=5u
X10 VDD VSS cap_mim_2f0_m4m5_noshield c_width=5u c_length=5u
X11 VDD VSS cap_mim_2f0_m4m5_noshield c_width=5u c_length=5u
X12 VDD VSS cap_mim_2f0_m4m5_noshield c_width=5u c_length=5u
X13 VDD VSS cap_mim_2f0_m4m5_noshield c_width=5u c_length=5u
X14 VDD VSS cap_mim_2f0_m4m5_noshield c_width=5u c_length=5u
X15 VDD VSS cap_mim_2f0_m4m5_noshield c_width=5u c_length=5u
X16 VDD VSS cap_mim_2f0_m4m5_noshield c_width=5u c_length=5u
X17 VDD VSS cap_mim_2f0_m4m5_noshield c_width=5u c_length=5u
X18 VDD VSS cap_mim_2f0_m4m5_noshield c_width=5u c_length=5u
X19 VDD VSS cap_mim_2f0_m4m5_noshield c_width=5u c_length=5u
X20 VDD VSS cap_mim_2f0_m4m5_noshield c_width=5u c_length=5u
X21 VDD VSS cap_mim_2f0_m4m5_noshield c_width=5u c_length=5u
X22 VDD VSS cap_mim_2f0_m4m5_noshield c_width=5u c_length=5u
X23 VDD VSS cap_mim_2f0_m4m5_noshield c_width=5u c_length=5u
X24 VDD VSS cap_mim_2f0_m4m5_noshield c_width=5u c_length=5u
X25 VDD VSS cap_mim_2f0_m4m5_noshield c_width=5u c_length=5u
X26 VDD VSS cap_mim_2f0_m4m5_noshield c_width=5u c_length=5u
X27 VDD VSS cap_mim_2f0_m4m5_noshield c_width=5u c_length=5u
X28 VDD VSS cap_mim_2f0_m4m5_noshield c_width=5u c_length=5u
X29 VDD VSS cap_mim_2f0_m4m5_noshield c_width=5u c_length=5u
X30 VDD VSS cap_mim_2f0_m4m5_noshield c_width=5u c_length=5u
X31 VDD VSS cap_mim_2f0_m4m5_noshield c_width=5u c_length=5u
X32 VDD VSS cap_mim_2f0_m4m5_noshield c_width=5u c_length=5u
X33 VDD VSS cap_mim_2f0_m4m5_noshield c_width=5u c_length=5u
X34 VDD VSS cap_mim_2f0_m4m5_noshield c_width=5u c_length=5u
X35 VDD VSS cap_mim_2f0_m4m5_noshield c_width=5u c_length=5u
X36 VDD VSS cap_mim_2f0_m4m5_noshield c_width=5u c_length=5u
X37 VDD VSS cap_mim_2f0_m4m5_noshield c_width=5u c_length=5u
X38 VDD VSS cap_mim_2f0_m4m5_noshield c_width=5u c_length=5u
X39 VDD VSS cap_mim_2f0_m4m5_noshield c_width=5u c_length=5u
X40 VDD VSS cap_mim_2f0_m4m5_noshield c_width=5u c_length=5u
X41 VDD VSS cap_mim_2f0_m4m5_noshield c_width=5u c_length=5u
X42 VDD VSS cap_mim_2f0_m4m5_noshield c_width=5u c_length=5u
X43 VDD VSS cap_mim_2f0_m4m5_noshield c_width=5u c_length=5u
X44 VDD VSS cap_mim_2f0_m4m5_noshield c_width=5u c_length=5u
X45 VDD VSS cap_mim_2f0_m4m5_noshield c_width=5u c_length=5u
X46 VDD VSS cap_mim_2f0_m4m5_noshield c_width=5u c_length=5u
X47 VDD VSS cap_mim_2f0_m4m5_noshield c_width=5u c_length=5u
X48 VDD VSS cap_mim_2f0_m4m5_noshield c_width=5u c_length=5u
X49 VDD VSS cap_mim_2f0_m4m5_noshield c_width=5u c_length=5u
X50 VDD VSS cap_mim_2f0_m4m5_noshield c_width=5u c_length=5u
X51 VDD VSS cap_mim_2f0_m4m5_noshield c_width=5u c_length=5u
X52 VDD VSS cap_mim_2f0_m4m5_noshield c_width=5u c_length=5u
X53 VDD VSS cap_mim_2f0_m4m5_noshield c_width=5u c_length=5u
X54 VDD VSS cap_mim_2f0_m4m5_noshield c_width=5u c_length=5u
X55 VDD VSS cap_mim_2f0_m4m5_noshield c_width=5u c_length=5u
X56 VDD VSS cap_mim_2f0_m4m5_noshield c_width=5u c_length=5u
X57 VDD VSS cap_mim_2f0_m4m5_noshield c_width=5u c_length=5u
X58 VDD VSS cap_mim_2f0_m4m5_noshield c_width=5u c_length=5u
X59 VDD VSS cap_mim_2f0_m4m5_noshield c_width=5u c_length=5u
X60 VDD VSS cap_mim_2f0_m4m5_noshield c_width=5u c_length=5u
X61 VDD VSS cap_mim_2f0_m4m5_noshield c_width=5u c_length=5u
X62 VDD VSS cap_mim_2f0_m4m5_noshield c_width=5u c_length=5u
X63 VDD VSS cap_mim_2f0_m4m5_noshield c_width=5u c_length=5u
X64 VDD VSS cap_mim_2f0_m4m5_noshield c_width=5u c_length=5u
X65 VDD VSS cap_mim_2f0_m4m5_noshield c_width=5u c_length=5u
X66 VDD VSS cap_mim_2f0_m4m5_noshield c_width=5u c_length=5u
X67 VDD VSS cap_mim_2f0_m4m5_noshield c_width=5u c_length=5u
X68 VDD VSS cap_mim_2f0_m4m5_noshield c_width=5u c_length=5u
X69 VDD VSS cap_mim_2f0_m4m5_noshield c_width=5u c_length=5u
X70 VDD VSS cap_mim_2f0_m4m5_noshield c_width=5u c_length=5u
X71 VDD VSS cap_mim_2f0_m4m5_noshield c_width=5u c_length=5u
X72 VDD VSS cap_mim_2f0_m4m5_noshield c_width=5u c_length=5u
X73 VDD VSS cap_mim_2f0_m4m5_noshield c_width=5u c_length=5u
X74 VDD VSS cap_mim_2f0_m4m5_noshield c_width=5u c_length=5u
X75 VDD VSS cap_mim_2f0_m4m5_noshield c_width=5u c_length=5u
X76 VDD VSS cap_mim_2f0_m4m5_noshield c_width=5u c_length=5u
X77 VDD VSS cap_mim_2f0_m4m5_noshield c_width=5u c_length=5u
X78 VDD VSS cap_mim_2f0_m4m5_noshield c_width=5u c_length=5u
X79 VDD VSS cap_mim_2f0_m4m5_noshield c_width=5u c_length=5u
X80 VDD VSS cap_mim_2f0_m4m5_noshield c_width=5u c_length=5u
X81 VDD VSS cap_mim_2f0_m4m5_noshield c_width=5u c_length=5u
X82 VDD VSS cap_mim_2f0_m4m5_noshield c_width=5u c_length=5u
X83 VDD VSS cap_mim_2f0_m4m5_noshield c_width=5u c_length=5u
X84 VDD VSS cap_mim_2f0_m4m5_noshield c_width=5u c_length=5u
X85 VDD VSS cap_mim_2f0_m4m5_noshield c_width=5u c_length=5u
X86 VDD VSS cap_mim_2f0_m4m5_noshield c_width=5u c_length=5u
X87 VDD VSS cap_mim_2f0_m4m5_noshield c_width=5u c_length=5u
X88 VDD VSS cap_mim_2f0_m4m5_noshield c_width=5u c_length=5u
X89 VDD VSS cap_mim_2f0_m4m5_noshield c_width=5u c_length=5u
X90 VDD VSS cap_mim_2f0_m4m5_noshield c_width=5u c_length=5u
X91 VDD VSS cap_mim_2f0_m4m5_noshield c_width=5u c_length=5u
X92 VDD VSS cap_mim_2f0_m4m5_noshield c_width=5u c_length=5u
X93 VDD VSS cap_mim_2f0_m4m5_noshield c_width=5u c_length=5u
X94 VDD VSS cap_mim_2f0_m4m5_noshield c_width=5u c_length=5u
X95 VDD VSS cap_mim_2f0_m4m5_noshield c_width=5u c_length=5u
X96 VDD VSS cap_mim_2f0_m4m5_noshield c_width=5u c_length=5u
X97 VDD VSS cap_mim_2f0_m4m5_noshield c_width=5u c_length=5u
X98 VDD VSS cap_mim_2f0_m4m5_noshield c_width=5u c_length=5u
X99 VDD VSS cap_mim_2f0_m4m5_noshield c_width=5u c_length=5u
X100 VDD VSS cap_mim_2f0_m4m5_noshield c_width=5u c_length=5u
X101 VDD VSS cap_mim_2f0_m4m5_noshield c_width=5u c_length=5u
X102 VDD VSS cap_mim_2f0_m4m5_noshield c_width=5u c_length=5u
X103 VDD VSS cap_mim_2f0_m4m5_noshield c_width=5u c_length=5u
X104 VDD VSS cap_mim_2f0_m4m5_noshield c_width=5u c_length=5u
X105 VDD VSS cap_mim_2f0_m4m5_noshield c_width=5u c_length=5u
X106 VDD VSS cap_mim_2f0_m4m5_noshield c_width=5u c_length=5u
X107 VDD VSS cap_mim_2f0_m4m5_noshield c_width=5u c_length=5u
X108 VDD VSS cap_mim_2f0_m4m5_noshield c_width=5u c_length=5u
X109 VDD VSS cap_mim_2f0_m4m5_noshield c_width=5u c_length=5u
X110 VDD VSS cap_mim_2f0_m4m5_noshield c_width=5u c_length=5u
X111 VDD VSS cap_mim_2f0_m4m5_noshield c_width=5u c_length=5u
X112 VDD VSS cap_mim_2f0_m4m5_noshield c_width=5u c_length=5u
X113 VDD VSS cap_mim_2f0_m4m5_noshield c_width=5u c_length=5u
X114 VDD VSS cap_mim_2f0_m4m5_noshield c_width=5u c_length=5u
X115 VDD VSS cap_mim_2f0_m4m5_noshield c_width=5u c_length=5u
X116 VDD VSS cap_mim_2f0_m4m5_noshield c_width=5u c_length=5u
X117 VDD VSS cap_mim_2f0_m4m5_noshield c_width=5u c_length=5u
X118 VDD VSS cap_mim_2f0_m4m5_noshield c_width=5u c_length=5u
X119 VDD VSS cap_mim_2f0_m4m5_noshield c_width=5u c_length=5u
X120 VDD VSS cap_mim_2f0_m4m5_noshield c_width=5u c_length=5u
X121 VDD VSS cap_mim_2f0_m4m5_noshield c_width=5u c_length=5u
X122 VDD VSS cap_mim_2f0_m4m5_noshield c_width=5u c_length=5u
X123 VDD VSS cap_mim_2f0_m4m5_noshield c_width=5u c_length=5u
X124 VDD VSS cap_mim_2f0_m4m5_noshield c_width=5u c_length=5u
X125 VDD VSS cap_mim_2f0_m4m5_noshield c_width=5u c_length=5u
X126 VDD VSS cap_mim_2f0_m4m5_noshield c_width=5u c_length=5u
X127 VDD VSS cap_mim_2f0_m4m5_noshield c_width=5u c_length=5u
X128 VDD VSS cap_mim_2f0_m4m5_noshield c_width=5u c_length=5u
X129 VDD VSS cap_mim_2f0_m4m5_noshield c_width=5u c_length=5u
X130 VDD VSS cap_mim_2f0_m4m5_noshield c_width=5u c_length=5u
X131 VDD VSS cap_mim_2f0_m4m5_noshield c_width=5u c_length=5u
X132 VDD VSS cap_mim_2f0_m4m5_noshield c_width=5u c_length=5u
X133 VDD VSS cap_mim_2f0_m4m5_noshield c_width=5u c_length=5u
X134 VDD VSS cap_mim_2f0_m4m5_noshield c_width=5u c_length=5u
X135 VDD VSS cap_mim_2f0_m4m5_noshield c_width=5u c_length=5u
X136 VDD VSS cap_mim_2f0_m4m5_noshield c_width=5u c_length=5u
X137 VDD VSS cap_mim_2f0_m4m5_noshield c_width=5u c_length=5u
X138 VDD VSS cap_mim_2f0_m4m5_noshield c_width=5u c_length=5u
X139 VDD VSS cap_mim_2f0_m4m5_noshield c_width=5u c_length=5u
X140 VDD VSS cap_mim_2f0_m4m5_noshield c_width=5u c_length=5u
X141 VDD VSS cap_mim_2f0_m4m5_noshield c_width=5u c_length=5u
X142 VDD VSS cap_mim_2f0_m4m5_noshield c_width=5u c_length=5u
X143 VDD VSS cap_mim_2f0_m4m5_noshield c_width=5u c_length=5u
X144 VDD VSS cap_mim_2f0_m4m5_noshield c_width=5u c_length=5u
X145 VDD VSS cap_mim_2f0_m4m5_noshield c_width=5u c_length=5u
X146 VDD VSS cap_mim_2f0_m4m5_noshield c_width=5u c_length=5u
X147 VDD VSS cap_mim_2f0_m4m5_noshield c_width=5u c_length=5u
X148 VDD VSS cap_mim_2f0_m4m5_noshield c_width=5u c_length=5u
X149 VDD VSS cap_mim_2f0_m4m5_noshield c_width=5u c_length=5u
X150 VDD VSS cap_mim_2f0_m4m5_noshield c_width=5u c_length=5u
X151 VDD VSS cap_mim_2f0_m4m5_noshield c_width=5u c_length=5u
X152 VDD VSS cap_mim_2f0_m4m5_noshield c_width=5u c_length=5u
X153 VDD VSS cap_mim_2f0_m4m5_noshield c_width=5u c_length=5u
X154 VDD VSS cap_mim_2f0_m4m5_noshield c_width=5u c_length=5u
X155 VDD VSS cap_mim_2f0_m4m5_noshield c_width=5u c_length=5u
X156 VDD VSS cap_mim_2f0_m4m5_noshield c_width=5u c_length=5u
X157 VDD VSS cap_mim_2f0_m4m5_noshield c_width=5u c_length=5u
X158 VDD VSS cap_mim_2f0_m4m5_noshield c_width=5u c_length=5u
X159 VDD VSS cap_mim_2f0_m4m5_noshield c_width=5u c_length=5u
X160 VDD VSS cap_mim_2f0_m4m5_noshield c_width=5u c_length=5u
X161 VDD VSS cap_mim_2f0_m4m5_noshield c_width=5u c_length=5u
X162 VDD VSS cap_mim_2f0_m4m5_noshield c_width=5u c_length=5u
X163 VDD VSS cap_mim_2f0_m4m5_noshield c_width=5u c_length=5u
X164 VDD VSS cap_mim_2f0_m4m5_noshield c_width=5u c_length=5u
X165 VDD VSS cap_mim_2f0_m4m5_noshield c_width=5u c_length=5u
X166 VDD VSS cap_mim_2f0_m4m5_noshield c_width=5u c_length=5u
X167 VDD VSS cap_mim_2f0_m4m5_noshield c_width=5u c_length=5u
X168 VDD VSS cap_mim_2f0_m4m5_noshield c_width=5u c_length=5u
X169 VDD VSS cap_mim_2f0_m4m5_noshield c_width=5u c_length=5u
X170 VDD VSS cap_mim_2f0_m4m5_noshield c_width=5u c_length=5u
X171 VDD VSS cap_mim_2f0_m4m5_noshield c_width=5u c_length=5u
X172 VDD VSS cap_mim_2f0_m4m5_noshield c_width=5u c_length=5u
X173 VDD VSS cap_mim_2f0_m4m5_noshield c_width=5u c_length=5u
X174 VDD VSS cap_mim_2f0_m4m5_noshield c_width=5u c_length=5u
X175 VDD VSS cap_mim_2f0_m4m5_noshield c_width=5u c_length=5u
X176 VDD VSS cap_mim_2f0_m4m5_noshield c_width=5u c_length=5u
X177 VDD VSS cap_mim_2f0_m4m5_noshield c_width=5u c_length=5u
X178 VDD VSS cap_mim_2f0_m4m5_noshield c_width=5u c_length=5u
X179 VDD VSS cap_mim_2f0_m4m5_noshield c_width=5u c_length=5u
X180 VDD VSS cap_mim_2f0_m4m5_noshield c_width=5u c_length=5u
X181 VDD VSS cap_mim_2f0_m4m5_noshield c_width=5u c_length=5u
X182 VDD VSS cap_mim_2f0_m4m5_noshield c_width=5u c_length=5u
X183 VDD VSS cap_mim_2f0_m4m5_noshield c_width=5u c_length=5u
X184 VDD VSS cap_mim_2f0_m4m5_noshield c_width=5u c_length=5u
X185 VDD VSS cap_mim_2f0_m4m5_noshield c_width=5u c_length=5u
X186 VDD VSS cap_mim_2f0_m4m5_noshield c_width=5u c_length=5u
X187 VDD VSS cap_mim_2f0_m4m5_noshield c_width=5u c_length=5u
X188 VDD VSS cap_mim_2f0_m4m5_noshield c_width=5u c_length=5u
X189 VDD VSS cap_mim_2f0_m4m5_noshield c_width=5u c_length=5u
X190 VDD VSS cap_mim_2f0_m4m5_noshield c_width=5u c_length=5u
X191 VDD VSS cap_mim_2f0_m4m5_noshield c_width=5u c_length=5u
X192 VDD VSS cap_mim_2f0_m4m5_noshield c_width=5u c_length=5u
X193 VDD VSS cap_mim_2f0_m4m5_noshield c_width=5u c_length=5u
X194 VDD VSS cap_mim_2f0_m4m5_noshield c_width=5u c_length=5u
X195 VDD VSS cap_mim_2f0_m4m5_noshield c_width=5u c_length=5u
X196 VDD VSS cap_mim_2f0_m4m5_noshield c_width=5u c_length=5u
X197 VDD VSS cap_mim_2f0_m4m5_noshield c_width=5u c_length=5u
X198 VDD VSS cap_mim_2f0_m4m5_noshield c_width=5u c_length=5u
X199 VDD VSS cap_mim_2f0_m4m5_noshield c_width=5u c_length=5u
X200 VDD VSS cap_mim_2f0_m4m5_noshield c_width=5u c_length=5u
X201 VDD VSS cap_mim_2f0_m4m5_noshield c_width=5u c_length=5u
X202 VDD VSS cap_mim_2f0_m4m5_noshield c_width=5u c_length=5u
X203 VDD VSS cap_mim_2f0_m4m5_noshield c_width=5u c_length=5u
X204 VDD VSS cap_mim_2f0_m4m5_noshield c_width=5u c_length=5u
X205 VDD VSS cap_mim_2f0_m4m5_noshield c_width=5u c_length=5u
X206 VDD VSS cap_mim_2f0_m4m5_noshield c_width=5u c_length=5u
X207 VDD VSS cap_mim_2f0_m4m5_noshield c_width=5u c_length=5u
X208 VDD VSS cap_mim_2f0_m4m5_noshield c_width=5u c_length=5u
X209 VDD VSS cap_mim_2f0_m4m5_noshield c_width=5u c_length=5u
X210 VDD VSS cap_mim_2f0_m4m5_noshield c_width=5u c_length=5u
X211 VDD VSS cap_mim_2f0_m4m5_noshield c_width=5u c_length=5u
X212 VDD VSS cap_mim_2f0_m4m5_noshield c_width=5u c_length=5u
X213 VDD VSS cap_mim_2f0_m4m5_noshield c_width=5u c_length=5u
X214 VDD VSS cap_mim_2f0_m4m5_noshield c_width=5u c_length=5u
X215 VDD VSS cap_mim_2f0_m4m5_noshield c_width=5u c_length=5u
X216 VDD VSS cap_mim_2f0_m4m5_noshield c_width=5u c_length=5u
X217 VDD VSS cap_mim_2f0_m4m5_noshield c_width=5u c_length=5u
X218 VDD VSS cap_mim_2f0_m4m5_noshield c_width=5u c_length=5u
X219 VDD VSS cap_mim_2f0_m4m5_noshield c_width=5u c_length=5u
X220 VDD VSS cap_mim_2f0_m4m5_noshield c_width=5u c_length=5u
X221 VDD VSS cap_mim_2f0_m4m5_noshield c_width=5u c_length=5u
X222 VDD VSS cap_mim_2f0_m4m5_noshield c_width=5u c_length=5u
X223 VDD VSS cap_mim_2f0_m4m5_noshield c_width=5u c_length=5u
X224 VDD VSS cap_mim_2f0_m4m5_noshield c_width=5u c_length=5u
X225 VDD VSS cap_mim_2f0_m4m5_noshield c_width=5u c_length=5u
X226 VDD VSS cap_mim_2f0_m4m5_noshield c_width=5u c_length=5u
X227 VDD VSS cap_mim_2f0_m4m5_noshield c_width=5u c_length=5u
X228 VDD VSS cap_mim_2f0_m4m5_noshield c_width=5u c_length=5u
X229 VDD VSS cap_mim_2f0_m4m5_noshield c_width=5u c_length=5u
X230 VDD VSS cap_mim_2f0_m4m5_noshield c_width=5u c_length=5u
X231 VDD VSS cap_mim_2f0_m4m5_noshield c_width=5u c_length=5u
X232 VDD VSS cap_mim_2f0_m4m5_noshield c_width=5u c_length=5u
X233 VDD VSS cap_mim_2f0_m4m5_noshield c_width=5u c_length=5u
X234 VDD VSS cap_mim_2f0_m4m5_noshield c_width=5u c_length=5u
X235 VDD VSS cap_mim_2f0_m4m5_noshield c_width=5u c_length=5u
X236 VDD VSS cap_mim_2f0_m4m5_noshield c_width=5u c_length=5u
X237 VDD VSS cap_mim_2f0_m4m5_noshield c_width=5u c_length=5u
X238 VDD VSS cap_mim_2f0_m4m5_noshield c_width=5u c_length=5u
X239 VDD VSS cap_mim_2f0_m4m5_noshield c_width=5u c_length=5u
X240 VDD VSS cap_mim_2f0_m4m5_noshield c_width=5u c_length=5u
X241 VDD VSS cap_mim_2f0_m4m5_noshield c_width=5u c_length=5u
X242 VDD VSS cap_mim_2f0_m4m5_noshield c_width=5u c_length=5u
X243 VDD VSS cap_mim_2f0_m4m5_noshield c_width=5u c_length=5u
X244 VDD VSS cap_mim_2f0_m4m5_noshield c_width=5u c_length=5u
X245 VDD VSS cap_mim_2f0_m4m5_noshield c_width=5u c_length=5u
X246 VDD VSS cap_mim_2f0_m4m5_noshield c_width=5u c_length=5u
X247 VDD VSS cap_mim_2f0_m4m5_noshield c_width=5u c_length=5u
X248 VDD VSS cap_mim_2f0_m4m5_noshield c_width=5u c_length=5u
X249 VDD VSS cap_mim_2f0_m4m5_noshield c_width=5u c_length=5u
X250 VDD VSS cap_mim_2f0_m4m5_noshield c_width=5u c_length=5u
X251 VDD VSS cap_mim_2f0_m4m5_noshield c_width=5u c_length=5u
X252 VDD VSS cap_mim_2f0_m4m5_noshield c_width=5u c_length=5u
X253 VDD VSS cap_mim_2f0_m4m5_noshield c_width=5u c_length=5u
X254 VDD VSS cap_mim_2f0_m4m5_noshield c_width=5u c_length=5u
X255 VDD VSS cap_mim_2f0_m4m5_noshield c_width=5u c_length=5u
X256 VDD VSS cap_mim_2f0_m4m5_noshield c_width=5u c_length=5u
X257 VDD VSS cap_mim_2f0_m4m5_noshield c_width=5u c_length=5u
X258 VDD VSS cap_mim_2f0_m4m5_noshield c_width=5u c_length=5u
X259 VDD VSS cap_mim_2f0_m4m5_noshield c_width=5u c_length=5u
X260 VDD VSS cap_mim_2f0_m4m5_noshield c_width=5u c_length=5u
X261 VDD VSS cap_mim_2f0_m4m5_noshield c_width=5u c_length=5u
X262 VDD VSS cap_mim_2f0_m4m5_noshield c_width=5u c_length=5u
X263 VDD VSS cap_mim_2f0_m4m5_noshield c_width=5u c_length=5u
X264 VDD VSS cap_mim_2f0_m4m5_noshield c_width=5u c_length=5u
X265 VDD VSS cap_mim_2f0_m4m5_noshield c_width=5u c_length=5u
X266 VDD VSS cap_mim_2f0_m4m5_noshield c_width=5u c_length=5u
X267 VDD VSS cap_mim_2f0_m4m5_noshield c_width=5u c_length=5u
X268 VDD VSS cap_mim_2f0_m4m5_noshield c_width=5u c_length=5u
X269 VDD VSS cap_mim_2f0_m4m5_noshield c_width=5u c_length=5u
X270 VDD VSS cap_mim_2f0_m4m5_noshield c_width=5u c_length=5u
X271 VDD VSS cap_mim_2f0_m4m5_noshield c_width=5u c_length=5u
X272 VDD VSS cap_mim_2f0_m4m5_noshield c_width=5u c_length=5u
X273 VDD VSS cap_mim_2f0_m4m5_noshield c_width=5u c_length=5u
X274 VDD VSS cap_mim_2f0_m4m5_noshield c_width=5u c_length=5u
X275 VDD VSS cap_mim_2f0_m4m5_noshield c_width=5u c_length=5u
X276 VDD VSS cap_mim_2f0_m4m5_noshield c_width=5u c_length=5u
X277 VDD VSS cap_mim_2f0_m4m5_noshield c_width=5u c_length=5u
X278 VDD VSS cap_mim_2f0_m4m5_noshield c_width=5u c_length=5u
X279 VDD VSS cap_mim_2f0_m4m5_noshield c_width=5u c_length=5u
X280 VDD VSS cap_mim_2f0_m4m5_noshield c_width=5u c_length=5u
X281 VDD VSS cap_mim_2f0_m4m5_noshield c_width=5u c_length=5u
X282 VDD VSS cap_mim_2f0_m4m5_noshield c_width=5u c_length=5u
X283 VDD VSS cap_mim_2f0_m4m5_noshield c_width=5u c_length=5u
X284 VDD VSS cap_mim_2f0_m4m5_noshield c_width=5u c_length=5u
X285 VDD VSS cap_mim_2f0_m4m5_noshield c_width=5u c_length=5u
X286 VDD VSS cap_mim_2f0_m4m5_noshield c_width=5u c_length=5u
X287 VDD VSS cap_mim_2f0_m4m5_noshield c_width=5u c_length=5u
X288 VDD VSS cap_mim_2f0_m4m5_noshield c_width=5u c_length=5u
X289 VDD VSS cap_mim_2f0_m4m5_noshield c_width=5u c_length=5u
X290 VDD VSS cap_mim_2f0_m4m5_noshield c_width=5u c_length=5u
X291 VDD VSS cap_mim_2f0_m4m5_noshield c_width=5u c_length=5u
X292 VDD VSS cap_mim_2f0_m4m5_noshield c_width=5u c_length=5u
X293 VDD VSS cap_mim_2f0_m4m5_noshield c_width=5u c_length=5u
X294 VDD VSS cap_mim_2f0_m4m5_noshield c_width=5u c_length=5u
X295 VDD VSS cap_mim_2f0_m4m5_noshield c_width=5u c_length=5u
X296 VDD VSS cap_mim_2f0_m4m5_noshield c_width=5u c_length=5u
X297 VDD VSS cap_mim_2f0_m4m5_noshield c_width=5u c_length=5u
X298 VDD VSS cap_mim_2f0_m4m5_noshield c_width=5u c_length=5u
X299 VDD VSS cap_mim_2f0_m4m5_noshield c_width=5u c_length=5u
X300 VDD VSS cap_mim_2f0_m4m5_noshield c_width=5u c_length=5u
X301 VDD VSS cap_mim_2f0_m4m5_noshield c_width=5u c_length=5u
X302 VDD VSS cap_mim_2f0_m4m5_noshield c_width=5u c_length=5u
X303 VDD VSS cap_mim_2f0_m4m5_noshield c_width=5u c_length=5u
X304 VDD VSS cap_mim_2f0_m4m5_noshield c_width=5u c_length=5u
X305 VDD VSS cap_mim_2f0_m4m5_noshield c_width=5u c_length=5u
X306 VDD VSS cap_mim_2f0_m4m5_noshield c_width=5u c_length=5u
X307 VDD VSS cap_mim_2f0_m4m5_noshield c_width=5u c_length=5u
X308 VDD VSS cap_mim_2f0_m4m5_noshield c_width=5u c_length=5u
X309 VDD VSS cap_mim_2f0_m4m5_noshield c_width=5u c_length=5u
X310 VDD VSS cap_mim_2f0_m4m5_noshield c_width=5u c_length=5u
X311 VDD VSS cap_mim_2f0_m4m5_noshield c_width=5u c_length=5u
X312 VDD VSS cap_mim_2f0_m4m5_noshield c_width=5u c_length=5u
X313 VDD VSS cap_mim_2f0_m4m5_noshield c_width=5u c_length=5u
X314 VDD VSS cap_mim_2f0_m4m5_noshield c_width=5u c_length=5u
X315 VDD VSS cap_mim_2f0_m4m5_noshield c_width=5u c_length=5u
X316 VDD VSS cap_mim_2f0_m4m5_noshield c_width=5u c_length=5u
X317 VDD VSS cap_mim_2f0_m4m5_noshield c_width=5u c_length=5u
X318 VDD VSS cap_mim_2f0_m4m5_noshield c_width=5u c_length=5u
X319 VDD VSS cap_mim_2f0_m4m5_noshield c_width=5u c_length=5u
X320 VDD VSS cap_mim_2f0_m4m5_noshield c_width=5u c_length=5u
X321 VDD VSS cap_mim_2f0_m4m5_noshield c_width=5u c_length=5u
X322 VDD VSS cap_mim_2f0_m4m5_noshield c_width=5u c_length=5u
X323 VDD VSS cap_mim_2f0_m4m5_noshield c_width=5u c_length=5u
X324 VDD VSS cap_mim_2f0_m4m5_noshield c_width=5u c_length=5u
X325 VDD VSS cap_mim_2f0_m4m5_noshield c_width=5u c_length=5u
X326 VDD VSS cap_mim_2f0_m4m5_noshield c_width=5u c_length=5u
X327 VDD VSS cap_mim_2f0_m4m5_noshield c_width=5u c_length=5u
X328 VDD VSS cap_mim_2f0_m4m5_noshield c_width=5u c_length=5u
X329 VDD VSS cap_mim_2f0_m4m5_noshield c_width=5u c_length=5u
X330 VDD VSS cap_mim_2f0_m4m5_noshield c_width=5u c_length=5u
X331 VDD VSS cap_mim_2f0_m4m5_noshield c_width=5u c_length=5u
X332 VDD VSS cap_mim_2f0_m4m5_noshield c_width=5u c_length=5u
X333 VDD VSS cap_mim_2f0_m4m5_noshield c_width=5u c_length=5u
X334 VDD VSS cap_mim_2f0_m4m5_noshield c_width=5u c_length=5u
X335 VDD VSS cap_mim_2f0_m4m5_noshield c_width=5u c_length=5u
X336 VDD VSS cap_mim_2f0_m4m5_noshield c_width=5u c_length=5u
X337 VDD VSS cap_mim_2f0_m4m5_noshield c_width=5u c_length=5u
X338 VDD VSS cap_mim_2f0_m4m5_noshield c_width=5u c_length=5u
X339 VDD VSS cap_mim_2f0_m4m5_noshield c_width=5u c_length=5u
X340 VDD VSS cap_mim_2f0_m4m5_noshield c_width=5u c_length=5u
X341 VDD VSS cap_mim_2f0_m4m5_noshield c_width=5u c_length=5u
X342 VDD VSS cap_mim_2f0_m4m5_noshield c_width=5u c_length=5u
X343 VDD VSS cap_mim_2f0_m4m5_noshield c_width=5u c_length=5u
X344 VDD VSS cap_mim_2f0_m4m5_noshield c_width=5u c_length=5u
X345 VDD VSS cap_mim_2f0_m4m5_noshield c_width=5u c_length=5u
X346 VDD VSS cap_mim_2f0_m4m5_noshield c_width=5u c_length=5u
X347 VDD VSS cap_mim_2f0_m4m5_noshield c_width=5u c_length=5u
X348 VDD VSS cap_mim_2f0_m4m5_noshield c_width=5u c_length=5u
X349 VDD VSS cap_mim_2f0_m4m5_noshield c_width=5u c_length=5u
X350 VDD VSS cap_mim_2f0_m4m5_noshield c_width=5u c_length=5u
X351 VDD VSS cap_mim_2f0_m4m5_noshield c_width=5u c_length=5u
X352 VDD VSS cap_mim_2f0_m4m5_noshield c_width=5u c_length=5u
X353 VDD VSS cap_mim_2f0_m4m5_noshield c_width=5u c_length=5u
X354 VDD VSS cap_mim_2f0_m4m5_noshield c_width=5u c_length=5u
X355 VDD VSS cap_mim_2f0_m4m5_noshield c_width=5u c_length=5u
X356 VDD VSS cap_mim_2f0_m4m5_noshield c_width=5u c_length=5u
X357 VDD VSS cap_mim_2f0_m4m5_noshield c_width=5u c_length=5u
X358 VDD VSS cap_mim_2f0_m4m5_noshield c_width=5u c_length=5u
X359 VDD VSS cap_mim_2f0_m4m5_noshield c_width=5u c_length=5u
X360 VDD VSS cap_mim_2f0_m4m5_noshield c_width=5u c_length=5u
.ends

.subckt decap_CD2 VDD VSS
X0 VDD VSS cap_mim_2f0_m4m5_noshield c_width=5u c_length=5u
X1 VDD VSS cap_mim_2f0_m4m5_noshield c_width=5u c_length=5u
X2 VDD VSS cap_mim_2f0_m4m5_noshield c_width=5u c_length=5u
X3 VDD VSS cap_mim_2f0_m4m5_noshield c_width=5u c_length=5u
X4 VDD VSS cap_mim_2f0_m4m5_noshield c_width=5u c_length=5u
X5 VDD VSS cap_mim_2f0_m4m5_noshield c_width=5u c_length=5u
X6 VDD VSS cap_mim_2f0_m4m5_noshield c_width=5u c_length=5u
X7 VDD VSS cap_mim_2f0_m4m5_noshield c_width=5u c_length=5u
X8 VDD VSS cap_mim_2f0_m4m5_noshield c_width=5u c_length=5u
X9 VDD VSS cap_mim_2f0_m4m5_noshield c_width=5u c_length=5u
X10 VDD VSS cap_mim_2f0_m4m5_noshield c_width=5u c_length=5u
X11 VDD VSS cap_mim_2f0_m4m5_noshield c_width=5u c_length=5u
X12 VDD VSS cap_mim_2f0_m4m5_noshield c_width=5u c_length=5u
X13 VDD VSS cap_mim_2f0_m4m5_noshield c_width=5u c_length=5u
X14 VDD VSS cap_mim_2f0_m4m5_noshield c_width=5u c_length=5u
X15 VDD VSS cap_mim_2f0_m4m5_noshield c_width=5u c_length=5u
X16 VDD VSS cap_mim_2f0_m4m5_noshield c_width=5u c_length=5u
X17 VDD VSS cap_mim_2f0_m4m5_noshield c_width=5u c_length=5u
X18 VDD VSS cap_mim_2f0_m4m5_noshield c_width=5u c_length=5u
X19 VDD VSS cap_mim_2f0_m4m5_noshield c_width=5u c_length=5u
X20 VDD VSS cap_mim_2f0_m4m5_noshield c_width=5u c_length=5u
X21 VDD VSS cap_mim_2f0_m4m5_noshield c_width=5u c_length=5u
X22 VDD VSS cap_mim_2f0_m4m5_noshield c_width=5u c_length=5u
X23 VDD VSS cap_mim_2f0_m4m5_noshield c_width=5u c_length=5u
X24 VDD VSS cap_mim_2f0_m4m5_noshield c_width=5u c_length=5u
X25 VDD VSS cap_mim_2f0_m4m5_noshield c_width=5u c_length=5u
X26 VDD VSS cap_mim_2f0_m4m5_noshield c_width=5u c_length=5u
X27 VDD VSS cap_mim_2f0_m4m5_noshield c_width=5u c_length=5u
X28 VDD VSS cap_mim_2f0_m4m5_noshield c_width=5u c_length=5u
X29 VDD VSS cap_mim_2f0_m4m5_noshield c_width=5u c_length=5u
X30 VDD VSS cap_mim_2f0_m4m5_noshield c_width=5u c_length=5u
X31 VDD VSS cap_mim_2f0_m4m5_noshield c_width=5u c_length=5u
X32 VDD VSS cap_mim_2f0_m4m5_noshield c_width=5u c_length=5u
X33 VDD VSS cap_mim_2f0_m4m5_noshield c_width=5u c_length=5u
X34 VDD VSS cap_mim_2f0_m4m5_noshield c_width=5u c_length=5u
X35 VDD VSS cap_mim_2f0_m4m5_noshield c_width=5u c_length=5u
X36 VDD VSS cap_mim_2f0_m4m5_noshield c_width=5u c_length=5u
X37 VDD VSS cap_mim_2f0_m4m5_noshield c_width=5u c_length=5u
X38 VDD VSS cap_mim_2f0_m4m5_noshield c_width=5u c_length=5u
X39 VDD VSS cap_mim_2f0_m4m5_noshield c_width=5u c_length=5u
X40 VDD VSS cap_mim_2f0_m4m5_noshield c_width=5u c_length=5u
X41 VDD VSS cap_mim_2f0_m4m5_noshield c_width=5u c_length=5u
X42 VDD VSS cap_mim_2f0_m4m5_noshield c_width=5u c_length=5u
X43 VDD VSS cap_mim_2f0_m4m5_noshield c_width=5u c_length=5u
X44 VDD VSS cap_mim_2f0_m4m5_noshield c_width=5u c_length=5u
X45 VDD VSS cap_mim_2f0_m4m5_noshield c_width=5u c_length=5u
X46 VDD VSS cap_mim_2f0_m4m5_noshield c_width=5u c_length=5u
X47 VDD VSS cap_mim_2f0_m4m5_noshield c_width=5u c_length=5u
X48 VDD VSS cap_mim_2f0_m4m5_noshield c_width=5u c_length=5u
X49 VDD VSS cap_mim_2f0_m4m5_noshield c_width=5u c_length=5u
X50 VDD VSS cap_mim_2f0_m4m5_noshield c_width=5u c_length=5u
X51 VDD VSS cap_mim_2f0_m4m5_noshield c_width=5u c_length=5u
X52 VDD VSS cap_mim_2f0_m4m5_noshield c_width=5u c_length=5u
X53 VDD VSS cap_mim_2f0_m4m5_noshield c_width=5u c_length=5u
X54 VDD VSS cap_mim_2f0_m4m5_noshield c_width=5u c_length=5u
X55 VDD VSS cap_mim_2f0_m4m5_noshield c_width=5u c_length=5u
X56 VDD VSS cap_mim_2f0_m4m5_noshield c_width=5u c_length=5u
X57 VDD VSS cap_mim_2f0_m4m5_noshield c_width=5u c_length=5u
X58 VDD VSS cap_mim_2f0_m4m5_noshield c_width=5u c_length=5u
X59 VDD VSS cap_mim_2f0_m4m5_noshield c_width=5u c_length=5u
X60 VDD VSS cap_mim_2f0_m4m5_noshield c_width=5u c_length=5u
X61 VDD VSS cap_mim_2f0_m4m5_noshield c_width=5u c_length=5u
X62 VDD VSS cap_mim_2f0_m4m5_noshield c_width=5u c_length=5u
X63 VDD VSS cap_mim_2f0_m4m5_noshield c_width=5u c_length=5u
X64 VDD VSS cap_mim_2f0_m4m5_noshield c_width=5u c_length=5u
X65 VDD VSS cap_mim_2f0_m4m5_noshield c_width=5u c_length=5u
X66 VDD VSS cap_mim_2f0_m4m5_noshield c_width=5u c_length=5u
X67 VDD VSS cap_mim_2f0_m4m5_noshield c_width=5u c_length=5u
X68 VDD VSS cap_mim_2f0_m4m5_noshield c_width=5u c_length=5u
X69 VDD VSS cap_mim_2f0_m4m5_noshield c_width=5u c_length=5u
X70 VDD VSS cap_mim_2f0_m4m5_noshield c_width=5u c_length=5u
X71 VDD VSS cap_mim_2f0_m4m5_noshield c_width=5u c_length=5u
X72 VDD VSS cap_mim_2f0_m4m5_noshield c_width=5u c_length=5u
X73 VDD VSS cap_mim_2f0_m4m5_noshield c_width=5u c_length=5u
X74 VDD VSS cap_mim_2f0_m4m5_noshield c_width=5u c_length=5u
X75 VDD VSS cap_mim_2f0_m4m5_noshield c_width=5u c_length=5u
X76 VDD VSS cap_mim_2f0_m4m5_noshield c_width=5u c_length=5u
X77 VDD VSS cap_mim_2f0_m4m5_noshield c_width=5u c_length=5u
X78 VDD VSS cap_mim_2f0_m4m5_noshield c_width=5u c_length=5u
X79 VDD VSS cap_mim_2f0_m4m5_noshield c_width=5u c_length=5u
X80 VDD VSS cap_mim_2f0_m4m5_noshield c_width=5u c_length=5u
X81 VDD VSS cap_mim_2f0_m4m5_noshield c_width=5u c_length=5u
X82 VDD VSS cap_mim_2f0_m4m5_noshield c_width=5u c_length=5u
X83 VDD VSS cap_mim_2f0_m4m5_noshield c_width=5u c_length=5u
X84 VDD VSS cap_mim_2f0_m4m5_noshield c_width=5u c_length=5u
X85 VDD VSS cap_mim_2f0_m4m5_noshield c_width=5u c_length=5u
X86 VDD VSS cap_mim_2f0_m4m5_noshield c_width=5u c_length=5u
X87 VDD VSS cap_mim_2f0_m4m5_noshield c_width=5u c_length=5u
X88 VDD VSS cap_mim_2f0_m4m5_noshield c_width=5u c_length=5u
X89 VDD VSS cap_mim_2f0_m4m5_noshield c_width=5u c_length=5u
X90 VDD VSS cap_mim_2f0_m4m5_noshield c_width=5u c_length=5u
X91 VDD VSS cap_mim_2f0_m4m5_noshield c_width=5u c_length=5u
X92 VDD VSS cap_mim_2f0_m4m5_noshield c_width=5u c_length=5u
X93 VDD VSS cap_mim_2f0_m4m5_noshield c_width=5u c_length=5u
X94 VDD VSS cap_mim_2f0_m4m5_noshield c_width=5u c_length=5u
X95 VDD VSS cap_mim_2f0_m4m5_noshield c_width=5u c_length=5u
X96 VDD VSS cap_mim_2f0_m4m5_noshield c_width=5u c_length=5u
X97 VDD VSS cap_mim_2f0_m4m5_noshield c_width=5u c_length=5u
X98 VDD VSS cap_mim_2f0_m4m5_noshield c_width=5u c_length=5u
X99 VDD VSS cap_mim_2f0_m4m5_noshield c_width=5u c_length=5u
X100 VDD VSS cap_mim_2f0_m4m5_noshield c_width=5u c_length=5u
X101 VDD VSS cap_mim_2f0_m4m5_noshield c_width=5u c_length=5u
X102 VDD VSS cap_mim_2f0_m4m5_noshield c_width=5u c_length=5u
X103 VDD VSS cap_mim_2f0_m4m5_noshield c_width=5u c_length=5u
X104 VDD VSS cap_mim_2f0_m4m5_noshield c_width=5u c_length=5u
X105 VDD VSS cap_mim_2f0_m4m5_noshield c_width=5u c_length=5u
X106 VDD VSS cap_mim_2f0_m4m5_noshield c_width=5u c_length=5u
X107 VDD VSS cap_mim_2f0_m4m5_noshield c_width=5u c_length=5u
X108 VDD VSS cap_mim_2f0_m4m5_noshield c_width=5u c_length=5u
X109 VDD VSS cap_mim_2f0_m4m5_noshield c_width=5u c_length=5u
X110 VDD VSS cap_mim_2f0_m4m5_noshield c_width=5u c_length=5u
X111 VDD VSS cap_mim_2f0_m4m5_noshield c_width=5u c_length=5u
X112 VDD VSS cap_mim_2f0_m4m5_noshield c_width=5u c_length=5u
X113 VDD VSS cap_mim_2f0_m4m5_noshield c_width=5u c_length=5u
X114 VDD VSS cap_mim_2f0_m4m5_noshield c_width=5u c_length=5u
X115 VDD VSS cap_mim_2f0_m4m5_noshield c_width=5u c_length=5u
X116 VDD VSS cap_mim_2f0_m4m5_noshield c_width=5u c_length=5u
X117 VDD VSS cap_mim_2f0_m4m5_noshield c_width=5u c_length=5u
X118 VDD VSS cap_mim_2f0_m4m5_noshield c_width=5u c_length=5u
X119 VDD VSS cap_mim_2f0_m4m5_noshield c_width=5u c_length=5u
X120 VDD VSS cap_mim_2f0_m4m5_noshield c_width=5u c_length=5u
X121 VDD VSS cap_mim_2f0_m4m5_noshield c_width=5u c_length=5u
X122 VDD VSS cap_mim_2f0_m4m5_noshield c_width=5u c_length=5u
X123 VDD VSS cap_mim_2f0_m4m5_noshield c_width=5u c_length=5u
X124 VDD VSS cap_mim_2f0_m4m5_noshield c_width=5u c_length=5u
X125 VDD VSS cap_mim_2f0_m4m5_noshield c_width=5u c_length=5u
X126 VDD VSS cap_mim_2f0_m4m5_noshield c_width=5u c_length=5u
X127 VDD VSS cap_mim_2f0_m4m5_noshield c_width=5u c_length=5u
X128 VDD VSS cap_mim_2f0_m4m5_noshield c_width=5u c_length=5u
X129 VDD VSS cap_mim_2f0_m4m5_noshield c_width=5u c_length=5u
X130 VDD VSS cap_mim_2f0_m4m5_noshield c_width=5u c_length=5u
X131 VDD VSS cap_mim_2f0_m4m5_noshield c_width=5u c_length=5u
X132 VDD VSS cap_mim_2f0_m4m5_noshield c_width=5u c_length=5u
X133 VDD VSS cap_mim_2f0_m4m5_noshield c_width=5u c_length=5u
X134 VDD VSS cap_mim_2f0_m4m5_noshield c_width=5u c_length=5u
X135 VDD VSS cap_mim_2f0_m4m5_noshield c_width=5u c_length=5u
X136 VDD VSS cap_mim_2f0_m4m5_noshield c_width=5u c_length=5u
X137 VDD VSS cap_mim_2f0_m4m5_noshield c_width=5u c_length=5u
X138 VDD VSS cap_mim_2f0_m4m5_noshield c_width=5u c_length=5u
X139 VDD VSS cap_mim_2f0_m4m5_noshield c_width=5u c_length=5u
X140 VDD VSS cap_mim_2f0_m4m5_noshield c_width=5u c_length=5u
X141 VDD VSS cap_mim_2f0_m4m5_noshield c_width=5u c_length=5u
X142 VDD VSS cap_mim_2f0_m4m5_noshield c_width=5u c_length=5u
X143 VDD VSS cap_mim_2f0_m4m5_noshield c_width=5u c_length=5u
X144 VDD VSS cap_mim_2f0_m4m5_noshield c_width=5u c_length=5u
X145 VDD VSS cap_mim_2f0_m4m5_noshield c_width=5u c_length=5u
X146 VDD VSS cap_mim_2f0_m4m5_noshield c_width=5u c_length=5u
X147 VDD VSS cap_mim_2f0_m4m5_noshield c_width=5u c_length=5u
X148 VDD VSS cap_mim_2f0_m4m5_noshield c_width=5u c_length=5u
X149 VDD VSS cap_mim_2f0_m4m5_noshield c_width=5u c_length=5u
X150 VDD VSS cap_mim_2f0_m4m5_noshield c_width=5u c_length=5u
X151 VDD VSS cap_mim_2f0_m4m5_noshield c_width=5u c_length=5u
X152 VDD VSS cap_mim_2f0_m4m5_noshield c_width=5u c_length=5u
X153 VDD VSS cap_mim_2f0_m4m5_noshield c_width=5u c_length=5u
X154 VDD VSS cap_mim_2f0_m4m5_noshield c_width=5u c_length=5u
X155 VDD VSS cap_mim_2f0_m4m5_noshield c_width=5u c_length=5u
X156 VDD VSS cap_mim_2f0_m4m5_noshield c_width=5u c_length=5u
X157 VDD VSS cap_mim_2f0_m4m5_noshield c_width=5u c_length=5u
X158 VDD VSS cap_mim_2f0_m4m5_noshield c_width=5u c_length=5u
X159 VDD VSS cap_mim_2f0_m4m5_noshield c_width=5u c_length=5u
X160 VDD VSS cap_mim_2f0_m4m5_noshield c_width=5u c_length=5u
X161 VDD VSS cap_mim_2f0_m4m5_noshield c_width=5u c_length=5u
X162 VDD VSS cap_mim_2f0_m4m5_noshield c_width=5u c_length=5u
X163 VDD VSS cap_mim_2f0_m4m5_noshield c_width=5u c_length=5u
X164 VDD VSS cap_mim_2f0_m4m5_noshield c_width=5u c_length=5u
X165 VDD VSS cap_mim_2f0_m4m5_noshield c_width=5u c_length=5u
X166 VDD VSS cap_mim_2f0_m4m5_noshield c_width=5u c_length=5u
X167 VDD VSS cap_mim_2f0_m4m5_noshield c_width=5u c_length=5u
X168 VDD VSS cap_mim_2f0_m4m5_noshield c_width=5u c_length=5u
X169 VDD VSS cap_mim_2f0_m4m5_noshield c_width=5u c_length=5u
X170 VDD VSS cap_mim_2f0_m4m5_noshield c_width=5u c_length=5u
X171 VDD VSS cap_mim_2f0_m4m5_noshield c_width=5u c_length=5u
X172 VDD VSS cap_mim_2f0_m4m5_noshield c_width=5u c_length=5u
X173 VDD VSS cap_mim_2f0_m4m5_noshield c_width=5u c_length=5u
X174 VDD VSS cap_mim_2f0_m4m5_noshield c_width=5u c_length=5u
X175 VDD VSS cap_mim_2f0_m4m5_noshield c_width=5u c_length=5u
X176 VDD VSS cap_mim_2f0_m4m5_noshield c_width=5u c_length=5u
X177 VDD VSS cap_mim_2f0_m4m5_noshield c_width=5u c_length=5u
X178 VDD VSS cap_mim_2f0_m4m5_noshield c_width=5u c_length=5u
X179 VDD VSS cap_mim_2f0_m4m5_noshield c_width=5u c_length=5u
X180 VDD VSS cap_mim_2f0_m4m5_noshield c_width=5u c_length=5u
X181 VDD VSS cap_mim_2f0_m4m5_noshield c_width=5u c_length=5u
X182 VDD VSS cap_mim_2f0_m4m5_noshield c_width=5u c_length=5u
X183 VDD VSS cap_mim_2f0_m4m5_noshield c_width=5u c_length=5u
X184 VDD VSS cap_mim_2f0_m4m5_noshield c_width=5u c_length=5u
X185 VDD VSS cap_mim_2f0_m4m5_noshield c_width=5u c_length=5u
X186 VDD VSS cap_mim_2f0_m4m5_noshield c_width=5u c_length=5u
X187 VDD VSS cap_mim_2f0_m4m5_noshield c_width=5u c_length=5u
X188 VDD VSS cap_mim_2f0_m4m5_noshield c_width=5u c_length=5u
X189 VDD VSS cap_mim_2f0_m4m5_noshield c_width=5u c_length=5u
X190 VDD VSS cap_mim_2f0_m4m5_noshield c_width=5u c_length=5u
X191 VDD VSS cap_mim_2f0_m4m5_noshield c_width=5u c_length=5u
X192 VDD VSS cap_mim_2f0_m4m5_noshield c_width=5u c_length=5u
X193 VDD VSS cap_mim_2f0_m4m5_noshield c_width=5u c_length=5u
X194 VDD VSS cap_mim_2f0_m4m5_noshield c_width=5u c_length=5u
X195 VDD VSS cap_mim_2f0_m4m5_noshield c_width=5u c_length=5u
X196 VDD VSS cap_mim_2f0_m4m5_noshield c_width=5u c_length=5u
X197 VDD VSS cap_mim_2f0_m4m5_noshield c_width=5u c_length=5u
X198 VDD VSS cap_mim_2f0_m4m5_noshield c_width=5u c_length=5u
X199 VDD VSS cap_mim_2f0_m4m5_noshield c_width=5u c_length=5u
X200 VDD VSS cap_mim_2f0_m4m5_noshield c_width=5u c_length=5u
X201 VDD VSS cap_mim_2f0_m4m5_noshield c_width=5u c_length=5u
X202 VDD VSS cap_mim_2f0_m4m5_noshield c_width=5u c_length=5u
X203 VDD VSS cap_mim_2f0_m4m5_noshield c_width=5u c_length=5u
X204 VDD VSS cap_mim_2f0_m4m5_noshield c_width=5u c_length=5u
X205 VDD VSS cap_mim_2f0_m4m5_noshield c_width=5u c_length=5u
X206 VDD VSS cap_mim_2f0_m4m5_noshield c_width=5u c_length=5u
X207 VDD VSS cap_mim_2f0_m4m5_noshield c_width=5u c_length=5u
X208 VDD VSS cap_mim_2f0_m4m5_noshield c_width=5u c_length=5u
X209 VDD VSS cap_mim_2f0_m4m5_noshield c_width=5u c_length=5u
X210 VDD VSS cap_mim_2f0_m4m5_noshield c_width=5u c_length=5u
X211 VDD VSS cap_mim_2f0_m4m5_noshield c_width=5u c_length=5u
X212 VDD VSS cap_mim_2f0_m4m5_noshield c_width=5u c_length=5u
X213 VDD VSS cap_mim_2f0_m4m5_noshield c_width=5u c_length=5u
X214 VDD VSS cap_mim_2f0_m4m5_noshield c_width=5u c_length=5u
X215 VDD VSS cap_mim_2f0_m4m5_noshield c_width=5u c_length=5u
X216 VDD VSS cap_mim_2f0_m4m5_noshield c_width=5u c_length=5u
X217 VDD VSS cap_mim_2f0_m4m5_noshield c_width=5u c_length=5u
X218 VDD VSS cap_mim_2f0_m4m5_noshield c_width=5u c_length=5u
X219 VDD VSS cap_mim_2f0_m4m5_noshield c_width=5u c_length=5u
X220 VDD VSS cap_mim_2f0_m4m5_noshield c_width=5u c_length=5u
X221 VDD VSS cap_mim_2f0_m4m5_noshield c_width=5u c_length=5u
X222 VDD VSS cap_mim_2f0_m4m5_noshield c_width=5u c_length=5u
X223 VDD VSS cap_mim_2f0_m4m5_noshield c_width=5u c_length=5u
X224 VDD VSS cap_mim_2f0_m4m5_noshield c_width=5u c_length=5u
X225 VDD VSS cap_mim_2f0_m4m5_noshield c_width=5u c_length=5u
X226 VDD VSS cap_mim_2f0_m4m5_noshield c_width=5u c_length=5u
X227 VDD VSS cap_mim_2f0_m4m5_noshield c_width=5u c_length=5u
X228 VDD VSS cap_mim_2f0_m4m5_noshield c_width=5u c_length=5u
X229 VDD VSS cap_mim_2f0_m4m5_noshield c_width=5u c_length=5u
X230 VDD VSS cap_mim_2f0_m4m5_noshield c_width=5u c_length=5u
X231 VDD VSS cap_mim_2f0_m4m5_noshield c_width=5u c_length=5u
X232 VDD VSS cap_mim_2f0_m4m5_noshield c_width=5u c_length=5u
X233 VDD VSS cap_mim_2f0_m4m5_noshield c_width=5u c_length=5u
X234 VDD VSS cap_mim_2f0_m4m5_noshield c_width=5u c_length=5u
X235 VDD VSS cap_mim_2f0_m4m5_noshield c_width=5u c_length=5u
X236 VDD VSS cap_mim_2f0_m4m5_noshield c_width=5u c_length=5u
X237 VDD VSS cap_mim_2f0_m4m5_noshield c_width=5u c_length=5u
X238 VDD VSS cap_mim_2f0_m4m5_noshield c_width=5u c_length=5u
X239 VDD VSS cap_mim_2f0_m4m5_noshield c_width=5u c_length=5u
X240 VDD VSS cap_mim_2f0_m4m5_noshield c_width=5u c_length=5u
X241 VDD VSS cap_mim_2f0_m4m5_noshield c_width=5u c_length=5u
X242 VDD VSS cap_mim_2f0_m4m5_noshield c_width=5u c_length=5u
X243 VDD VSS cap_mim_2f0_m4m5_noshield c_width=5u c_length=5u
X244 VDD VSS cap_mim_2f0_m4m5_noshield c_width=5u c_length=5u
X245 VDD VSS cap_mim_2f0_m4m5_noshield c_width=5u c_length=5u
X246 VDD VSS cap_mim_2f0_m4m5_noshield c_width=5u c_length=5u
X247 VDD VSS cap_mim_2f0_m4m5_noshield c_width=5u c_length=5u
X248 VDD VSS cap_mim_2f0_m4m5_noshield c_width=5u c_length=5u
X249 VDD VSS cap_mim_2f0_m4m5_noshield c_width=5u c_length=5u
X250 VDD VSS cap_mim_2f0_m4m5_noshield c_width=5u c_length=5u
X251 VDD VSS cap_mim_2f0_m4m5_noshield c_width=5u c_length=5u
X252 VDD VSS cap_mim_2f0_m4m5_noshield c_width=5u c_length=5u
X253 VDD VSS cap_mim_2f0_m4m5_noshield c_width=5u c_length=5u
X254 VDD VSS cap_mim_2f0_m4m5_noshield c_width=5u c_length=5u
X255 VDD VSS cap_mim_2f0_m4m5_noshield c_width=5u c_length=5u
X256 VDD VSS cap_mim_2f0_m4m5_noshield c_width=5u c_length=5u
X257 VDD VSS cap_mim_2f0_m4m5_noshield c_width=5u c_length=5u
X258 VDD VSS cap_mim_2f0_m4m5_noshield c_width=5u c_length=5u
X259 VDD VSS cap_mim_2f0_m4m5_noshield c_width=5u c_length=5u
X260 VDD VSS cap_mim_2f0_m4m5_noshield c_width=5u c_length=5u
X261 VDD VSS cap_mim_2f0_m4m5_noshield c_width=5u c_length=5u
X262 VDD VSS cap_mim_2f0_m4m5_noshield c_width=5u c_length=5u
X263 VDD VSS cap_mim_2f0_m4m5_noshield c_width=5u c_length=5u
X264 VDD VSS cap_mim_2f0_m4m5_noshield c_width=5u c_length=5u
X265 VDD VSS cap_mim_2f0_m4m5_noshield c_width=5u c_length=5u
X266 VDD VSS cap_mim_2f0_m4m5_noshield c_width=5u c_length=5u
X267 VDD VSS cap_mim_2f0_m4m5_noshield c_width=5u c_length=5u
X268 VDD VSS cap_mim_2f0_m4m5_noshield c_width=5u c_length=5u
X269 VDD VSS cap_mim_2f0_m4m5_noshield c_width=5u c_length=5u
X270 VDD VSS cap_mim_2f0_m4m5_noshield c_width=5u c_length=5u
X271 VDD VSS cap_mim_2f0_m4m5_noshield c_width=5u c_length=5u
X272 VDD VSS cap_mim_2f0_m4m5_noshield c_width=5u c_length=5u
X273 VDD VSS cap_mim_2f0_m4m5_noshield c_width=5u c_length=5u
X274 VDD VSS cap_mim_2f0_m4m5_noshield c_width=5u c_length=5u
X275 VDD VSS cap_mim_2f0_m4m5_noshield c_width=5u c_length=5u
X276 VDD VSS cap_mim_2f0_m4m5_noshield c_width=5u c_length=5u
X277 VDD VSS cap_mim_2f0_m4m5_noshield c_width=5u c_length=5u
X278 VDD VSS cap_mim_2f0_m4m5_noshield c_width=5u c_length=5u
X279 VDD VSS cap_mim_2f0_m4m5_noshield c_width=5u c_length=5u
X280 VDD VSS cap_mim_2f0_m4m5_noshield c_width=5u c_length=5u
X281 VDD VSS cap_mim_2f0_m4m5_noshield c_width=5u c_length=5u
X282 VDD VSS cap_mim_2f0_m4m5_noshield c_width=5u c_length=5u
X283 VDD VSS cap_mim_2f0_m4m5_noshield c_width=5u c_length=5u
X284 VDD VSS cap_mim_2f0_m4m5_noshield c_width=5u c_length=5u
X285 VDD VSS cap_mim_2f0_m4m5_noshield c_width=5u c_length=5u
X286 VDD VSS cap_mim_2f0_m4m5_noshield c_width=5u c_length=5u
X287 VDD VSS cap_mim_2f0_m4m5_noshield c_width=5u c_length=5u
X288 VDD VSS cap_mim_2f0_m4m5_noshield c_width=5u c_length=5u
X289 VDD VSS cap_mim_2f0_m4m5_noshield c_width=5u c_length=5u
X290 VDD VSS cap_mim_2f0_m4m5_noshield c_width=5u c_length=5u
X291 VDD VSS cap_mim_2f0_m4m5_noshield c_width=5u c_length=5u
X292 VDD VSS cap_mim_2f0_m4m5_noshield c_width=5u c_length=5u
X293 VDD VSS cap_mim_2f0_m4m5_noshield c_width=5u c_length=5u
X294 VDD VSS cap_mim_2f0_m4m5_noshield c_width=5u c_length=5u
X295 VDD VSS cap_mim_2f0_m4m5_noshield c_width=5u c_length=5u
X296 VDD VSS cap_mim_2f0_m4m5_noshield c_width=5u c_length=5u
X297 VDD VSS cap_mim_2f0_m4m5_noshield c_width=5u c_length=5u
X298 VDD VSS cap_mim_2f0_m4m5_noshield c_width=5u c_length=5u
X299 VDD VSS cap_mim_2f0_m4m5_noshield c_width=5u c_length=5u
X300 VDD VSS cap_mim_2f0_m4m5_noshield c_width=5u c_length=5u
X301 VDD VSS cap_mim_2f0_m4m5_noshield c_width=5u c_length=5u
X302 VDD VSS cap_mim_2f0_m4m5_noshield c_width=5u c_length=5u
X303 VDD VSS cap_mim_2f0_m4m5_noshield c_width=5u c_length=5u
X304 VDD VSS cap_mim_2f0_m4m5_noshield c_width=5u c_length=5u
X305 VDD VSS cap_mim_2f0_m4m5_noshield c_width=5u c_length=5u
X306 VDD VSS cap_mim_2f0_m4m5_noshield c_width=5u c_length=5u
X307 VDD VSS cap_mim_2f0_m4m5_noshield c_width=5u c_length=5u
X308 VDD VSS cap_mim_2f0_m4m5_noshield c_width=5u c_length=5u
X309 VDD VSS cap_mim_2f0_m4m5_noshield c_width=5u c_length=5u
X310 VDD VSS cap_mim_2f0_m4m5_noshield c_width=5u c_length=5u
X311 VDD VSS cap_mim_2f0_m4m5_noshield c_width=5u c_length=5u
X312 VDD VSS cap_mim_2f0_m4m5_noshield c_width=5u c_length=5u
X313 VDD VSS cap_mim_2f0_m4m5_noshield c_width=5u c_length=5u
X314 VDD VSS cap_mim_2f0_m4m5_noshield c_width=5u c_length=5u
X315 VDD VSS cap_mim_2f0_m4m5_noshield c_width=5u c_length=5u
X316 VDD VSS cap_mim_2f0_m4m5_noshield c_width=5u c_length=5u
X317 VDD VSS cap_mim_2f0_m4m5_noshield c_width=5u c_length=5u
X318 VDD VSS cap_mim_2f0_m4m5_noshield c_width=5u c_length=5u
X319 VDD VSS cap_mim_2f0_m4m5_noshield c_width=5u c_length=5u
X320 VDD VSS cap_mim_2f0_m4m5_noshield c_width=5u c_length=5u
X321 VDD VSS cap_mim_2f0_m4m5_noshield c_width=5u c_length=5u
X322 VDD VSS cap_mim_2f0_m4m5_noshield c_width=5u c_length=5u
X323 VDD VSS cap_mim_2f0_m4m5_noshield c_width=5u c_length=5u
X324 VDD VSS cap_mim_2f0_m4m5_noshield c_width=5u c_length=5u
X325 VDD VSS cap_mim_2f0_m4m5_noshield c_width=5u c_length=5u
X326 VDD VSS cap_mim_2f0_m4m5_noshield c_width=5u c_length=5u
X327 VDD VSS cap_mim_2f0_m4m5_noshield c_width=5u c_length=5u
X328 VDD VSS cap_mim_2f0_m4m5_noshield c_width=5u c_length=5u
X329 VDD VSS cap_mim_2f0_m4m5_noshield c_width=5u c_length=5u
X330 VDD VSS cap_mim_2f0_m4m5_noshield c_width=5u c_length=5u
X331 VDD VSS cap_mim_2f0_m4m5_noshield c_width=5u c_length=5u
X332 VDD VSS cap_mim_2f0_m4m5_noshield c_width=5u c_length=5u
X333 VDD VSS cap_mim_2f0_m4m5_noshield c_width=5u c_length=5u
X334 VDD VSS cap_mim_2f0_m4m5_noshield c_width=5u c_length=5u
X335 VDD VSS cap_mim_2f0_m4m5_noshield c_width=5u c_length=5u
X336 VDD VSS cap_mim_2f0_m4m5_noshield c_width=5u c_length=5u
X337 VDD VSS cap_mim_2f0_m4m5_noshield c_width=5u c_length=5u
X338 VDD VSS cap_mim_2f0_m4m5_noshield c_width=5u c_length=5u
X339 VDD VSS cap_mim_2f0_m4m5_noshield c_width=5u c_length=5u
X340 VDD VSS cap_mim_2f0_m4m5_noshield c_width=5u c_length=5u
X341 VDD VSS cap_mim_2f0_m4m5_noshield c_width=5u c_length=5u
X342 VDD VSS cap_mim_2f0_m4m5_noshield c_width=5u c_length=5u
X343 VDD VSS cap_mim_2f0_m4m5_noshield c_width=5u c_length=5u
X344 VDD VSS cap_mim_2f0_m4m5_noshield c_width=5u c_length=5u
X345 VDD VSS cap_mim_2f0_m4m5_noshield c_width=5u c_length=5u
X346 VDD VSS cap_mim_2f0_m4m5_noshield c_width=5u c_length=5u
X347 VDD VSS cap_mim_2f0_m4m5_noshield c_width=5u c_length=5u
X348 VDD VSS cap_mim_2f0_m4m5_noshield c_width=5u c_length=5u
X349 VDD VSS cap_mim_2f0_m4m5_noshield c_width=5u c_length=5u
X350 VDD VSS cap_mim_2f0_m4m5_noshield c_width=5u c_length=5u
X351 VDD VSS cap_mim_2f0_m4m5_noshield c_width=5u c_length=5u
X352 VDD VSS cap_mim_2f0_m4m5_noshield c_width=5u c_length=5u
X353 VDD VSS cap_mim_2f0_m4m5_noshield c_width=5u c_length=5u
X354 VDD VSS cap_mim_2f0_m4m5_noshield c_width=5u c_length=5u
X355 VDD VSS cap_mim_2f0_m4m5_noshield c_width=5u c_length=5u
X356 VDD VSS cap_mim_2f0_m4m5_noshield c_width=5u c_length=5u
X357 VDD VSS cap_mim_2f0_m4m5_noshield c_width=5u c_length=5u
X358 VDD VSS cap_mim_2f0_m4m5_noshield c_width=5u c_length=5u
X359 VDD VSS cap_mim_2f0_m4m5_noshield c_width=5u c_length=5u
X360 VDD VSS cap_mim_2f0_m4m5_noshield c_width=5u c_length=5u
.ends

.subckt decap_CD3 VDD VSS
X0 VDD VSS cap_mim_2f0_m4m5_noshield c_width=5u c_length=5u
X1 VDD VSS cap_mim_2f0_m4m5_noshield c_width=5u c_length=5u
X2 VDD VSS cap_mim_2f0_m4m5_noshield c_width=5u c_length=5u
X3 VDD VSS cap_mim_2f0_m4m5_noshield c_width=5u c_length=5u
X4 VDD VSS cap_mim_2f0_m4m5_noshield c_width=5u c_length=5u
X5 VDD VSS cap_mim_2f0_m4m5_noshield c_width=5u c_length=5u
X6 VDD VSS cap_mim_2f0_m4m5_noshield c_width=5u c_length=5u
X7 VDD VSS cap_mim_2f0_m4m5_noshield c_width=5u c_length=5u
X8 VDD VSS cap_mim_2f0_m4m5_noshield c_width=5u c_length=5u
X9 VDD VSS cap_mim_2f0_m4m5_noshield c_width=5u c_length=5u
X10 VDD VSS cap_mim_2f0_m4m5_noshield c_width=5u c_length=5u
X11 VDD VSS cap_mim_2f0_m4m5_noshield c_width=5u c_length=5u
X12 VDD VSS cap_mim_2f0_m4m5_noshield c_width=5u c_length=5u
X13 VDD VSS cap_mim_2f0_m4m5_noshield c_width=5u c_length=5u
X14 VDD VSS cap_mim_2f0_m4m5_noshield c_width=5u c_length=5u
X15 VDD VSS cap_mim_2f0_m4m5_noshield c_width=5u c_length=5u
X16 VDD VSS cap_mim_2f0_m4m5_noshield c_width=5u c_length=5u
X17 VDD VSS cap_mim_2f0_m4m5_noshield c_width=5u c_length=5u
X18 VDD VSS cap_mim_2f0_m4m5_noshield c_width=5u c_length=5u
X19 VDD VSS cap_mim_2f0_m4m5_noshield c_width=5u c_length=5u
X20 VDD VSS cap_mim_2f0_m4m5_noshield c_width=5u c_length=5u
X21 VDD VSS cap_mim_2f0_m4m5_noshield c_width=5u c_length=5u
X22 VDD VSS cap_mim_2f0_m4m5_noshield c_width=5u c_length=5u
X23 VDD VSS cap_mim_2f0_m4m5_noshield c_width=5u c_length=5u
X24 VDD VSS cap_mim_2f0_m4m5_noshield c_width=5u c_length=5u
X25 VDD VSS cap_mim_2f0_m4m5_noshield c_width=5u c_length=5u
X26 VDD VSS cap_mim_2f0_m4m5_noshield c_width=5u c_length=5u
X27 VDD VSS cap_mim_2f0_m4m5_noshield c_width=5u c_length=5u
X28 VDD VSS cap_mim_2f0_m4m5_noshield c_width=5u c_length=5u
X29 VDD VSS cap_mim_2f0_m4m5_noshield c_width=5u c_length=5u
X30 VDD VSS cap_mim_2f0_m4m5_noshield c_width=5u c_length=5u
X31 VDD VSS cap_mim_2f0_m4m5_noshield c_width=5u c_length=5u
X32 VDD VSS cap_mim_2f0_m4m5_noshield c_width=5u c_length=5u
X33 VDD VSS cap_mim_2f0_m4m5_noshield c_width=5u c_length=5u
X34 VDD VSS cap_mim_2f0_m4m5_noshield c_width=5u c_length=5u
X35 VDD VSS cap_mim_2f0_m4m5_noshield c_width=5u c_length=5u
X36 VDD VSS cap_mim_2f0_m4m5_noshield c_width=5u c_length=5u
X37 VDD VSS cap_mim_2f0_m4m5_noshield c_width=5u c_length=5u
X38 VDD VSS cap_mim_2f0_m4m5_noshield c_width=5u c_length=5u
X39 VDD VSS cap_mim_2f0_m4m5_noshield c_width=5u c_length=5u
X40 VDD VSS cap_mim_2f0_m4m5_noshield c_width=5u c_length=5u
X41 VDD VSS cap_mim_2f0_m4m5_noshield c_width=5u c_length=5u
X42 VDD VSS cap_mim_2f0_m4m5_noshield c_width=5u c_length=5u
X43 VDD VSS cap_mim_2f0_m4m5_noshield c_width=5u c_length=5u
X44 VDD VSS cap_mim_2f0_m4m5_noshield c_width=5u c_length=5u
X45 VDD VSS cap_mim_2f0_m4m5_noshield c_width=5u c_length=5u
X46 VDD VSS cap_mim_2f0_m4m5_noshield c_width=5u c_length=5u
X47 VDD VSS cap_mim_2f0_m4m5_noshield c_width=5u c_length=5u
X48 VDD VSS cap_mim_2f0_m4m5_noshield c_width=5u c_length=5u
X49 VDD VSS cap_mim_2f0_m4m5_noshield c_width=5u c_length=5u
X50 VDD VSS cap_mim_2f0_m4m5_noshield c_width=5u c_length=5u
X51 VDD VSS cap_mim_2f0_m4m5_noshield c_width=5u c_length=5u
X52 VDD VSS cap_mim_2f0_m4m5_noshield c_width=5u c_length=5u
X53 VDD VSS cap_mim_2f0_m4m5_noshield c_width=5u c_length=5u
X54 VDD VSS cap_mim_2f0_m4m5_noshield c_width=5u c_length=5u
X55 VDD VSS cap_mim_2f0_m4m5_noshield c_width=5u c_length=5u
X56 VDD VSS cap_mim_2f0_m4m5_noshield c_width=5u c_length=5u
X57 VDD VSS cap_mim_2f0_m4m5_noshield c_width=5u c_length=5u
X58 VDD VSS cap_mim_2f0_m4m5_noshield c_width=5u c_length=5u
X59 VDD VSS cap_mim_2f0_m4m5_noshield c_width=5u c_length=5u
X60 VDD VSS cap_mim_2f0_m4m5_noshield c_width=5u c_length=5u
X61 VDD VSS cap_mim_2f0_m4m5_noshield c_width=5u c_length=5u
X62 VDD VSS cap_mim_2f0_m4m5_noshield c_width=5u c_length=5u
X63 VDD VSS cap_mim_2f0_m4m5_noshield c_width=5u c_length=5u
X64 VDD VSS cap_mim_2f0_m4m5_noshield c_width=5u c_length=5u
X65 VDD VSS cap_mim_2f0_m4m5_noshield c_width=5u c_length=5u
X66 VDD VSS cap_mim_2f0_m4m5_noshield c_width=5u c_length=5u
X67 VDD VSS cap_mim_2f0_m4m5_noshield c_width=5u c_length=5u
X68 VDD VSS cap_mim_2f0_m4m5_noshield c_width=5u c_length=5u
X69 VDD VSS cap_mim_2f0_m4m5_noshield c_width=5u c_length=5u
X70 VDD VSS cap_mim_2f0_m4m5_noshield c_width=5u c_length=5u
X71 VDD VSS cap_mim_2f0_m4m5_noshield c_width=5u c_length=5u
X72 VDD VSS cap_mim_2f0_m4m5_noshield c_width=5u c_length=5u
X73 VDD VSS cap_mim_2f0_m4m5_noshield c_width=5u c_length=5u
X74 VDD VSS cap_mim_2f0_m4m5_noshield c_width=5u c_length=5u
X75 VDD VSS cap_mim_2f0_m4m5_noshield c_width=5u c_length=5u
X76 VDD VSS cap_mim_2f0_m4m5_noshield c_width=5u c_length=5u
X77 VDD VSS cap_mim_2f0_m4m5_noshield c_width=5u c_length=5u
X78 VDD VSS cap_mim_2f0_m4m5_noshield c_width=5u c_length=5u
X79 VDD VSS cap_mim_2f0_m4m5_noshield c_width=5u c_length=5u
X80 VDD VSS cap_mim_2f0_m4m5_noshield c_width=5u c_length=5u
X81 VDD VSS cap_mim_2f0_m4m5_noshield c_width=5u c_length=5u
X82 VDD VSS cap_mim_2f0_m4m5_noshield c_width=5u c_length=5u
X83 VDD VSS cap_mim_2f0_m4m5_noshield c_width=5u c_length=5u
X84 VDD VSS cap_mim_2f0_m4m5_noshield c_width=5u c_length=5u
X85 VDD VSS cap_mim_2f0_m4m5_noshield c_width=5u c_length=5u
X86 VDD VSS cap_mim_2f0_m4m5_noshield c_width=5u c_length=5u
X87 VDD VSS cap_mim_2f0_m4m5_noshield c_width=5u c_length=5u
X88 VDD VSS cap_mim_2f0_m4m5_noshield c_width=5u c_length=5u
X89 VDD VSS cap_mim_2f0_m4m5_noshield c_width=5u c_length=5u
X90 VDD VSS cap_mim_2f0_m4m5_noshield c_width=5u c_length=5u
X91 VDD VSS cap_mim_2f0_m4m5_noshield c_width=5u c_length=5u
X92 VDD VSS cap_mim_2f0_m4m5_noshield c_width=5u c_length=5u
X93 VDD VSS cap_mim_2f0_m4m5_noshield c_width=5u c_length=5u
X94 VDD VSS cap_mim_2f0_m4m5_noshield c_width=5u c_length=5u
X95 VDD VSS cap_mim_2f0_m4m5_noshield c_width=5u c_length=5u
X96 VDD VSS cap_mim_2f0_m4m5_noshield c_width=5u c_length=5u
X97 VDD VSS cap_mim_2f0_m4m5_noshield c_width=5u c_length=5u
X98 VDD VSS cap_mim_2f0_m4m5_noshield c_width=5u c_length=5u
X99 VDD VSS cap_mim_2f0_m4m5_noshield c_width=5u c_length=5u
X100 VDD VSS cap_mim_2f0_m4m5_noshield c_width=5u c_length=5u
X101 VDD VSS cap_mim_2f0_m4m5_noshield c_width=5u c_length=5u
X102 VDD VSS cap_mim_2f0_m4m5_noshield c_width=5u c_length=5u
X103 VDD VSS cap_mim_2f0_m4m5_noshield c_width=5u c_length=5u
X104 VDD VSS cap_mim_2f0_m4m5_noshield c_width=5u c_length=5u
X105 VDD VSS cap_mim_2f0_m4m5_noshield c_width=5u c_length=5u
X106 VDD VSS cap_mim_2f0_m4m5_noshield c_width=5u c_length=5u
X107 VDD VSS cap_mim_2f0_m4m5_noshield c_width=5u c_length=5u
X108 VDD VSS cap_mim_2f0_m4m5_noshield c_width=5u c_length=5u
X109 VDD VSS cap_mim_2f0_m4m5_noshield c_width=5u c_length=5u
X110 VDD VSS cap_mim_2f0_m4m5_noshield c_width=5u c_length=5u
X111 VDD VSS cap_mim_2f0_m4m5_noshield c_width=5u c_length=5u
X112 VDD VSS cap_mim_2f0_m4m5_noshield c_width=5u c_length=5u
X113 VDD VSS cap_mim_2f0_m4m5_noshield c_width=5u c_length=5u
X114 VDD VSS cap_mim_2f0_m4m5_noshield c_width=5u c_length=5u
X115 VDD VSS cap_mim_2f0_m4m5_noshield c_width=5u c_length=5u
X116 VDD VSS cap_mim_2f0_m4m5_noshield c_width=5u c_length=5u
X117 VDD VSS cap_mim_2f0_m4m5_noshield c_width=5u c_length=5u
X118 VDD VSS cap_mim_2f0_m4m5_noshield c_width=5u c_length=5u
X119 VDD VSS cap_mim_2f0_m4m5_noshield c_width=5u c_length=5u
X120 VDD VSS cap_mim_2f0_m4m5_noshield c_width=5u c_length=5u
X121 VDD VSS cap_mim_2f0_m4m5_noshield c_width=5u c_length=5u
X122 VDD VSS cap_mim_2f0_m4m5_noshield c_width=5u c_length=5u
X123 VDD VSS cap_mim_2f0_m4m5_noshield c_width=5u c_length=5u
X124 VDD VSS cap_mim_2f0_m4m5_noshield c_width=5u c_length=5u
X125 VDD VSS cap_mim_2f0_m4m5_noshield c_width=5u c_length=5u
X126 VDD VSS cap_mim_2f0_m4m5_noshield c_width=5u c_length=5u
X127 VDD VSS cap_mim_2f0_m4m5_noshield c_width=5u c_length=5u
X128 VDD VSS cap_mim_2f0_m4m5_noshield c_width=5u c_length=5u
X129 VDD VSS cap_mim_2f0_m4m5_noshield c_width=5u c_length=5u
X130 VDD VSS cap_mim_2f0_m4m5_noshield c_width=5u c_length=5u
X131 VDD VSS cap_mim_2f0_m4m5_noshield c_width=5u c_length=5u
X132 VDD VSS cap_mim_2f0_m4m5_noshield c_width=5u c_length=5u
X133 VDD VSS cap_mim_2f0_m4m5_noshield c_width=5u c_length=5u
X134 VDD VSS cap_mim_2f0_m4m5_noshield c_width=5u c_length=5u
X135 VDD VSS cap_mim_2f0_m4m5_noshield c_width=5u c_length=5u
X136 VDD VSS cap_mim_2f0_m4m5_noshield c_width=5u c_length=5u
X137 VDD VSS cap_mim_2f0_m4m5_noshield c_width=5u c_length=5u
X138 VDD VSS cap_mim_2f0_m4m5_noshield c_width=5u c_length=5u
X139 VDD VSS cap_mim_2f0_m4m5_noshield c_width=5u c_length=5u
X140 VDD VSS cap_mim_2f0_m4m5_noshield c_width=5u c_length=5u
X141 VDD VSS cap_mim_2f0_m4m5_noshield c_width=5u c_length=5u
X142 VDD VSS cap_mim_2f0_m4m5_noshield c_width=5u c_length=5u
X143 VDD VSS cap_mim_2f0_m4m5_noshield c_width=5u c_length=5u
X144 VDD VSS cap_mim_2f0_m4m5_noshield c_width=5u c_length=5u
X145 VDD VSS cap_mim_2f0_m4m5_noshield c_width=5u c_length=5u
X146 VDD VSS cap_mim_2f0_m4m5_noshield c_width=5u c_length=5u
X147 VDD VSS cap_mim_2f0_m4m5_noshield c_width=5u c_length=5u
X148 VDD VSS cap_mim_2f0_m4m5_noshield c_width=5u c_length=5u
X149 VDD VSS cap_mim_2f0_m4m5_noshield c_width=5u c_length=5u
X150 VDD VSS cap_mim_2f0_m4m5_noshield c_width=5u c_length=5u
X151 VDD VSS cap_mim_2f0_m4m5_noshield c_width=5u c_length=5u
X152 VDD VSS cap_mim_2f0_m4m5_noshield c_width=5u c_length=5u
X153 VDD VSS cap_mim_2f0_m4m5_noshield c_width=5u c_length=5u
X154 VDD VSS cap_mim_2f0_m4m5_noshield c_width=5u c_length=5u
X155 VDD VSS cap_mim_2f0_m4m5_noshield c_width=5u c_length=5u
X156 VDD VSS cap_mim_2f0_m4m5_noshield c_width=5u c_length=5u
X157 VDD VSS cap_mim_2f0_m4m5_noshield c_width=5u c_length=5u
X158 VDD VSS cap_mim_2f0_m4m5_noshield c_width=5u c_length=5u
X159 VDD VSS cap_mim_2f0_m4m5_noshield c_width=5u c_length=5u
X160 VDD VSS cap_mim_2f0_m4m5_noshield c_width=5u c_length=5u
X161 VDD VSS cap_mim_2f0_m4m5_noshield c_width=5u c_length=5u
X162 VDD VSS cap_mim_2f0_m4m5_noshield c_width=5u c_length=5u
X163 VDD VSS cap_mim_2f0_m4m5_noshield c_width=5u c_length=5u
X164 VDD VSS cap_mim_2f0_m4m5_noshield c_width=5u c_length=5u
X165 VDD VSS cap_mim_2f0_m4m5_noshield c_width=5u c_length=5u
X166 VDD VSS cap_mim_2f0_m4m5_noshield c_width=5u c_length=5u
X167 VDD VSS cap_mim_2f0_m4m5_noshield c_width=5u c_length=5u
X168 VDD VSS cap_mim_2f0_m4m5_noshield c_width=5u c_length=5u
X169 VDD VSS cap_mim_2f0_m4m5_noshield c_width=5u c_length=5u
X170 VDD VSS cap_mim_2f0_m4m5_noshield c_width=5u c_length=5u
X171 VDD VSS cap_mim_2f0_m4m5_noshield c_width=5u c_length=5u
X172 VDD VSS cap_mim_2f0_m4m5_noshield c_width=5u c_length=5u
X173 VDD VSS cap_mim_2f0_m4m5_noshield c_width=5u c_length=5u
X174 VDD VSS cap_mim_2f0_m4m5_noshield c_width=5u c_length=5u
X175 VDD VSS cap_mim_2f0_m4m5_noshield c_width=5u c_length=5u
X176 VDD VSS cap_mim_2f0_m4m5_noshield c_width=5u c_length=5u
X177 VDD VSS cap_mim_2f0_m4m5_noshield c_width=5u c_length=5u
X178 VDD VSS cap_mim_2f0_m4m5_noshield c_width=5u c_length=5u
X179 VDD VSS cap_mim_2f0_m4m5_noshield c_width=5u c_length=5u
X180 VDD VSS cap_mim_2f0_m4m5_noshield c_width=5u c_length=5u
X181 VDD VSS cap_mim_2f0_m4m5_noshield c_width=5u c_length=5u
X182 VDD VSS cap_mim_2f0_m4m5_noshield c_width=5u c_length=5u
X183 VDD VSS cap_mim_2f0_m4m5_noshield c_width=5u c_length=5u
X184 VDD VSS cap_mim_2f0_m4m5_noshield c_width=5u c_length=5u
X185 VDD VSS cap_mim_2f0_m4m5_noshield c_width=5u c_length=5u
X186 VDD VSS cap_mim_2f0_m4m5_noshield c_width=5u c_length=5u
X187 VDD VSS cap_mim_2f0_m4m5_noshield c_width=5u c_length=5u
X188 VDD VSS cap_mim_2f0_m4m5_noshield c_width=5u c_length=5u
X189 VDD VSS cap_mim_2f0_m4m5_noshield c_width=5u c_length=5u
X190 VDD VSS cap_mim_2f0_m4m5_noshield c_width=5u c_length=5u
X191 VDD VSS cap_mim_2f0_m4m5_noshield c_width=5u c_length=5u
X192 VDD VSS cap_mim_2f0_m4m5_noshield c_width=5u c_length=5u
X193 VDD VSS cap_mim_2f0_m4m5_noshield c_width=5u c_length=5u
X194 VDD VSS cap_mim_2f0_m4m5_noshield c_width=5u c_length=5u
X195 VDD VSS cap_mim_2f0_m4m5_noshield c_width=5u c_length=5u
X196 VDD VSS cap_mim_2f0_m4m5_noshield c_width=5u c_length=5u
X197 VDD VSS cap_mim_2f0_m4m5_noshield c_width=5u c_length=5u
X198 VDD VSS cap_mim_2f0_m4m5_noshield c_width=5u c_length=5u
X199 VDD VSS cap_mim_2f0_m4m5_noshield c_width=5u c_length=5u
X200 VDD VSS cap_mim_2f0_m4m5_noshield c_width=5u c_length=5u
X201 VDD VSS cap_mim_2f0_m4m5_noshield c_width=5u c_length=5u
X202 VDD VSS cap_mim_2f0_m4m5_noshield c_width=5u c_length=5u
X203 VDD VSS cap_mim_2f0_m4m5_noshield c_width=5u c_length=5u
X204 VDD VSS cap_mim_2f0_m4m5_noshield c_width=5u c_length=5u
X205 VDD VSS cap_mim_2f0_m4m5_noshield c_width=5u c_length=5u
X206 VDD VSS cap_mim_2f0_m4m5_noshield c_width=5u c_length=5u
X207 VDD VSS cap_mim_2f0_m4m5_noshield c_width=5u c_length=5u
X208 VDD VSS cap_mim_2f0_m4m5_noshield c_width=5u c_length=5u
X209 VDD VSS cap_mim_2f0_m4m5_noshield c_width=5u c_length=5u
X210 VDD VSS cap_mim_2f0_m4m5_noshield c_width=5u c_length=5u
X211 VDD VSS cap_mim_2f0_m4m5_noshield c_width=5u c_length=5u
X212 VDD VSS cap_mim_2f0_m4m5_noshield c_width=5u c_length=5u
X213 VDD VSS cap_mim_2f0_m4m5_noshield c_width=5u c_length=5u
X214 VDD VSS cap_mim_2f0_m4m5_noshield c_width=5u c_length=5u
X215 VDD VSS cap_mim_2f0_m4m5_noshield c_width=5u c_length=5u
X216 VDD VSS cap_mim_2f0_m4m5_noshield c_width=5u c_length=5u
X217 VDD VSS cap_mim_2f0_m4m5_noshield c_width=5u c_length=5u
X218 VDD VSS cap_mim_2f0_m4m5_noshield c_width=5u c_length=5u
X219 VDD VSS cap_mim_2f0_m4m5_noshield c_width=5u c_length=5u
X220 VDD VSS cap_mim_2f0_m4m5_noshield c_width=5u c_length=5u
X221 VDD VSS cap_mim_2f0_m4m5_noshield c_width=5u c_length=5u
X222 VDD VSS cap_mim_2f0_m4m5_noshield c_width=5u c_length=5u
X223 VDD VSS cap_mim_2f0_m4m5_noshield c_width=5u c_length=5u
X224 VDD VSS cap_mim_2f0_m4m5_noshield c_width=5u c_length=5u
X225 VDD VSS cap_mim_2f0_m4m5_noshield c_width=5u c_length=5u
X226 VDD VSS cap_mim_2f0_m4m5_noshield c_width=5u c_length=5u
X227 VDD VSS cap_mim_2f0_m4m5_noshield c_width=5u c_length=5u
X228 VDD VSS cap_mim_2f0_m4m5_noshield c_width=5u c_length=5u
X229 VDD VSS cap_mim_2f0_m4m5_noshield c_width=5u c_length=5u
X230 VDD VSS cap_mim_2f0_m4m5_noshield c_width=5u c_length=5u
X231 VDD VSS cap_mim_2f0_m4m5_noshield c_width=5u c_length=5u
X232 VDD VSS cap_mim_2f0_m4m5_noshield c_width=5u c_length=5u
X233 VDD VSS cap_mim_2f0_m4m5_noshield c_width=5u c_length=5u
X234 VDD VSS cap_mim_2f0_m4m5_noshield c_width=5u c_length=5u
X235 VDD VSS cap_mim_2f0_m4m5_noshield c_width=5u c_length=5u
X236 VDD VSS cap_mim_2f0_m4m5_noshield c_width=5u c_length=5u
X237 VDD VSS cap_mim_2f0_m4m5_noshield c_width=5u c_length=5u
X238 VDD VSS cap_mim_2f0_m4m5_noshield c_width=5u c_length=5u
X239 VDD VSS cap_mim_2f0_m4m5_noshield c_width=5u c_length=5u
X240 VDD VSS cap_mim_2f0_m4m5_noshield c_width=5u c_length=5u
X241 VDD VSS cap_mim_2f0_m4m5_noshield c_width=5u c_length=5u
X242 VDD VSS cap_mim_2f0_m4m5_noshield c_width=5u c_length=5u
X243 VDD VSS cap_mim_2f0_m4m5_noshield c_width=5u c_length=5u
X244 VDD VSS cap_mim_2f0_m4m5_noshield c_width=5u c_length=5u
X245 VDD VSS cap_mim_2f0_m4m5_noshield c_width=5u c_length=5u
X246 VDD VSS cap_mim_2f0_m4m5_noshield c_width=5u c_length=5u
X247 VDD VSS cap_mim_2f0_m4m5_noshield c_width=5u c_length=5u
X248 VDD VSS cap_mim_2f0_m4m5_noshield c_width=5u c_length=5u
X249 VDD VSS cap_mim_2f0_m4m5_noshield c_width=5u c_length=5u
X250 VDD VSS cap_mim_2f0_m4m5_noshield c_width=5u c_length=5u
X251 VDD VSS cap_mim_2f0_m4m5_noshield c_width=5u c_length=5u
X252 VDD VSS cap_mim_2f0_m4m5_noshield c_width=5u c_length=5u
X253 VDD VSS cap_mim_2f0_m4m5_noshield c_width=5u c_length=5u
X254 VDD VSS cap_mim_2f0_m4m5_noshield c_width=5u c_length=5u
X255 VDD VSS cap_mim_2f0_m4m5_noshield c_width=5u c_length=5u
X256 VDD VSS cap_mim_2f0_m4m5_noshield c_width=5u c_length=5u
X257 VDD VSS cap_mim_2f0_m4m5_noshield c_width=5u c_length=5u
X258 VDD VSS cap_mim_2f0_m4m5_noshield c_width=5u c_length=5u
X259 VDD VSS cap_mim_2f0_m4m5_noshield c_width=5u c_length=5u
X260 VDD VSS cap_mim_2f0_m4m5_noshield c_width=5u c_length=5u
X261 VDD VSS cap_mim_2f0_m4m5_noshield c_width=5u c_length=5u
X262 VDD VSS cap_mim_2f0_m4m5_noshield c_width=5u c_length=5u
X263 VDD VSS cap_mim_2f0_m4m5_noshield c_width=5u c_length=5u
X264 VDD VSS cap_mim_2f0_m4m5_noshield c_width=5u c_length=5u
X265 VDD VSS cap_mim_2f0_m4m5_noshield c_width=5u c_length=5u
X266 VDD VSS cap_mim_2f0_m4m5_noshield c_width=5u c_length=5u
X267 VDD VSS cap_mim_2f0_m4m5_noshield c_width=5u c_length=5u
X268 VDD VSS cap_mim_2f0_m4m5_noshield c_width=5u c_length=5u
X269 VDD VSS cap_mim_2f0_m4m5_noshield c_width=5u c_length=5u
X270 VDD VSS cap_mim_2f0_m4m5_noshield c_width=5u c_length=5u
X271 VDD VSS cap_mim_2f0_m4m5_noshield c_width=5u c_length=5u
X272 VDD VSS cap_mim_2f0_m4m5_noshield c_width=5u c_length=5u
X273 VDD VSS cap_mim_2f0_m4m5_noshield c_width=5u c_length=5u
X274 VDD VSS cap_mim_2f0_m4m5_noshield c_width=5u c_length=5u
X275 VDD VSS cap_mim_2f0_m4m5_noshield c_width=5u c_length=5u
X276 VDD VSS cap_mim_2f0_m4m5_noshield c_width=5u c_length=5u
X277 VDD VSS cap_mim_2f0_m4m5_noshield c_width=5u c_length=5u
X278 VDD VSS cap_mim_2f0_m4m5_noshield c_width=5u c_length=5u
X279 VDD VSS cap_mim_2f0_m4m5_noshield c_width=5u c_length=5u
X280 VDD VSS cap_mim_2f0_m4m5_noshield c_width=5u c_length=5u
X281 VDD VSS cap_mim_2f0_m4m5_noshield c_width=5u c_length=5u
X282 VDD VSS cap_mim_2f0_m4m5_noshield c_width=5u c_length=5u
X283 VDD VSS cap_mim_2f0_m4m5_noshield c_width=5u c_length=5u
X284 VDD VSS cap_mim_2f0_m4m5_noshield c_width=5u c_length=5u
X285 VDD VSS cap_mim_2f0_m4m5_noshield c_width=5u c_length=5u
X286 VDD VSS cap_mim_2f0_m4m5_noshield c_width=5u c_length=5u
X287 VDD VSS cap_mim_2f0_m4m5_noshield c_width=5u c_length=5u
X288 VDD VSS cap_mim_2f0_m4m5_noshield c_width=5u c_length=5u
X289 VDD VSS cap_mim_2f0_m4m5_noshield c_width=5u c_length=5u
X290 VDD VSS cap_mim_2f0_m4m5_noshield c_width=5u c_length=5u
X291 VDD VSS cap_mim_2f0_m4m5_noshield c_width=5u c_length=5u
X292 VDD VSS cap_mim_2f0_m4m5_noshield c_width=5u c_length=5u
X293 VDD VSS cap_mim_2f0_m4m5_noshield c_width=5u c_length=5u
X294 VDD VSS cap_mim_2f0_m4m5_noshield c_width=5u c_length=5u
X295 VDD VSS cap_mim_2f0_m4m5_noshield c_width=5u c_length=5u
X296 VDD VSS cap_mim_2f0_m4m5_noshield c_width=5u c_length=5u
X297 VDD VSS cap_mim_2f0_m4m5_noshield c_width=5u c_length=5u
X298 VDD VSS cap_mim_2f0_m4m5_noshield c_width=5u c_length=5u
X299 VDD VSS cap_mim_2f0_m4m5_noshield c_width=5u c_length=5u
X300 VDD VSS cap_mim_2f0_m4m5_noshield c_width=5u c_length=5u
X301 VDD VSS cap_mim_2f0_m4m5_noshield c_width=5u c_length=5u
X302 VDD VSS cap_mim_2f0_m4m5_noshield c_width=5u c_length=5u
X303 VDD VSS cap_mim_2f0_m4m5_noshield c_width=5u c_length=5u
X304 VDD VSS cap_mim_2f0_m4m5_noshield c_width=5u c_length=5u
X305 VDD VSS cap_mim_2f0_m4m5_noshield c_width=5u c_length=5u
X306 VDD VSS cap_mim_2f0_m4m5_noshield c_width=5u c_length=5u
X307 VDD VSS cap_mim_2f0_m4m5_noshield c_width=5u c_length=5u
X308 VDD VSS cap_mim_2f0_m4m5_noshield c_width=5u c_length=5u
X309 VDD VSS cap_mim_2f0_m4m5_noshield c_width=5u c_length=5u
X310 VDD VSS cap_mim_2f0_m4m5_noshield c_width=5u c_length=5u
X311 VDD VSS cap_mim_2f0_m4m5_noshield c_width=5u c_length=5u
X312 VDD VSS cap_mim_2f0_m4m5_noshield c_width=5u c_length=5u
X313 VDD VSS cap_mim_2f0_m4m5_noshield c_width=5u c_length=5u
X314 VDD VSS cap_mim_2f0_m4m5_noshield c_width=5u c_length=5u
X315 VDD VSS cap_mim_2f0_m4m5_noshield c_width=5u c_length=5u
X316 VDD VSS cap_mim_2f0_m4m5_noshield c_width=5u c_length=5u
X317 VDD VSS cap_mim_2f0_m4m5_noshield c_width=5u c_length=5u
X318 VDD VSS cap_mim_2f0_m4m5_noshield c_width=5u c_length=5u
X319 VDD VSS cap_mim_2f0_m4m5_noshield c_width=5u c_length=5u
X320 VDD VSS cap_mim_2f0_m4m5_noshield c_width=5u c_length=5u
X321 VDD VSS cap_mim_2f0_m4m5_noshield c_width=5u c_length=5u
X322 VDD VSS cap_mim_2f0_m4m5_noshield c_width=5u c_length=5u
X323 VDD VSS cap_mim_2f0_m4m5_noshield c_width=5u c_length=5u
X324 VDD VSS cap_mim_2f0_m4m5_noshield c_width=5u c_length=5u
X325 VDD VSS cap_mim_2f0_m4m5_noshield c_width=5u c_length=5u
X326 VDD VSS cap_mim_2f0_m4m5_noshield c_width=5u c_length=5u
X327 VDD VSS cap_mim_2f0_m4m5_noshield c_width=5u c_length=5u
X328 VDD VSS cap_mim_2f0_m4m5_noshield c_width=5u c_length=5u
X329 VDD VSS cap_mim_2f0_m4m5_noshield c_width=5u c_length=5u
X330 VDD VSS cap_mim_2f0_m4m5_noshield c_width=5u c_length=5u
X331 VDD VSS cap_mim_2f0_m4m5_noshield c_width=5u c_length=5u
X332 VDD VSS cap_mim_2f0_m4m5_noshield c_width=5u c_length=5u
X333 VDD VSS cap_mim_2f0_m4m5_noshield c_width=5u c_length=5u
X334 VDD VSS cap_mim_2f0_m4m5_noshield c_width=5u c_length=5u
X335 VDD VSS cap_mim_2f0_m4m5_noshield c_width=5u c_length=5u
X336 VDD VSS cap_mim_2f0_m4m5_noshield c_width=5u c_length=5u
X337 VDD VSS cap_mim_2f0_m4m5_noshield c_width=5u c_length=5u
X338 VDD VSS cap_mim_2f0_m4m5_noshield c_width=5u c_length=5u
X339 VDD VSS cap_mim_2f0_m4m5_noshield c_width=5u c_length=5u
X340 VDD VSS cap_mim_2f0_m4m5_noshield c_width=5u c_length=5u
X341 VDD VSS cap_mim_2f0_m4m5_noshield c_width=5u c_length=5u
X342 VDD VSS cap_mim_2f0_m4m5_noshield c_width=5u c_length=5u
X343 VDD VSS cap_mim_2f0_m4m5_noshield c_width=5u c_length=5u
X344 VDD VSS cap_mim_2f0_m4m5_noshield c_width=5u c_length=5u
X345 VDD VSS cap_mim_2f0_m4m5_noshield c_width=5u c_length=5u
X346 VDD VSS cap_mim_2f0_m4m5_noshield c_width=5u c_length=5u
X347 VDD VSS cap_mim_2f0_m4m5_noshield c_width=5u c_length=5u
X348 VDD VSS cap_mim_2f0_m4m5_noshield c_width=5u c_length=5u
X349 VDD VSS cap_mim_2f0_m4m5_noshield c_width=5u c_length=5u
X350 VDD VSS cap_mim_2f0_m4m5_noshield c_width=5u c_length=5u
X351 VDD VSS cap_mim_2f0_m4m5_noshield c_width=5u c_length=5u
X352 VDD VSS cap_mim_2f0_m4m5_noshield c_width=5u c_length=5u
X353 VDD VSS cap_mim_2f0_m4m5_noshield c_width=5u c_length=5u
X354 VDD VSS cap_mim_2f0_m4m5_noshield c_width=5u c_length=5u
X355 VDD VSS cap_mim_2f0_m4m5_noshield c_width=5u c_length=5u
X356 VDD VSS cap_mim_2f0_m4m5_noshield c_width=5u c_length=5u
X357 VDD VSS cap_mim_2f0_m4m5_noshield c_width=5u c_length=5u
X358 VDD VSS cap_mim_2f0_m4m5_noshield c_width=5u c_length=5u
X359 VDD VSS cap_mim_2f0_m4m5_noshield c_width=5u c_length=5u
X360 VDD VSS cap_mim_2f0_m4m5_noshield c_width=5u c_length=5u
.ends

.subckt decap_CD4 VDD VSS
X0 VDD VSS cap_mim_2f0_m4m5_noshield c_width=5u c_length=5u
X1 VDD VSS cap_mim_2f0_m4m5_noshield c_width=5u c_length=5u
X2 VDD VSS cap_mim_2f0_m4m5_noshield c_width=5u c_length=5u
X3 VDD VSS cap_mim_2f0_m4m5_noshield c_width=5u c_length=5u
X4 VDD VSS cap_mim_2f0_m4m5_noshield c_width=5u c_length=5u
X5 VDD VSS cap_mim_2f0_m4m5_noshield c_width=5u c_length=5u
X6 VDD VSS cap_mim_2f0_m4m5_noshield c_width=5u c_length=5u
X7 VDD VSS cap_mim_2f0_m4m5_noshield c_width=5u c_length=5u
X8 VDD VSS cap_mim_2f0_m4m5_noshield c_width=5u c_length=5u
X9 VDD VSS cap_mim_2f0_m4m5_noshield c_width=5u c_length=5u
X10 VDD VSS cap_mim_2f0_m4m5_noshield c_width=5u c_length=5u
X11 VDD VSS cap_mim_2f0_m4m5_noshield c_width=5u c_length=5u
X12 VDD VSS cap_mim_2f0_m4m5_noshield c_width=5u c_length=5u
X13 VDD VSS cap_mim_2f0_m4m5_noshield c_width=5u c_length=5u
X14 VDD VSS cap_mim_2f0_m4m5_noshield c_width=5u c_length=5u
X15 VDD VSS cap_mim_2f0_m4m5_noshield c_width=5u c_length=5u
X16 VDD VSS cap_mim_2f0_m4m5_noshield c_width=5u c_length=5u
X17 VDD VSS cap_mim_2f0_m4m5_noshield c_width=5u c_length=5u
X18 VDD VSS cap_mim_2f0_m4m5_noshield c_width=5u c_length=5u
X19 VDD VSS cap_mim_2f0_m4m5_noshield c_width=5u c_length=5u
X20 VDD VSS cap_mim_2f0_m4m5_noshield c_width=5u c_length=5u
X21 VDD VSS cap_mim_2f0_m4m5_noshield c_width=5u c_length=5u
X22 VDD VSS cap_mim_2f0_m4m5_noshield c_width=5u c_length=5u
X23 VDD VSS cap_mim_2f0_m4m5_noshield c_width=5u c_length=5u
X24 VDD VSS cap_mim_2f0_m4m5_noshield c_width=5u c_length=5u
X25 VDD VSS cap_mim_2f0_m4m5_noshield c_width=5u c_length=5u
X26 VDD VSS cap_mim_2f0_m4m5_noshield c_width=5u c_length=5u
X27 VDD VSS cap_mim_2f0_m4m5_noshield c_width=5u c_length=5u
X28 VDD VSS cap_mim_2f0_m4m5_noshield c_width=5u c_length=5u
X29 VDD VSS cap_mim_2f0_m4m5_noshield c_width=5u c_length=5u
X30 VDD VSS cap_mim_2f0_m4m5_noshield c_width=5u c_length=5u
X31 VDD VSS cap_mim_2f0_m4m5_noshield c_width=5u c_length=5u
X32 VDD VSS cap_mim_2f0_m4m5_noshield c_width=5u c_length=5u
X33 VDD VSS cap_mim_2f0_m4m5_noshield c_width=5u c_length=5u
X34 VDD VSS cap_mim_2f0_m4m5_noshield c_width=5u c_length=5u
X35 VDD VSS cap_mim_2f0_m4m5_noshield c_width=5u c_length=5u
X36 VDD VSS cap_mim_2f0_m4m5_noshield c_width=5u c_length=5u
X37 VDD VSS cap_mim_2f0_m4m5_noshield c_width=5u c_length=5u
X38 VDD VSS cap_mim_2f0_m4m5_noshield c_width=5u c_length=5u
X39 VDD VSS cap_mim_2f0_m4m5_noshield c_width=5u c_length=5u
X40 VDD VSS cap_mim_2f0_m4m5_noshield c_width=5u c_length=5u
X41 VDD VSS cap_mim_2f0_m4m5_noshield c_width=5u c_length=5u
X42 VDD VSS cap_mim_2f0_m4m5_noshield c_width=5u c_length=5u
X43 VDD VSS cap_mim_2f0_m4m5_noshield c_width=5u c_length=5u
X44 VDD VSS cap_mim_2f0_m4m5_noshield c_width=5u c_length=5u
X45 VDD VSS cap_mim_2f0_m4m5_noshield c_width=5u c_length=5u
X46 VDD VSS cap_mim_2f0_m4m5_noshield c_width=5u c_length=5u
X47 VDD VSS cap_mim_2f0_m4m5_noshield c_width=5u c_length=5u
X48 VDD VSS cap_mim_2f0_m4m5_noshield c_width=5u c_length=5u
X49 VDD VSS cap_mim_2f0_m4m5_noshield c_width=5u c_length=5u
X50 VDD VSS cap_mim_2f0_m4m5_noshield c_width=5u c_length=5u
X51 VDD VSS cap_mim_2f0_m4m5_noshield c_width=5u c_length=5u
X52 VDD VSS cap_mim_2f0_m4m5_noshield c_width=5u c_length=5u
X53 VDD VSS cap_mim_2f0_m4m5_noshield c_width=5u c_length=5u
X54 VDD VSS cap_mim_2f0_m4m5_noshield c_width=5u c_length=5u
X55 VDD VSS cap_mim_2f0_m4m5_noshield c_width=5u c_length=5u
X56 VDD VSS cap_mim_2f0_m4m5_noshield c_width=5u c_length=5u
X57 VDD VSS cap_mim_2f0_m4m5_noshield c_width=5u c_length=5u
X58 VDD VSS cap_mim_2f0_m4m5_noshield c_width=5u c_length=5u
X59 VDD VSS cap_mim_2f0_m4m5_noshield c_width=5u c_length=5u
X60 VDD VSS cap_mim_2f0_m4m5_noshield c_width=5u c_length=5u
X61 VDD VSS cap_mim_2f0_m4m5_noshield c_width=5u c_length=5u
X62 VDD VSS cap_mim_2f0_m4m5_noshield c_width=5u c_length=5u
X63 VDD VSS cap_mim_2f0_m4m5_noshield c_width=5u c_length=5u
X64 VDD VSS cap_mim_2f0_m4m5_noshield c_width=5u c_length=5u
X65 VDD VSS cap_mim_2f0_m4m5_noshield c_width=5u c_length=5u
X66 VDD VSS cap_mim_2f0_m4m5_noshield c_width=5u c_length=5u
X67 VDD VSS cap_mim_2f0_m4m5_noshield c_width=5u c_length=5u
X68 VDD VSS cap_mim_2f0_m4m5_noshield c_width=5u c_length=5u
X69 VDD VSS cap_mim_2f0_m4m5_noshield c_width=5u c_length=5u
X70 VDD VSS cap_mim_2f0_m4m5_noshield c_width=5u c_length=5u
X71 VDD VSS cap_mim_2f0_m4m5_noshield c_width=5u c_length=5u
X72 VDD VSS cap_mim_2f0_m4m5_noshield c_width=5u c_length=5u
X73 VDD VSS cap_mim_2f0_m4m5_noshield c_width=5u c_length=5u
X74 VDD VSS cap_mim_2f0_m4m5_noshield c_width=5u c_length=5u
X75 VDD VSS cap_mim_2f0_m4m5_noshield c_width=5u c_length=5u
X76 VDD VSS cap_mim_2f0_m4m5_noshield c_width=5u c_length=5u
X77 VDD VSS cap_mim_2f0_m4m5_noshield c_width=5u c_length=5u
X78 VDD VSS cap_mim_2f0_m4m5_noshield c_width=5u c_length=5u
X79 VDD VSS cap_mim_2f0_m4m5_noshield c_width=5u c_length=5u
X80 VDD VSS cap_mim_2f0_m4m5_noshield c_width=5u c_length=5u
X81 VDD VSS cap_mim_2f0_m4m5_noshield c_width=5u c_length=5u
X82 VDD VSS cap_mim_2f0_m4m5_noshield c_width=5u c_length=5u
X83 VDD VSS cap_mim_2f0_m4m5_noshield c_width=5u c_length=5u
X84 VDD VSS cap_mim_2f0_m4m5_noshield c_width=5u c_length=5u
X85 VDD VSS cap_mim_2f0_m4m5_noshield c_width=5u c_length=5u
X86 VDD VSS cap_mim_2f0_m4m5_noshield c_width=5u c_length=5u
X87 VDD VSS cap_mim_2f0_m4m5_noshield c_width=5u c_length=5u
X88 VDD VSS cap_mim_2f0_m4m5_noshield c_width=5u c_length=5u
X89 VDD VSS cap_mim_2f0_m4m5_noshield c_width=5u c_length=5u
X90 VDD VSS cap_mim_2f0_m4m5_noshield c_width=5u c_length=5u
X91 VDD VSS cap_mim_2f0_m4m5_noshield c_width=5u c_length=5u
X92 VDD VSS cap_mim_2f0_m4m5_noshield c_width=5u c_length=5u
X93 VDD VSS cap_mim_2f0_m4m5_noshield c_width=5u c_length=5u
X94 VDD VSS cap_mim_2f0_m4m5_noshield c_width=5u c_length=5u
X95 VDD VSS cap_mim_2f0_m4m5_noshield c_width=5u c_length=5u
X96 VDD VSS cap_mim_2f0_m4m5_noshield c_width=5u c_length=5u
X97 VDD VSS cap_mim_2f0_m4m5_noshield c_width=5u c_length=5u
X98 VDD VSS cap_mim_2f0_m4m5_noshield c_width=5u c_length=5u
X99 VDD VSS cap_mim_2f0_m4m5_noshield c_width=5u c_length=5u
X100 VDD VSS cap_mim_2f0_m4m5_noshield c_width=5u c_length=5u
X101 VDD VSS cap_mim_2f0_m4m5_noshield c_width=5u c_length=5u
X102 VDD VSS cap_mim_2f0_m4m5_noshield c_width=5u c_length=5u
X103 VDD VSS cap_mim_2f0_m4m5_noshield c_width=5u c_length=5u
X104 VDD VSS cap_mim_2f0_m4m5_noshield c_width=5u c_length=5u
X105 VDD VSS cap_mim_2f0_m4m5_noshield c_width=5u c_length=5u
X106 VDD VSS cap_mim_2f0_m4m5_noshield c_width=5u c_length=5u
X107 VDD VSS cap_mim_2f0_m4m5_noshield c_width=5u c_length=5u
X108 VDD VSS cap_mim_2f0_m4m5_noshield c_width=5u c_length=5u
X109 VDD VSS cap_mim_2f0_m4m5_noshield c_width=5u c_length=5u
X110 VDD VSS cap_mim_2f0_m4m5_noshield c_width=5u c_length=5u
X111 VDD VSS cap_mim_2f0_m4m5_noshield c_width=5u c_length=5u
X112 VDD VSS cap_mim_2f0_m4m5_noshield c_width=5u c_length=5u
X113 VDD VSS cap_mim_2f0_m4m5_noshield c_width=5u c_length=5u
X114 VDD VSS cap_mim_2f0_m4m5_noshield c_width=5u c_length=5u
X115 VDD VSS cap_mim_2f0_m4m5_noshield c_width=5u c_length=5u
X116 VDD VSS cap_mim_2f0_m4m5_noshield c_width=5u c_length=5u
X117 VDD VSS cap_mim_2f0_m4m5_noshield c_width=5u c_length=5u
X118 VDD VSS cap_mim_2f0_m4m5_noshield c_width=5u c_length=5u
X119 VDD VSS cap_mim_2f0_m4m5_noshield c_width=5u c_length=5u
X120 VDD VSS cap_mim_2f0_m4m5_noshield c_width=5u c_length=5u
X121 VDD VSS cap_mim_2f0_m4m5_noshield c_width=5u c_length=5u
X122 VDD VSS cap_mim_2f0_m4m5_noshield c_width=5u c_length=5u
X123 VDD VSS cap_mim_2f0_m4m5_noshield c_width=5u c_length=5u
X124 VDD VSS cap_mim_2f0_m4m5_noshield c_width=5u c_length=5u
X125 VDD VSS cap_mim_2f0_m4m5_noshield c_width=5u c_length=5u
X126 VDD VSS cap_mim_2f0_m4m5_noshield c_width=5u c_length=5u
X127 VDD VSS cap_mim_2f0_m4m5_noshield c_width=5u c_length=5u
X128 VDD VSS cap_mim_2f0_m4m5_noshield c_width=5u c_length=5u
X129 VDD VSS cap_mim_2f0_m4m5_noshield c_width=5u c_length=5u
X130 VDD VSS cap_mim_2f0_m4m5_noshield c_width=5u c_length=5u
X131 VDD VSS cap_mim_2f0_m4m5_noshield c_width=5u c_length=5u
X132 VDD VSS cap_mim_2f0_m4m5_noshield c_width=5u c_length=5u
X133 VDD VSS cap_mim_2f0_m4m5_noshield c_width=5u c_length=5u
X134 VDD VSS cap_mim_2f0_m4m5_noshield c_width=5u c_length=5u
X135 VDD VSS cap_mim_2f0_m4m5_noshield c_width=5u c_length=5u
X136 VDD VSS cap_mim_2f0_m4m5_noshield c_width=5u c_length=5u
X137 VDD VSS cap_mim_2f0_m4m5_noshield c_width=5u c_length=5u
X138 VDD VSS cap_mim_2f0_m4m5_noshield c_width=5u c_length=5u
X139 VDD VSS cap_mim_2f0_m4m5_noshield c_width=5u c_length=5u
X140 VDD VSS cap_mim_2f0_m4m5_noshield c_width=5u c_length=5u
X141 VDD VSS cap_mim_2f0_m4m5_noshield c_width=5u c_length=5u
X142 VDD VSS cap_mim_2f0_m4m5_noshield c_width=5u c_length=5u
X143 VDD VSS cap_mim_2f0_m4m5_noshield c_width=5u c_length=5u
X144 VDD VSS cap_mim_2f0_m4m5_noshield c_width=5u c_length=5u
X145 VDD VSS cap_mim_2f0_m4m5_noshield c_width=5u c_length=5u
X146 VDD VSS cap_mim_2f0_m4m5_noshield c_width=5u c_length=5u
X147 VDD VSS cap_mim_2f0_m4m5_noshield c_width=5u c_length=5u
X148 VDD VSS cap_mim_2f0_m4m5_noshield c_width=5u c_length=5u
X149 VDD VSS cap_mim_2f0_m4m5_noshield c_width=5u c_length=5u
X150 VDD VSS cap_mim_2f0_m4m5_noshield c_width=5u c_length=5u
X151 VDD VSS cap_mim_2f0_m4m5_noshield c_width=5u c_length=5u
X152 VDD VSS cap_mim_2f0_m4m5_noshield c_width=5u c_length=5u
X153 VDD VSS cap_mim_2f0_m4m5_noshield c_width=5u c_length=5u
X154 VDD VSS cap_mim_2f0_m4m5_noshield c_width=5u c_length=5u
X155 VDD VSS cap_mim_2f0_m4m5_noshield c_width=5u c_length=5u
X156 VDD VSS cap_mim_2f0_m4m5_noshield c_width=5u c_length=5u
X157 VDD VSS cap_mim_2f0_m4m5_noshield c_width=5u c_length=5u
X158 VDD VSS cap_mim_2f0_m4m5_noshield c_width=5u c_length=5u
X159 VDD VSS cap_mim_2f0_m4m5_noshield c_width=5u c_length=5u
X160 VDD VSS cap_mim_2f0_m4m5_noshield c_width=5u c_length=5u
X161 VDD VSS cap_mim_2f0_m4m5_noshield c_width=5u c_length=5u
X162 VDD VSS cap_mim_2f0_m4m5_noshield c_width=5u c_length=5u
X163 VDD VSS cap_mim_2f0_m4m5_noshield c_width=5u c_length=5u
X164 VDD VSS cap_mim_2f0_m4m5_noshield c_width=5u c_length=5u
X165 VDD VSS cap_mim_2f0_m4m5_noshield c_width=5u c_length=5u
X166 VDD VSS cap_mim_2f0_m4m5_noshield c_width=5u c_length=5u
X167 VDD VSS cap_mim_2f0_m4m5_noshield c_width=5u c_length=5u
X168 VDD VSS cap_mim_2f0_m4m5_noshield c_width=5u c_length=5u
X169 VDD VSS cap_mim_2f0_m4m5_noshield c_width=5u c_length=5u
X170 VDD VSS cap_mim_2f0_m4m5_noshield c_width=5u c_length=5u
X171 VDD VSS cap_mim_2f0_m4m5_noshield c_width=5u c_length=5u
X172 VDD VSS cap_mim_2f0_m4m5_noshield c_width=5u c_length=5u
X173 VDD VSS cap_mim_2f0_m4m5_noshield c_width=5u c_length=5u
X174 VDD VSS cap_mim_2f0_m4m5_noshield c_width=5u c_length=5u
X175 VDD VSS cap_mim_2f0_m4m5_noshield c_width=5u c_length=5u
X176 VDD VSS cap_mim_2f0_m4m5_noshield c_width=5u c_length=5u
X177 VDD VSS cap_mim_2f0_m4m5_noshield c_width=5u c_length=5u
X178 VDD VSS cap_mim_2f0_m4m5_noshield c_width=5u c_length=5u
X179 VDD VSS cap_mim_2f0_m4m5_noshield c_width=5u c_length=5u
X180 VDD VSS cap_mim_2f0_m4m5_noshield c_width=5u c_length=5u
X181 VDD VSS cap_mim_2f0_m4m5_noshield c_width=5u c_length=5u
X182 VDD VSS cap_mim_2f0_m4m5_noshield c_width=5u c_length=5u
X183 VDD VSS cap_mim_2f0_m4m5_noshield c_width=5u c_length=5u
X184 VDD VSS cap_mim_2f0_m4m5_noshield c_width=5u c_length=5u
X185 VDD VSS cap_mim_2f0_m4m5_noshield c_width=5u c_length=5u
X186 VDD VSS cap_mim_2f0_m4m5_noshield c_width=5u c_length=5u
X187 VDD VSS cap_mim_2f0_m4m5_noshield c_width=5u c_length=5u
X188 VDD VSS cap_mim_2f0_m4m5_noshield c_width=5u c_length=5u
X189 VDD VSS cap_mim_2f0_m4m5_noshield c_width=5u c_length=5u
X190 VDD VSS cap_mim_2f0_m4m5_noshield c_width=5u c_length=5u
X191 VDD VSS cap_mim_2f0_m4m5_noshield c_width=5u c_length=5u
X192 VDD VSS cap_mim_2f0_m4m5_noshield c_width=5u c_length=5u
X193 VDD VSS cap_mim_2f0_m4m5_noshield c_width=5u c_length=5u
X194 VDD VSS cap_mim_2f0_m4m5_noshield c_width=5u c_length=5u
X195 VDD VSS cap_mim_2f0_m4m5_noshield c_width=5u c_length=5u
X196 VDD VSS cap_mim_2f0_m4m5_noshield c_width=5u c_length=5u
X197 VDD VSS cap_mim_2f0_m4m5_noshield c_width=5u c_length=5u
X198 VDD VSS cap_mim_2f0_m4m5_noshield c_width=5u c_length=5u
X199 VDD VSS cap_mim_2f0_m4m5_noshield c_width=5u c_length=5u
X200 VDD VSS cap_mim_2f0_m4m5_noshield c_width=5u c_length=5u
X201 VDD VSS cap_mim_2f0_m4m5_noshield c_width=5u c_length=5u
X202 VDD VSS cap_mim_2f0_m4m5_noshield c_width=5u c_length=5u
X203 VDD VSS cap_mim_2f0_m4m5_noshield c_width=5u c_length=5u
X204 VDD VSS cap_mim_2f0_m4m5_noshield c_width=5u c_length=5u
X205 VDD VSS cap_mim_2f0_m4m5_noshield c_width=5u c_length=5u
X206 VDD VSS cap_mim_2f0_m4m5_noshield c_width=5u c_length=5u
X207 VDD VSS cap_mim_2f0_m4m5_noshield c_width=5u c_length=5u
X208 VDD VSS cap_mim_2f0_m4m5_noshield c_width=5u c_length=5u
X209 VDD VSS cap_mim_2f0_m4m5_noshield c_width=5u c_length=5u
X210 VDD VSS cap_mim_2f0_m4m5_noshield c_width=5u c_length=5u
X211 VDD VSS cap_mim_2f0_m4m5_noshield c_width=5u c_length=5u
X212 VDD VSS cap_mim_2f0_m4m5_noshield c_width=5u c_length=5u
X213 VDD VSS cap_mim_2f0_m4m5_noshield c_width=5u c_length=5u
X214 VDD VSS cap_mim_2f0_m4m5_noshield c_width=5u c_length=5u
X215 VDD VSS cap_mim_2f0_m4m5_noshield c_width=5u c_length=5u
X216 VDD VSS cap_mim_2f0_m4m5_noshield c_width=5u c_length=5u
X217 VDD VSS cap_mim_2f0_m4m5_noshield c_width=5u c_length=5u
X218 VDD VSS cap_mim_2f0_m4m5_noshield c_width=5u c_length=5u
X219 VDD VSS cap_mim_2f0_m4m5_noshield c_width=5u c_length=5u
X220 VDD VSS cap_mim_2f0_m4m5_noshield c_width=5u c_length=5u
X221 VDD VSS cap_mim_2f0_m4m5_noshield c_width=5u c_length=5u
X222 VDD VSS cap_mim_2f0_m4m5_noshield c_width=5u c_length=5u
X223 VDD VSS cap_mim_2f0_m4m5_noshield c_width=5u c_length=5u
X224 VDD VSS cap_mim_2f0_m4m5_noshield c_width=5u c_length=5u
X225 VDD VSS cap_mim_2f0_m4m5_noshield c_width=5u c_length=5u
X226 VDD VSS cap_mim_2f0_m4m5_noshield c_width=5u c_length=5u
X227 VDD VSS cap_mim_2f0_m4m5_noshield c_width=5u c_length=5u
X228 VDD VSS cap_mim_2f0_m4m5_noshield c_width=5u c_length=5u
X229 VDD VSS cap_mim_2f0_m4m5_noshield c_width=5u c_length=5u
X230 VDD VSS cap_mim_2f0_m4m5_noshield c_width=5u c_length=5u
X231 VDD VSS cap_mim_2f0_m4m5_noshield c_width=5u c_length=5u
X232 VDD VSS cap_mim_2f0_m4m5_noshield c_width=5u c_length=5u
X233 VDD VSS cap_mim_2f0_m4m5_noshield c_width=5u c_length=5u
X234 VDD VSS cap_mim_2f0_m4m5_noshield c_width=5u c_length=5u
X235 VDD VSS cap_mim_2f0_m4m5_noshield c_width=5u c_length=5u
X236 VDD VSS cap_mim_2f0_m4m5_noshield c_width=5u c_length=5u
X237 VDD VSS cap_mim_2f0_m4m5_noshield c_width=5u c_length=5u
X238 VDD VSS cap_mim_2f0_m4m5_noshield c_width=5u c_length=5u
X239 VDD VSS cap_mim_2f0_m4m5_noshield c_width=5u c_length=5u
X240 VDD VSS cap_mim_2f0_m4m5_noshield c_width=5u c_length=5u
X241 VDD VSS cap_mim_2f0_m4m5_noshield c_width=5u c_length=5u
X242 VDD VSS cap_mim_2f0_m4m5_noshield c_width=5u c_length=5u
X243 VDD VSS cap_mim_2f0_m4m5_noshield c_width=5u c_length=5u
X244 VDD VSS cap_mim_2f0_m4m5_noshield c_width=5u c_length=5u
X245 VDD VSS cap_mim_2f0_m4m5_noshield c_width=5u c_length=5u
X246 VDD VSS cap_mim_2f0_m4m5_noshield c_width=5u c_length=5u
X247 VDD VSS cap_mim_2f0_m4m5_noshield c_width=5u c_length=5u
X248 VDD VSS cap_mim_2f0_m4m5_noshield c_width=5u c_length=5u
X249 VDD VSS cap_mim_2f0_m4m5_noshield c_width=5u c_length=5u
X250 VDD VSS cap_mim_2f0_m4m5_noshield c_width=5u c_length=5u
X251 VDD VSS cap_mim_2f0_m4m5_noshield c_width=5u c_length=5u
X252 VDD VSS cap_mim_2f0_m4m5_noshield c_width=5u c_length=5u
X253 VDD VSS cap_mim_2f0_m4m5_noshield c_width=5u c_length=5u
X254 VDD VSS cap_mim_2f0_m4m5_noshield c_width=5u c_length=5u
X255 VDD VSS cap_mim_2f0_m4m5_noshield c_width=5u c_length=5u
X256 VDD VSS cap_mim_2f0_m4m5_noshield c_width=5u c_length=5u
X257 VDD VSS cap_mim_2f0_m4m5_noshield c_width=5u c_length=5u
X258 VDD VSS cap_mim_2f0_m4m5_noshield c_width=5u c_length=5u
X259 VDD VSS cap_mim_2f0_m4m5_noshield c_width=5u c_length=5u
X260 VDD VSS cap_mim_2f0_m4m5_noshield c_width=5u c_length=5u
X261 VDD VSS cap_mim_2f0_m4m5_noshield c_width=5u c_length=5u
X262 VDD VSS cap_mim_2f0_m4m5_noshield c_width=5u c_length=5u
X263 VDD VSS cap_mim_2f0_m4m5_noshield c_width=5u c_length=5u
X264 VDD VSS cap_mim_2f0_m4m5_noshield c_width=5u c_length=5u
X265 VDD VSS cap_mim_2f0_m4m5_noshield c_width=5u c_length=5u
X266 VDD VSS cap_mim_2f0_m4m5_noshield c_width=5u c_length=5u
X267 VDD VSS cap_mim_2f0_m4m5_noshield c_width=5u c_length=5u
X268 VDD VSS cap_mim_2f0_m4m5_noshield c_width=5u c_length=5u
X269 VDD VSS cap_mim_2f0_m4m5_noshield c_width=5u c_length=5u
X270 VDD VSS cap_mim_2f0_m4m5_noshield c_width=5u c_length=5u
X271 VDD VSS cap_mim_2f0_m4m5_noshield c_width=5u c_length=5u
X272 VDD VSS cap_mim_2f0_m4m5_noshield c_width=5u c_length=5u
X273 VDD VSS cap_mim_2f0_m4m5_noshield c_width=5u c_length=5u
X274 VDD VSS cap_mim_2f0_m4m5_noshield c_width=5u c_length=5u
X275 VDD VSS cap_mim_2f0_m4m5_noshield c_width=5u c_length=5u
X276 VDD VSS cap_mim_2f0_m4m5_noshield c_width=5u c_length=5u
X277 VDD VSS cap_mim_2f0_m4m5_noshield c_width=5u c_length=5u
X278 VDD VSS cap_mim_2f0_m4m5_noshield c_width=5u c_length=5u
X279 VDD VSS cap_mim_2f0_m4m5_noshield c_width=5u c_length=5u
X280 VDD VSS cap_mim_2f0_m4m5_noshield c_width=5u c_length=5u
X281 VDD VSS cap_mim_2f0_m4m5_noshield c_width=5u c_length=5u
X282 VDD VSS cap_mim_2f0_m4m5_noshield c_width=5u c_length=5u
X283 VDD VSS cap_mim_2f0_m4m5_noshield c_width=5u c_length=5u
X284 VDD VSS cap_mim_2f0_m4m5_noshield c_width=5u c_length=5u
X285 VDD VSS cap_mim_2f0_m4m5_noshield c_width=5u c_length=5u
X286 VDD VSS cap_mim_2f0_m4m5_noshield c_width=5u c_length=5u
X287 VDD VSS cap_mim_2f0_m4m5_noshield c_width=5u c_length=5u
X288 VDD VSS cap_mim_2f0_m4m5_noshield c_width=5u c_length=5u
X289 VDD VSS cap_mim_2f0_m4m5_noshield c_width=5u c_length=5u
X290 VDD VSS cap_mim_2f0_m4m5_noshield c_width=5u c_length=5u
X291 VDD VSS cap_mim_2f0_m4m5_noshield c_width=5u c_length=5u
X292 VDD VSS cap_mim_2f0_m4m5_noshield c_width=5u c_length=5u
X293 VDD VSS cap_mim_2f0_m4m5_noshield c_width=5u c_length=5u
X294 VDD VSS cap_mim_2f0_m4m5_noshield c_width=5u c_length=5u
X295 VDD VSS cap_mim_2f0_m4m5_noshield c_width=5u c_length=5u
X296 VDD VSS cap_mim_2f0_m4m5_noshield c_width=5u c_length=5u
X297 VDD VSS cap_mim_2f0_m4m5_noshield c_width=5u c_length=5u
X298 VDD VSS cap_mim_2f0_m4m5_noshield c_width=5u c_length=5u
X299 VDD VSS cap_mim_2f0_m4m5_noshield c_width=5u c_length=5u
X300 VDD VSS cap_mim_2f0_m4m5_noshield c_width=5u c_length=5u
X301 VDD VSS cap_mim_2f0_m4m5_noshield c_width=5u c_length=5u
X302 VDD VSS cap_mim_2f0_m4m5_noshield c_width=5u c_length=5u
X303 VDD VSS cap_mim_2f0_m4m5_noshield c_width=5u c_length=5u
X304 VDD VSS cap_mim_2f0_m4m5_noshield c_width=5u c_length=5u
X305 VDD VSS cap_mim_2f0_m4m5_noshield c_width=5u c_length=5u
X306 VDD VSS cap_mim_2f0_m4m5_noshield c_width=5u c_length=5u
X307 VDD VSS cap_mim_2f0_m4m5_noshield c_width=5u c_length=5u
X308 VDD VSS cap_mim_2f0_m4m5_noshield c_width=5u c_length=5u
X309 VDD VSS cap_mim_2f0_m4m5_noshield c_width=5u c_length=5u
X310 VDD VSS cap_mim_2f0_m4m5_noshield c_width=5u c_length=5u
X311 VDD VSS cap_mim_2f0_m4m5_noshield c_width=5u c_length=5u
X312 VDD VSS cap_mim_2f0_m4m5_noshield c_width=5u c_length=5u
X313 VDD VSS cap_mim_2f0_m4m5_noshield c_width=5u c_length=5u
X314 VDD VSS cap_mim_2f0_m4m5_noshield c_width=5u c_length=5u
X315 VDD VSS cap_mim_2f0_m4m5_noshield c_width=5u c_length=5u
X316 VDD VSS cap_mim_2f0_m4m5_noshield c_width=5u c_length=5u
X317 VDD VSS cap_mim_2f0_m4m5_noshield c_width=5u c_length=5u
X318 VDD VSS cap_mim_2f0_m4m5_noshield c_width=5u c_length=5u
X319 VDD VSS cap_mim_2f0_m4m5_noshield c_width=5u c_length=5u
X320 VDD VSS cap_mim_2f0_m4m5_noshield c_width=5u c_length=5u
X321 VDD VSS cap_mim_2f0_m4m5_noshield c_width=5u c_length=5u
X322 VDD VSS cap_mim_2f0_m4m5_noshield c_width=5u c_length=5u
X323 VDD VSS cap_mim_2f0_m4m5_noshield c_width=5u c_length=5u
X324 VDD VSS cap_mim_2f0_m4m5_noshield c_width=5u c_length=5u
X325 VDD VSS cap_mim_2f0_m4m5_noshield c_width=5u c_length=5u
X326 VDD VSS cap_mim_2f0_m4m5_noshield c_width=5u c_length=5u
X327 VDD VSS cap_mim_2f0_m4m5_noshield c_width=5u c_length=5u
X328 VDD VSS cap_mim_2f0_m4m5_noshield c_width=5u c_length=5u
X329 VDD VSS cap_mim_2f0_m4m5_noshield c_width=5u c_length=5u
X330 VDD VSS cap_mim_2f0_m4m5_noshield c_width=5u c_length=5u
X331 VDD VSS cap_mim_2f0_m4m5_noshield c_width=5u c_length=5u
X332 VDD VSS cap_mim_2f0_m4m5_noshield c_width=5u c_length=5u
X333 VDD VSS cap_mim_2f0_m4m5_noshield c_width=5u c_length=5u
X334 VDD VSS cap_mim_2f0_m4m5_noshield c_width=5u c_length=5u
X335 VDD VSS cap_mim_2f0_m4m5_noshield c_width=5u c_length=5u
X336 VDD VSS cap_mim_2f0_m4m5_noshield c_width=5u c_length=5u
X337 VDD VSS cap_mim_2f0_m4m5_noshield c_width=5u c_length=5u
X338 VDD VSS cap_mim_2f0_m4m5_noshield c_width=5u c_length=5u
X339 VDD VSS cap_mim_2f0_m4m5_noshield c_width=5u c_length=5u
X340 VDD VSS cap_mim_2f0_m4m5_noshield c_width=5u c_length=5u
X341 VDD VSS cap_mim_2f0_m4m5_noshield c_width=5u c_length=5u
X342 VDD VSS cap_mim_2f0_m4m5_noshield c_width=5u c_length=5u
X343 VDD VSS cap_mim_2f0_m4m5_noshield c_width=5u c_length=5u
X344 VDD VSS cap_mim_2f0_m4m5_noshield c_width=5u c_length=5u
X345 VDD VSS cap_mim_2f0_m4m5_noshield c_width=5u c_length=5u
X346 VDD VSS cap_mim_2f0_m4m5_noshield c_width=5u c_length=5u
X347 VDD VSS cap_mim_2f0_m4m5_noshield c_width=5u c_length=5u
X348 VDD VSS cap_mim_2f0_m4m5_noshield c_width=5u c_length=5u
X349 VDD VSS cap_mim_2f0_m4m5_noshield c_width=5u c_length=5u
X350 VDD VSS cap_mim_2f0_m4m5_noshield c_width=5u c_length=5u
X351 VDD VSS cap_mim_2f0_m4m5_noshield c_width=5u c_length=5u
X352 VDD VSS cap_mim_2f0_m4m5_noshield c_width=5u c_length=5u
X353 VDD VSS cap_mim_2f0_m4m5_noshield c_width=5u c_length=5u
X354 VDD VSS cap_mim_2f0_m4m5_noshield c_width=5u c_length=5u
X355 VDD VSS cap_mim_2f0_m4m5_noshield c_width=5u c_length=5u
X356 VDD VSS cap_mim_2f0_m4m5_noshield c_width=5u c_length=5u
X357 VDD VSS cap_mim_2f0_m4m5_noshield c_width=5u c_length=5u
X358 VDD VSS cap_mim_2f0_m4m5_noshield c_width=5u c_length=5u
X359 VDD VSS cap_mim_2f0_m4m5_noshield c_width=5u c_length=5u
X360 VDD VSS cap_mim_2f0_m4m5_noshield c_width=5u c_length=5u
.ends

.subckt decap VSS VDD
XXCD5 VDD VSS decap_CD5
XXCD6 VDD VSS decap_CD6
XXCD0 VDD VSS decap_CD0
XXCD1 VDD VSS decap_CD1
XXCD2 VDD VSS decap_CD2
XXCD3 VDD VSS decap_CD3
XXCD4 VDD VSS decap_CD4
.ends
