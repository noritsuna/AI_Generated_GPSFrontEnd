* NGSPICE file created from sk_lpf2.ext - technology: gf180mcuD

.subckt sk_lpf2_MFN VSS yN OUTN
X0 OUTN yN VSS OUTN pfet_03v3 ad=1.325p pd=5.53u as=1.325p ps=5.53u w=5u l=0.28u
X1 OUTN yN VSS OUTN pfet_03v3 ad=1.325p pd=5.53u as=1.325p ps=5.53u w=5u l=0.28u
X2 VSS yN OUTN OUTN pfet_03v3 ad=1.325p pd=5.53u as=1.325p ps=5.53u w=5u l=0.28u
X3 VSS yN OUTN OUTN pfet_03v3 ad=1.325p pd=5.53u as=2.225p ps=10.89u w=5u l=0.28u
X4 VSS yN OUTN OUTN pfet_03v3 ad=1.325p pd=5.53u as=1.325p ps=5.53u w=5u l=0.28u
X5 OUTN yN VSS OUTN pfet_03v3 ad=1.325p pd=5.53u as=1.325p ps=5.53u w=5u l=0.28u
X6 VSS yN OUTN OUTN pfet_03v3 ad=1.325p pd=5.53u as=1.325p ps=5.53u w=5u l=0.28u
X7 OUTN yN VSS OUTN pfet_03v3 ad=2.225p pd=10.89u as=1.325p ps=5.53u w=5u l=0.28u
.ends

.subckt sk_lpf2_C2N yN VSS
X0 yN VSS cap_mim_2f0_m4m5_noshield c_width=5u c_length=5u
X1 yN VSS cap_mim_2f0_m4m5_noshield c_width=5u c_length=5u
X2 yN VSS cap_mim_2f0_m4m5_noshield c_width=5u c_length=5u
X3 yN VSS cap_mim_2f0_m4m5_noshield c_width=5u c_length=5u
X4 yN VSS cap_mim_2f0_m4m5_noshield c_width=5u c_length=5u
X5 yN VSS cap_mim_2f0_m4m5_noshield c_width=5u c_length=5u
X6 yN VSS cap_mim_2f0_m4m5_noshield c_width=5u c_length=5u
X7 yN VSS cap_mim_2f0_m4m5_noshield c_width=5u c_length=5u
X8 yN VSS cap_mim_2f0_m4m5_noshield c_width=5u c_length=5u
X9 yN VSS cap_mim_2f0_m4m5_noshield c_width=5u c_length=5u
X10 yN VSS cap_mim_2f0_m4m5_noshield c_width=5u c_length=5u
X11 yN VSS cap_mim_2f0_m4m5_noshield c_width=5u c_length=5u
X12 yN VSS cap_mim_2f0_m4m5_noshield c_width=5u c_length=5u
X13 yN VSS cap_mim_2f0_m4m5_noshield c_width=5u c_length=5u
X14 yN VSS cap_mim_2f0_m4m5_noshield c_width=5u c_length=5u
X15 yN VSS cap_mim_2f0_m4m5_noshield c_width=5u c_length=5u
X16 yN VSS cap_mim_2f0_m4m5_noshield c_width=5u c_length=5u
X17 yN VSS cap_mim_2f0_m4m5_noshield c_width=5u c_length=5u
X18 yN VSS cap_mim_2f0_m4m5_noshield c_width=5u c_length=5u
X19 yN VSS cap_mim_2f0_m4m5_noshield c_width=5u c_length=5u
X20 yN VSS cap_mim_2f0_m4m5_noshield c_width=5u c_length=5u
.ends

.subckt sk_lpf2_C1N xN OUTN
X0 xN OUTN cap_mim_2f0_m4m5_noshield c_width=5u c_length=5u
X1 xN OUTN cap_mim_2f0_m4m5_noshield c_width=5u c_length=5u
X2 xN OUTN cap_mim_2f0_m4m5_noshield c_width=5u c_length=5u
X3 xN OUTN cap_mim_2f0_m4m5_noshield c_width=5u c_length=5u
X4 xN OUTN cap_mim_2f0_m4m5_noshield c_width=5u c_length=5u
X5 xN OUTN cap_mim_2f0_m4m5_noshield c_width=5u c_length=5u
X6 xN OUTN cap_mim_2f0_m4m5_noshield c_width=5u c_length=5u
X7 xN OUTN cap_mim_2f0_m4m5_noshield c_width=5u c_length=5u
X8 xN OUTN cap_mim_2f0_m4m5_noshield c_width=5u c_length=5u
X9 xN OUTN cap_mim_2f0_m4m5_noshield c_width=5u c_length=5u
X10 xN OUTN cap_mim_2f0_m4m5_noshield c_width=5u c_length=5u
X11 xN OUTN cap_mim_2f0_m4m5_noshield c_width=5u c_length=5u
X12 xN OUTN cap_mim_2f0_m4m5_noshield c_width=5u c_length=5u
X13 xN OUTN cap_mim_2f0_m4m5_noshield c_width=5u c_length=5u
X14 xN OUTN cap_mim_2f0_m4m5_noshield c_width=5u c_length=5u
X15 xN OUTN cap_mim_2f0_m4m5_noshield c_width=5u c_length=5u
X16 xN OUTN cap_mim_2f0_m4m5_noshield c_width=5u c_length=5u
X17 xN OUTN cap_mim_2f0_m4m5_noshield c_width=5u c_length=5u
X18 xN OUTN cap_mim_2f0_m4m5_noshield c_width=5u c_length=5u
X19 xN OUTN cap_mim_2f0_m4m5_noshield c_width=5u c_length=5u
X20 xN OUTN cap_mim_2f0_m4m5_noshield c_width=5u c_length=5u
X21 xN OUTN cap_mim_2f0_m4m5_noshield c_width=5u c_length=5u
X22 xN OUTN cap_mim_2f0_m4m5_noshield c_width=5u c_length=5u
X23 xN OUTN cap_mim_2f0_m4m5_noshield c_width=5u c_length=5u
X24 xN OUTN cap_mim_2f0_m4m5_noshield c_width=5u c_length=5u
X25 xN OUTN cap_mim_2f0_m4m5_noshield c_width=5u c_length=5u
X26 xN OUTN cap_mim_2f0_m4m5_noshield c_width=5u c_length=5u
X27 xN OUTN cap_mim_2f0_m4m5_noshield c_width=5u c_length=5u
X28 xN OUTN cap_mim_2f0_m4m5_noshield c_width=5u c_length=5u
X29 xN OUTN cap_mim_2f0_m4m5_noshield c_width=5u c_length=5u
X30 xN OUTN cap_mim_2f0_m4m5_noshield c_width=5u c_length=5u
X31 xN OUTN cap_mim_2f0_m4m5_noshield c_width=5u c_length=5u
X32 xN OUTN cap_mim_2f0_m4m5_noshield c_width=5u c_length=5u
X33 xN OUTN cap_mim_2f0_m4m5_noshield c_width=5u c_length=5u
X34 xN OUTN cap_mim_2f0_m4m5_noshield c_width=5u c_length=5u
X35 xN OUTN cap_mim_2f0_m4m5_noshield c_width=5u c_length=5u
X36 xN OUTN cap_mim_2f0_m4m5_noshield c_width=5u c_length=5u
X37 xN OUTN cap_mim_2f0_m4m5_noshield c_width=5u c_length=5u
X38 xN OUTN cap_mim_2f0_m4m5_noshield c_width=5u c_length=5u
X39 xN OUTN cap_mim_2f0_m4m5_noshield c_width=5u c_length=5u
X40 xN OUTN cap_mim_2f0_m4m5_noshield c_width=5u c_length=5u
X41 xN OUTN cap_mim_2f0_m4m5_noshield c_width=5u c_length=5u
X42 xN OUTN cap_mim_2f0_m4m5_noshield c_width=5u c_length=5u
X43 xN OUTN cap_mim_2f0_m4m5_noshield c_width=5u c_length=5u
X44 xN OUTN cap_mim_2f0_m4m5_noshield c_width=5u c_length=5u
X45 xN OUTN cap_mim_2f0_m4m5_noshield c_width=5u c_length=5u
X46 xN OUTN cap_mim_2f0_m4m5_noshield c_width=5u c_length=5u
X47 xN OUTN cap_mim_2f0_m4m5_noshield c_width=5u c_length=5u
X48 xN OUTN cap_mim_2f0_m4m5_noshield c_width=5u c_length=5u
X49 xN OUTN cap_mim_2f0_m4m5_noshield c_width=5u c_length=5u
X50 xN OUTN cap_mim_2f0_m4m5_noshield c_width=5u c_length=5u
X51 xN OUTN cap_mim_2f0_m4m5_noshield c_width=5u c_length=5u
X52 xN OUTN cap_mim_2f0_m4m5_noshield c_width=5u c_length=5u
X53 xN OUTN cap_mim_2f0_m4m5_noshield c_width=5u c_length=5u
X54 xN OUTN cap_mim_2f0_m4m5_noshield c_width=5u c_length=5u
X55 xN OUTN cap_mim_2f0_m4m5_noshield c_width=5u c_length=5u
X56 xN OUTN cap_mim_2f0_m4m5_noshield c_width=5u c_length=5u
X57 xN OUTN cap_mim_2f0_m4m5_noshield c_width=5u c_length=5u
X58 xN OUTN cap_mim_2f0_m4m5_noshield c_width=5u c_length=5u
X59 xN OUTN cap_mim_2f0_m4m5_noshield c_width=5u c_length=5u
X60 xN OUTN cap_mim_2f0_m4m5_noshield c_width=5u c_length=5u
X61 xN OUTN cap_mim_2f0_m4m5_noshield c_width=5u c_length=5u
X62 xN OUTN cap_mim_2f0_m4m5_noshield c_width=5u c_length=5u
X63 xN OUTN cap_mim_2f0_m4m5_noshield c_width=5u c_length=5u
X64 xN OUTN cap_mim_2f0_m4m5_noshield c_width=5u c_length=5u
X65 xN OUTN cap_mim_2f0_m4m5_noshield c_width=5u c_length=5u
X66 xN OUTN cap_mim_2f0_m4m5_noshield c_width=5u c_length=5u
X67 xN OUTN cap_mim_2f0_m4m5_noshield c_width=5u c_length=5u
X68 xN OUTN cap_mim_2f0_m4m5_noshield c_width=5u c_length=5u
X69 xN OUTN cap_mim_2f0_m4m5_noshield c_width=5u c_length=5u
X70 xN OUTN cap_mim_2f0_m4m5_noshield c_width=5u c_length=5u
X71 xN OUTN cap_mim_2f0_m4m5_noshield c_width=5u c_length=5u
X72 xN OUTN cap_mim_2f0_m4m5_noshield c_width=5u c_length=5u
X73 xN OUTN cap_mim_2f0_m4m5_noshield c_width=5u c_length=5u
X74 xN OUTN cap_mim_2f0_m4m5_noshield c_width=5u c_length=5u
X75 xN OUTN cap_mim_2f0_m4m5_noshield c_width=5u c_length=5u
X76 xN OUTN cap_mim_2f0_m4m5_noshield c_width=5u c_length=5u
X77 xN OUTN cap_mim_2f0_m4m5_noshield c_width=5u c_length=5u
X78 xN OUTN cap_mim_2f0_m4m5_noshield c_width=5u c_length=5u
X79 xN OUTN cap_mim_2f0_m4m5_noshield c_width=5u c_length=5u
X80 xN OUTN cap_mim_2f0_m4m5_noshield c_width=5u c_length=5u
X81 xN OUTN cap_mim_2f0_m4m5_noshield c_width=5u c_length=5u
X82 xN OUTN cap_mim_2f0_m4m5_noshield c_width=5u c_length=5u
X83 xN OUTN cap_mim_2f0_m4m5_noshield c_width=5u c_length=5u
X84 xN OUTN cap_mim_2f0_m4m5_noshield c_width=5u c_length=5u
X85 xN OUTN cap_mim_2f0_m4m5_noshield c_width=5u c_length=5u
X86 xN OUTN cap_mim_2f0_m4m5_noshield c_width=5u c_length=5u
X87 xN OUTN cap_mim_2f0_m4m5_noshield c_width=5u c_length=5u
X88 xN OUTN cap_mim_2f0_m4m5_noshield c_width=5u c_length=5u
X89 xN OUTN cap_mim_2f0_m4m5_noshield c_width=5u c_length=5u
X90 xN OUTN cap_mim_2f0_m4m5_noshield c_width=5u c_length=5u
X91 xN OUTN cap_mim_2f0_m4m5_noshield c_width=5u c_length=5u
X92 xN OUTN cap_mim_2f0_m4m5_noshield c_width=5u c_length=5u
X93 xN OUTN cap_mim_2f0_m4m5_noshield c_width=5u c_length=5u
X94 xN OUTN cap_mim_2f0_m4m5_noshield c_width=5u c_length=5u
X95 xN OUTN cap_mim_2f0_m4m5_noshield c_width=5u c_length=5u
X96 xN OUTN cap_mim_2f0_m4m5_noshield c_width=5u c_length=5u
X97 xN OUTN cap_mim_2f0_m4m5_noshield c_width=5u c_length=5u
X98 xN OUTN cap_mim_2f0_m4m5_noshield c_width=5u c_length=5u
X99 xN OUTN cap_mim_2f0_m4m5_noshield c_width=5u c_length=5u
X100 xN OUTN cap_mim_2f0_m4m5_noshield c_width=5u c_length=5u
X101 xN OUTN cap_mim_2f0_m4m5_noshield c_width=5u c_length=5u
X102 xN OUTN cap_mim_2f0_m4m5_noshield c_width=5u c_length=5u
X103 xN OUTN cap_mim_2f0_m4m5_noshield c_width=5u c_length=5u
X104 xN OUTN cap_mim_2f0_m4m5_noshield c_width=5u c_length=5u
X105 xN OUTN cap_mim_2f0_m4m5_noshield c_width=5u c_length=5u
X106 xN OUTN cap_mim_2f0_m4m5_noshield c_width=5u c_length=5u
X107 xN OUTN cap_mim_2f0_m4m5_noshield c_width=5u c_length=5u
X108 xN OUTN cap_mim_2f0_m4m5_noshield c_width=5u c_length=5u
X109 xN OUTN cap_mim_2f0_m4m5_noshield c_width=5u c_length=5u
X110 xN OUTN cap_mim_2f0_m4m5_noshield c_width=5u c_length=5u
X111 xN OUTN cap_mim_2f0_m4m5_noshield c_width=5u c_length=5u
X112 xN OUTN cap_mim_2f0_m4m5_noshield c_width=5u c_length=5u
X113 xN OUTN cap_mim_2f0_m4m5_noshield c_width=5u c_length=5u
X114 xN OUTN cap_mim_2f0_m4m5_noshield c_width=5u c_length=5u
X115 xN OUTN cap_mim_2f0_m4m5_noshield c_width=5u c_length=5u
X116 xN OUTN cap_mim_2f0_m4m5_noshield c_width=5u c_length=5u
X117 xN OUTN cap_mim_2f0_m4m5_noshield c_width=5u c_length=5u
X118 xN OUTN cap_mim_2f0_m4m5_noshield c_width=5u c_length=5u
X119 xN OUTN cap_mim_2f0_m4m5_noshield c_width=5u c_length=5u
X120 xN OUTN cap_mim_2f0_m4m5_noshield c_width=5u c_length=5u
X121 xN OUTN cap_mim_2f0_m4m5_noshield c_width=5u c_length=5u
X122 xN OUTN cap_mim_2f0_m4m5_noshield c_width=5u c_length=5u
X123 xN OUTN cap_mim_2f0_m4m5_noshield c_width=5u c_length=5u
X124 xN OUTN cap_mim_2f0_m4m5_noshield c_width=5u c_length=5u
X125 xN OUTN cap_mim_2f0_m4m5_noshield c_width=5u c_length=5u
X126 xN OUTN cap_mim_2f0_m4m5_noshield c_width=5u c_length=5u
X127 xN OUTN cap_mim_2f0_m4m5_noshield c_width=5u c_length=5u
X128 xN OUTN cap_mim_2f0_m4m5_noshield c_width=5u c_length=5u
X129 xN OUTN cap_mim_2f0_m4m5_noshield c_width=5u c_length=5u
X130 xN OUTN cap_mim_2f0_m4m5_noshield c_width=5u c_length=5u
X131 xN OUTN cap_mim_2f0_m4m5_noshield c_width=5u c_length=5u
X132 xN OUTN cap_mim_2f0_m4m5_noshield c_width=5u c_length=5u
X133 xN OUTN cap_mim_2f0_m4m5_noshield c_width=5u c_length=5u
X134 xN OUTN cap_mim_2f0_m4m5_noshield c_width=5u c_length=5u
X135 xN OUTN cap_mim_2f0_m4m5_noshield c_width=5u c_length=5u
X136 xN OUTN cap_mim_2f0_m4m5_noshield c_width=5u c_length=5u
X137 xN OUTN cap_mim_2f0_m4m5_noshield c_width=5u c_length=5u
X138 xN OUTN cap_mim_2f0_m4m5_noshield c_width=5u c_length=5u
X139 xN OUTN cap_mim_2f0_m4m5_noshield c_width=5u c_length=5u
X140 xN OUTN cap_mim_2f0_m4m5_noshield c_width=5u c_length=5u
X141 xN OUTN cap_mim_2f0_m4m5_noshield c_width=5u c_length=5u
X142 xN OUTN cap_mim_2f0_m4m5_noshield c_width=5u c_length=5u
X143 xN OUTN cap_mim_2f0_m4m5_noshield c_width=5u c_length=5u
X144 xN OUTN cap_mim_2f0_m4m5_noshield c_width=5u c_length=5u
X145 xN OUTN cap_mim_2f0_m4m5_noshield c_width=5u c_length=5u
X146 xN OUTN cap_mim_2f0_m4m5_noshield c_width=5u c_length=5u
X147 xN OUTN cap_mim_2f0_m4m5_noshield c_width=5u c_length=5u
X148 xN OUTN cap_mim_2f0_m4m5_noshield c_width=5u c_length=5u
X149 xN OUTN cap_mim_2f0_m4m5_noshield c_width=5u c_length=5u
X150 xN OUTN cap_mim_2f0_m4m5_noshield c_width=5u c_length=5u
X151 xN OUTN cap_mim_2f0_m4m5_noshield c_width=5u c_length=5u
X152 xN OUTN cap_mim_2f0_m4m5_noshield c_width=5u c_length=5u
X153 xN OUTN cap_mim_2f0_m4m5_noshield c_width=5u c_length=5u
X154 xN OUTN cap_mim_2f0_m4m5_noshield c_width=5u c_length=5u
X155 xN OUTN cap_mim_2f0_m4m5_noshield c_width=5u c_length=5u
X156 xN OUTN cap_mim_2f0_m4m5_noshield c_width=5u c_length=5u
X157 xN OUTN cap_mim_2f0_m4m5_noshield c_width=5u c_length=5u
X158 xN OUTN cap_mim_2f0_m4m5_noshield c_width=5u c_length=5u
X159 xN OUTN cap_mim_2f0_m4m5_noshield c_width=5u c_length=5u
X160 xN OUTN cap_mim_2f0_m4m5_noshield c_width=5u c_length=5u
X161 xN OUTN cap_mim_2f0_m4m5_noshield c_width=5u c_length=5u
X162 xN OUTN cap_mim_2f0_m4m5_noshield c_width=5u c_length=5u
X163 xN OUTN cap_mim_2f0_m4m5_noshield c_width=5u c_length=5u
X164 xN OUTN cap_mim_2f0_m4m5_noshield c_width=5u c_length=5u
X165 xN OUTN cap_mim_2f0_m4m5_noshield c_width=5u c_length=5u
X166 xN OUTN cap_mim_2f0_m4m5_noshield c_width=5u c_length=5u
X167 xN OUTN cap_mim_2f0_m4m5_noshield c_width=5u c_length=5u
X168 xN OUTN cap_mim_2f0_m4m5_noshield c_width=5u c_length=5u
X169 xN OUTN cap_mim_2f0_m4m5_noshield c_width=5u c_length=5u
X170 xN OUTN cap_mim_2f0_m4m5_noshield c_width=5u c_length=5u
X171 xN OUTN cap_mim_2f0_m4m5_noshield c_width=5u c_length=5u
X172 xN OUTN cap_mim_2f0_m4m5_noshield c_width=5u c_length=5u
X173 xN OUTN cap_mim_2f0_m4m5_noshield c_width=5u c_length=5u
X174 xN OUTN cap_mim_2f0_m4m5_noshield c_width=5u c_length=5u
X175 xN OUTN cap_mim_2f0_m4m5_noshield c_width=5u c_length=5u
X176 xN OUTN cap_mim_2f0_m4m5_noshield c_width=5u c_length=5u
X177 xN OUTN cap_mim_2f0_m4m5_noshield c_width=5u c_length=5u
X178 xN OUTN cap_mim_2f0_m4m5_noshield c_width=5u c_length=5u
X179 xN OUTN cap_mim_2f0_m4m5_noshield c_width=5u c_length=5u
X180 xN OUTN cap_mim_2f0_m4m5_noshield c_width=5u c_length=5u
X181 xN OUTN cap_mim_2f0_m4m5_noshield c_width=5u c_length=5u
X182 xN OUTN cap_mim_2f0_m4m5_noshield c_width=5u c_length=5u
X183 xN OUTN cap_mim_2f0_m4m5_noshield c_width=5u c_length=5u
X184 xN OUTN cap_mim_2f0_m4m5_noshield c_width=5u c_length=5u
X185 xN OUTN cap_mim_2f0_m4m5_noshield c_width=5u c_length=5u
X186 xN OUTN cap_mim_2f0_m4m5_noshield c_width=5u c_length=5u
X187 xN OUTN cap_mim_2f0_m4m5_noshield c_width=5u c_length=5u
X188 xN OUTN cap_mim_2f0_m4m5_noshield c_width=5u c_length=5u
X189 xN OUTN cap_mim_2f0_m4m5_noshield c_width=5u c_length=5u
X190 xN OUTN cap_mim_2f0_m4m5_noshield c_width=5u c_length=5u
X191 xN OUTN cap_mim_2f0_m4m5_noshield c_width=5u c_length=5u
X192 xN OUTN cap_mim_2f0_m4m5_noshield c_width=5u c_length=5u
X193 xN OUTN cap_mim_2f0_m4m5_noshield c_width=5u c_length=5u
X194 xN OUTN cap_mim_2f0_m4m5_noshield c_width=5u c_length=5u
X195 xN OUTN cap_mim_2f0_m4m5_noshield c_width=5u c_length=5u
X196 xN OUTN cap_mim_2f0_m4m5_noshield c_width=5u c_length=5u
X197 xN OUTN cap_mim_2f0_m4m5_noshield c_width=5u c_length=5u
X198 xN OUTN cap_mim_2f0_m4m5_noshield c_width=5u c_length=5u
X199 xN OUTN cap_mim_2f0_m4m5_noshield c_width=5u c_length=5u
X200 xN OUTN cap_mim_2f0_m4m5_noshield c_width=5u c_length=5u
X201 xN OUTN cap_mim_2f0_m4m5_noshield c_width=5u c_length=5u
X202 xN OUTN cap_mim_2f0_m4m5_noshield c_width=5u c_length=5u
X203 xN OUTN cap_mim_2f0_m4m5_noshield c_width=5u c_length=5u
X204 xN OUTN cap_mim_2f0_m4m5_noshield c_width=5u c_length=5u
X205 xN OUTN cap_mim_2f0_m4m5_noshield c_width=5u c_length=5u
X206 xN OUTN cap_mim_2f0_m4m5_noshield c_width=5u c_length=5u
X207 xN OUTN cap_mim_2f0_m4m5_noshield c_width=5u c_length=5u
X208 xN OUTN cap_mim_2f0_m4m5_noshield c_width=5u c_length=5u
X209 xN OUTN cap_mim_2f0_m4m5_noshield c_width=5u c_length=5u
X210 xN OUTN cap_mim_2f0_m4m5_noshield c_width=5u c_length=5u
X211 xN OUTN cap_mim_2f0_m4m5_noshield c_width=5u c_length=5u
X212 xN OUTN cap_mim_2f0_m4m5_noshield c_width=5u c_length=5u
X213 xN OUTN cap_mim_2f0_m4m5_noshield c_width=5u c_length=5u
X214 xN OUTN cap_mim_2f0_m4m5_noshield c_width=5u c_length=5u
X215 xN OUTN cap_mim_2f0_m4m5_noshield c_width=5u c_length=5u
X216 xN OUTN cap_mim_2f0_m4m5_noshield c_width=5u c_length=5u
X217 xN OUTN cap_mim_2f0_m4m5_noshield c_width=5u c_length=5u
X218 xN OUTN cap_mim_2f0_m4m5_noshield c_width=5u c_length=5u
X219 xN OUTN cap_mim_2f0_m4m5_noshield c_width=5u c_length=5u
X220 xN OUTN cap_mim_2f0_m4m5_noshield c_width=5u c_length=5u
X221 xN OUTN cap_mim_2f0_m4m5_noshield c_width=5u c_length=5u
X222 xN OUTN cap_mim_2f0_m4m5_noshield c_width=5u c_length=5u
X223 xN OUTN cap_mim_2f0_m4m5_noshield c_width=5u c_length=5u
X224 xN OUTN cap_mim_2f0_m4m5_noshield c_width=5u c_length=5u
X225 xN OUTN cap_mim_2f0_m4m5_noshield c_width=5u c_length=5u
X226 xN OUTN cap_mim_2f0_m4m5_noshield c_width=5u c_length=5u
X227 xN OUTN cap_mim_2f0_m4m5_noshield c_width=5u c_length=5u
X228 xN OUTN cap_mim_2f0_m4m5_noshield c_width=5u c_length=5u
X229 xN OUTN cap_mim_2f0_m4m5_noshield c_width=5u c_length=5u
X230 xN OUTN cap_mim_2f0_m4m5_noshield c_width=5u c_length=5u
X231 xN OUTN cap_mim_2f0_m4m5_noshield c_width=5u c_length=5u
X232 xN OUTN cap_mim_2f0_m4m5_noshield c_width=5u c_length=5u
X233 xN OUTN cap_mim_2f0_m4m5_noshield c_width=5u c_length=5u
X234 xN OUTN cap_mim_2f0_m4m5_noshield c_width=5u c_length=5u
X235 xN OUTN cap_mim_2f0_m4m5_noshield c_width=5u c_length=5u
X236 xN OUTN cap_mim_2f0_m4m5_noshield c_width=5u c_length=5u
X237 xN OUTN cap_mim_2f0_m4m5_noshield c_width=5u c_length=5u
X238 xN OUTN cap_mim_2f0_m4m5_noshield c_width=5u c_length=5u
X239 xN OUTN cap_mim_2f0_m4m5_noshield c_width=5u c_length=5u
X240 xN OUTN cap_mim_2f0_m4m5_noshield c_width=5u c_length=5u
X241 xN OUTN cap_mim_2f0_m4m5_noshield c_width=5u c_length=5u
X242 xN OUTN cap_mim_2f0_m4m5_noshield c_width=5u c_length=5u
X243 xN OUTN cap_mim_2f0_m4m5_noshield c_width=5u c_length=5u
X244 xN OUTN cap_mim_2f0_m4m5_noshield c_width=5u c_length=5u
X245 xN OUTN cap_mim_2f0_m4m5_noshield c_width=5u c_length=5u
X246 xN OUTN cap_mim_2f0_m4m5_noshield c_width=5u c_length=5u
X247 xN OUTN cap_mim_2f0_m4m5_noshield c_width=5u c_length=5u
X248 xN OUTN cap_mim_2f0_m4m5_noshield c_width=5u c_length=5u
X249 xN OUTN cap_mim_2f0_m4m5_noshield c_width=5u c_length=5u
X250 xN OUTN cap_mim_2f0_m4m5_noshield c_width=5u c_length=5u
X251 xN OUTN cap_mim_2f0_m4m5_noshield c_width=5u c_length=5u
X252 xN OUTN cap_mim_2f0_m4m5_noshield c_width=5u c_length=5u
X253 xN OUTN cap_mim_2f0_m4m5_noshield c_width=5u c_length=5u
X254 xN OUTN cap_mim_2f0_m4m5_noshield c_width=5u c_length=5u
X255 xN OUTN cap_mim_2f0_m4m5_noshield c_width=5u c_length=5u
X256 xN OUTN cap_mim_2f0_m4m5_noshield c_width=5u c_length=5u
X257 xN OUTN cap_mim_2f0_m4m5_noshield c_width=5u c_length=5u
X258 xN OUTN cap_mim_2f0_m4m5_noshield c_width=5u c_length=5u
X259 xN OUTN cap_mim_2f0_m4m5_noshield c_width=5u c_length=5u
X260 xN OUTN cap_mim_2f0_m4m5_noshield c_width=5u c_length=5u
X261 xN OUTN cap_mim_2f0_m4m5_noshield c_width=5u c_length=5u
X262 xN OUTN cap_mim_2f0_m4m5_noshield c_width=5u c_length=5u
X263 xN OUTN cap_mim_2f0_m4m5_noshield c_width=5u c_length=5u
X264 xN OUTN cap_mim_2f0_m4m5_noshield c_width=5u c_length=5u
X265 xN OUTN cap_mim_2f0_m4m5_noshield c_width=5u c_length=5u
X266 xN OUTN cap_mim_2f0_m4m5_noshield c_width=5u c_length=5u
X267 xN OUTN cap_mim_2f0_m4m5_noshield c_width=5u c_length=5u
X268 xN OUTN cap_mim_2f0_m4m5_noshield c_width=5u c_length=5u
X269 xN OUTN cap_mim_2f0_m4m5_noshield c_width=5u c_length=5u
X270 xN OUTN cap_mim_2f0_m4m5_noshield c_width=5u c_length=5u
X271 xN OUTN cap_mim_2f0_m4m5_noshield c_width=5u c_length=5u
X272 xN OUTN cap_mim_2f0_m4m5_noshield c_width=5u c_length=5u
X273 xN OUTN cap_mim_2f0_m4m5_noshield c_width=5u c_length=5u
X274 xN OUTN cap_mim_2f0_m4m5_noshield c_width=5u c_length=5u
X275 xN OUTN cap_mim_2f0_m4m5_noshield c_width=5u c_length=5u
X276 xN OUTN cap_mim_2f0_m4m5_noshield c_width=5u c_length=5u
X277 xN OUTN cap_mim_2f0_m4m5_noshield c_width=5u c_length=5u
X278 xN OUTN cap_mim_2f0_m4m5_noshield c_width=5u c_length=5u
X279 xN OUTN cap_mim_2f0_m4m5_noshield c_width=5u c_length=5u
X280 xN OUTN cap_mim_2f0_m4m5_noshield c_width=5u c_length=5u
X281 xN OUTN cap_mim_2f0_m4m5_noshield c_width=5u c_length=5u
X282 xN OUTN cap_mim_2f0_m4m5_noshield c_width=5u c_length=5u
X283 xN OUTN cap_mim_2f0_m4m5_noshield c_width=5u c_length=5u
X284 xN OUTN cap_mim_2f0_m4m5_noshield c_width=5u c_length=5u
X285 xN OUTN cap_mim_2f0_m4m5_noshield c_width=5u c_length=5u
X286 xN OUTN cap_mim_2f0_m4m5_noshield c_width=5u c_length=5u
X287 xN OUTN cap_mim_2f0_m4m5_noshield c_width=5u c_length=5u
X288 xN OUTN cap_mim_2f0_m4m5_noshield c_width=5u c_length=5u
X289 xN OUTN cap_mim_2f0_m4m5_noshield c_width=5u c_length=5u
X290 xN OUTN cap_mim_2f0_m4m5_noshield c_width=5u c_length=5u
X291 xN OUTN cap_mim_2f0_m4m5_noshield c_width=5u c_length=5u
X292 xN OUTN cap_mim_2f0_m4m5_noshield c_width=5u c_length=5u
X293 xN OUTN cap_mim_2f0_m4m5_noshield c_width=5u c_length=5u
X294 xN OUTN cap_mim_2f0_m4m5_noshield c_width=5u c_length=5u
X295 xN OUTN cap_mim_2f0_m4m5_noshield c_width=5u c_length=5u
X296 xN OUTN cap_mim_2f0_m4m5_noshield c_width=5u c_length=5u
X297 xN OUTN cap_mim_2f0_m4m5_noshield c_width=5u c_length=5u
X298 xN OUTN cap_mim_2f0_m4m5_noshield c_width=5u c_length=5u
X299 xN OUTN cap_mim_2f0_m4m5_noshield c_width=5u c_length=5u
X300 xN OUTN cap_mim_2f0_m4m5_noshield c_width=5u c_length=5u
X301 xN OUTN cap_mim_2f0_m4m5_noshield c_width=5u c_length=5u
X302 xN OUTN cap_mim_2f0_m4m5_noshield c_width=5u c_length=5u
X303 xN OUTN cap_mim_2f0_m4m5_noshield c_width=5u c_length=5u
X304 xN OUTN cap_mim_2f0_m4m5_noshield c_width=5u c_length=5u
X305 xN OUTN cap_mim_2f0_m4m5_noshield c_width=5u c_length=5u
X306 xN OUTN cap_mim_2f0_m4m5_noshield c_width=5u c_length=5u
X307 xN OUTN cap_mim_2f0_m4m5_noshield c_width=5u c_length=5u
X308 xN OUTN cap_mim_2f0_m4m5_noshield c_width=5u c_length=5u
X309 xN OUTN cap_mim_2f0_m4m5_noshield c_width=5u c_length=5u
X310 xN OUTN cap_mim_2f0_m4m5_noshield c_width=5u c_length=5u
X311 xN OUTN cap_mim_2f0_m4m5_noshield c_width=5u c_length=5u
X312 xN OUTN cap_mim_2f0_m4m5_noshield c_width=5u c_length=5u
X313 xN OUTN cap_mim_2f0_m4m5_noshield c_width=5u c_length=5u
X314 xN OUTN cap_mim_2f0_m4m5_noshield c_width=5u c_length=5u
X315 xN OUTN cap_mim_2f0_m4m5_noshield c_width=5u c_length=5u
X316 xN OUTN cap_mim_2f0_m4m5_noshield c_width=5u c_length=5u
X317 xN OUTN cap_mim_2f0_m4m5_noshield c_width=5u c_length=5u
X318 xN OUTN cap_mim_2f0_m4m5_noshield c_width=5u c_length=5u
X319 xN OUTN cap_mim_2f0_m4m5_noshield c_width=5u c_length=5u
X320 xN OUTN cap_mim_2f0_m4m5_noshield c_width=5u c_length=5u
X321 xN OUTN cap_mim_2f0_m4m5_noshield c_width=5u c_length=5u
X322 xN OUTN cap_mim_2f0_m4m5_noshield c_width=5u c_length=5u
X323 xN OUTN cap_mim_2f0_m4m5_noshield c_width=5u c_length=5u
X324 xN OUTN cap_mim_2f0_m4m5_noshield c_width=5u c_length=5u
X325 xN OUTN cap_mim_2f0_m4m5_noshield c_width=5u c_length=5u
X326 xN OUTN cap_mim_2f0_m4m5_noshield c_width=5u c_length=5u
X327 xN OUTN cap_mim_2f0_m4m5_noshield c_width=5u c_length=5u
X328 xN OUTN cap_mim_2f0_m4m5_noshield c_width=5u c_length=5u
X329 xN OUTN cap_mim_2f0_m4m5_noshield c_width=5u c_length=5u
X330 xN OUTN cap_mim_2f0_m4m5_noshield c_width=5u c_length=5u
X331 xN OUTN cap_mim_2f0_m4m5_noshield c_width=5u c_length=5u
X332 xN OUTN cap_mim_2f0_m4m5_noshield c_width=5u c_length=5u
X333 xN OUTN cap_mim_2f0_m4m5_noshield c_width=5u c_length=5u
X334 xN OUTN cap_mim_2f0_m4m5_noshield c_width=5u c_length=5u
X335 xN OUTN cap_mim_2f0_m4m5_noshield c_width=5u c_length=5u
X336 xN OUTN cap_mim_2f0_m4m5_noshield c_width=5u c_length=5u
X337 xN OUTN cap_mim_2f0_m4m5_noshield c_width=5u c_length=5u
X338 xN OUTN cap_mim_2f0_m4m5_noshield c_width=5u c_length=5u
X339 xN OUTN cap_mim_2f0_m4m5_noshield c_width=5u c_length=5u
X340 xN OUTN cap_mim_2f0_m4m5_noshield c_width=5u c_length=5u
X341 xN OUTN cap_mim_2f0_m4m5_noshield c_width=5u c_length=5u
X342 xN OUTN cap_mim_2f0_m4m5_noshield c_width=5u c_length=5u
X343 xN OUTN cap_mim_2f0_m4m5_noshield c_width=5u c_length=5u
X344 xN OUTN cap_mim_2f0_m4m5_noshield c_width=5u c_length=5u
X345 xN OUTN cap_mim_2f0_m4m5_noshield c_width=5u c_length=5u
X346 xN OUTN cap_mim_2f0_m4m5_noshield c_width=5u c_length=5u
X347 xN OUTN cap_mim_2f0_m4m5_noshield c_width=5u c_length=5u
X348 xN OUTN cap_mim_2f0_m4m5_noshield c_width=5u c_length=5u
X349 xN OUTN cap_mim_2f0_m4m5_noshield c_width=5u c_length=5u
X350 xN OUTN cap_mim_2f0_m4m5_noshield c_width=5u c_length=5u
X351 xN OUTN cap_mim_2f0_m4m5_noshield c_width=5u c_length=5u
X352 xN OUTN cap_mim_2f0_m4m5_noshield c_width=5u c_length=5u
X353 xN OUTN cap_mim_2f0_m4m5_noshield c_width=5u c_length=5u
X354 xN OUTN cap_mim_2f0_m4m5_noshield c_width=5u c_length=5u
X355 xN OUTN cap_mim_2f0_m4m5_noshield c_width=5u c_length=5u
X356 xN OUTN cap_mim_2f0_m4m5_noshield c_width=5u c_length=5u
X357 xN OUTN cap_mim_2f0_m4m5_noshield c_width=5u c_length=5u
X358 xN OUTN cap_mim_2f0_m4m5_noshield c_width=5u c_length=5u
X359 xN OUTN cap_mim_2f0_m4m5_noshield c_width=5u c_length=5u
X360 xN OUTN cap_mim_2f0_m4m5_noshield c_width=5u c_length=5u
X361 xN OUTN cap_mim_2f0_m4m5_noshield c_width=5u c_length=5u
X362 xN OUTN cap_mim_2f0_m4m5_noshield c_width=5u c_length=5u
X363 xN OUTN cap_mim_2f0_m4m5_noshield c_width=5u c_length=5u
X364 xN OUTN cap_mim_2f0_m4m5_noshield c_width=5u c_length=5u
X365 xN OUTN cap_mim_2f0_m4m5_noshield c_width=5u c_length=5u
X366 xN OUTN cap_mim_2f0_m4m5_noshield c_width=5u c_length=5u
.ends

.subckt sk_lpf2_MFP VSS yP OUTP
X0 OUTP yP VSS OUTP pfet_03v3 ad=1.325p pd=5.53u as=1.325p ps=5.53u w=5u l=0.28u
X1 OUTP yP VSS OUTP pfet_03v3 ad=1.325p pd=5.53u as=1.325p ps=5.53u w=5u l=0.28u
X2 VSS yP OUTP OUTP pfet_03v3 ad=1.325p pd=5.53u as=1.325p ps=5.53u w=5u l=0.28u
X3 VSS yP OUTP OUTP pfet_03v3 ad=1.325p pd=5.53u as=2.225p ps=10.89u w=5u l=0.28u
X4 VSS yP OUTP OUTP pfet_03v3 ad=1.325p pd=5.53u as=1.325p ps=5.53u w=5u l=0.28u
X5 OUTP yP VSS OUTP pfet_03v3 ad=1.325p pd=5.53u as=1.325p ps=5.53u w=5u l=0.28u
X6 VSS yP OUTP OUTP pfet_03v3 ad=1.325p pd=5.53u as=1.325p ps=5.53u w=5u l=0.28u
X7 OUTP yP VSS OUTP pfet_03v3 ad=2.225p pd=10.89u as=1.325p ps=5.53u w=5u l=0.28u
.ends

.subckt sk_lpf2_C2P yP VSS
X0 yP VSS cap_mim_2f0_m4m5_noshield c_width=5u c_length=5u
X1 yP VSS cap_mim_2f0_m4m5_noshield c_width=5u c_length=5u
X2 yP VSS cap_mim_2f0_m4m5_noshield c_width=5u c_length=5u
X3 yP VSS cap_mim_2f0_m4m5_noshield c_width=5u c_length=5u
X4 yP VSS cap_mim_2f0_m4m5_noshield c_width=5u c_length=5u
X5 yP VSS cap_mim_2f0_m4m5_noshield c_width=5u c_length=5u
X6 yP VSS cap_mim_2f0_m4m5_noshield c_width=5u c_length=5u
X7 yP VSS cap_mim_2f0_m4m5_noshield c_width=5u c_length=5u
X8 yP VSS cap_mim_2f0_m4m5_noshield c_width=5u c_length=5u
X9 yP VSS cap_mim_2f0_m4m5_noshield c_width=5u c_length=5u
X10 yP VSS cap_mim_2f0_m4m5_noshield c_width=5u c_length=5u
X11 yP VSS cap_mim_2f0_m4m5_noshield c_width=5u c_length=5u
X12 yP VSS cap_mim_2f0_m4m5_noshield c_width=5u c_length=5u
X13 yP VSS cap_mim_2f0_m4m5_noshield c_width=5u c_length=5u
X14 yP VSS cap_mim_2f0_m4m5_noshield c_width=5u c_length=5u
X15 yP VSS cap_mim_2f0_m4m5_noshield c_width=5u c_length=5u
X16 yP VSS cap_mim_2f0_m4m5_noshield c_width=5u c_length=5u
X17 yP VSS cap_mim_2f0_m4m5_noshield c_width=5u c_length=5u
X18 yP VSS cap_mim_2f0_m4m5_noshield c_width=5u c_length=5u
X19 yP VSS cap_mim_2f0_m4m5_noshield c_width=5u c_length=5u
X20 yP VSS cap_mim_2f0_m4m5_noshield c_width=5u c_length=5u
.ends

.subckt sk_lpf2_C1P xP OUTP
X0 xP OUTP cap_mim_2f0_m4m5_noshield c_width=5u c_length=5u
X1 xP OUTP cap_mim_2f0_m4m5_noshield c_width=5u c_length=5u
X2 xP OUTP cap_mim_2f0_m4m5_noshield c_width=5u c_length=5u
X3 xP OUTP cap_mim_2f0_m4m5_noshield c_width=5u c_length=5u
X4 xP OUTP cap_mim_2f0_m4m5_noshield c_width=5u c_length=5u
X5 xP OUTP cap_mim_2f0_m4m5_noshield c_width=5u c_length=5u
X6 xP OUTP cap_mim_2f0_m4m5_noshield c_width=5u c_length=5u
X7 xP OUTP cap_mim_2f0_m4m5_noshield c_width=5u c_length=5u
X8 xP OUTP cap_mim_2f0_m4m5_noshield c_width=5u c_length=5u
X9 xP OUTP cap_mim_2f0_m4m5_noshield c_width=5u c_length=5u
X10 xP OUTP cap_mim_2f0_m4m5_noshield c_width=5u c_length=5u
X11 xP OUTP cap_mim_2f0_m4m5_noshield c_width=5u c_length=5u
X12 xP OUTP cap_mim_2f0_m4m5_noshield c_width=5u c_length=5u
X13 xP OUTP cap_mim_2f0_m4m5_noshield c_width=5u c_length=5u
X14 xP OUTP cap_mim_2f0_m4m5_noshield c_width=5u c_length=5u
X15 xP OUTP cap_mim_2f0_m4m5_noshield c_width=5u c_length=5u
X16 xP OUTP cap_mim_2f0_m4m5_noshield c_width=5u c_length=5u
X17 xP OUTP cap_mim_2f0_m4m5_noshield c_width=5u c_length=5u
X18 xP OUTP cap_mim_2f0_m4m5_noshield c_width=5u c_length=5u
X19 xP OUTP cap_mim_2f0_m4m5_noshield c_width=5u c_length=5u
X20 xP OUTP cap_mim_2f0_m4m5_noshield c_width=5u c_length=5u
X21 xP OUTP cap_mim_2f0_m4m5_noshield c_width=5u c_length=5u
X22 xP OUTP cap_mim_2f0_m4m5_noshield c_width=5u c_length=5u
X23 xP OUTP cap_mim_2f0_m4m5_noshield c_width=5u c_length=5u
X24 xP OUTP cap_mim_2f0_m4m5_noshield c_width=5u c_length=5u
X25 xP OUTP cap_mim_2f0_m4m5_noshield c_width=5u c_length=5u
X26 xP OUTP cap_mim_2f0_m4m5_noshield c_width=5u c_length=5u
X27 xP OUTP cap_mim_2f0_m4m5_noshield c_width=5u c_length=5u
X28 xP OUTP cap_mim_2f0_m4m5_noshield c_width=5u c_length=5u
X29 xP OUTP cap_mim_2f0_m4m5_noshield c_width=5u c_length=5u
X30 xP OUTP cap_mim_2f0_m4m5_noshield c_width=5u c_length=5u
X31 xP OUTP cap_mim_2f0_m4m5_noshield c_width=5u c_length=5u
X32 xP OUTP cap_mim_2f0_m4m5_noshield c_width=5u c_length=5u
X33 xP OUTP cap_mim_2f0_m4m5_noshield c_width=5u c_length=5u
X34 xP OUTP cap_mim_2f0_m4m5_noshield c_width=5u c_length=5u
X35 xP OUTP cap_mim_2f0_m4m5_noshield c_width=5u c_length=5u
X36 xP OUTP cap_mim_2f0_m4m5_noshield c_width=5u c_length=5u
X37 xP OUTP cap_mim_2f0_m4m5_noshield c_width=5u c_length=5u
X38 xP OUTP cap_mim_2f0_m4m5_noshield c_width=5u c_length=5u
X39 xP OUTP cap_mim_2f0_m4m5_noshield c_width=5u c_length=5u
X40 xP OUTP cap_mim_2f0_m4m5_noshield c_width=5u c_length=5u
X41 xP OUTP cap_mim_2f0_m4m5_noshield c_width=5u c_length=5u
X42 xP OUTP cap_mim_2f0_m4m5_noshield c_width=5u c_length=5u
X43 xP OUTP cap_mim_2f0_m4m5_noshield c_width=5u c_length=5u
X44 xP OUTP cap_mim_2f0_m4m5_noshield c_width=5u c_length=5u
X45 xP OUTP cap_mim_2f0_m4m5_noshield c_width=5u c_length=5u
X46 xP OUTP cap_mim_2f0_m4m5_noshield c_width=5u c_length=5u
X47 xP OUTP cap_mim_2f0_m4m5_noshield c_width=5u c_length=5u
X48 xP OUTP cap_mim_2f0_m4m5_noshield c_width=5u c_length=5u
X49 xP OUTP cap_mim_2f0_m4m5_noshield c_width=5u c_length=5u
X50 xP OUTP cap_mim_2f0_m4m5_noshield c_width=5u c_length=5u
X51 xP OUTP cap_mim_2f0_m4m5_noshield c_width=5u c_length=5u
X52 xP OUTP cap_mim_2f0_m4m5_noshield c_width=5u c_length=5u
X53 xP OUTP cap_mim_2f0_m4m5_noshield c_width=5u c_length=5u
X54 xP OUTP cap_mim_2f0_m4m5_noshield c_width=5u c_length=5u
X55 xP OUTP cap_mim_2f0_m4m5_noshield c_width=5u c_length=5u
X56 xP OUTP cap_mim_2f0_m4m5_noshield c_width=5u c_length=5u
X57 xP OUTP cap_mim_2f0_m4m5_noshield c_width=5u c_length=5u
X58 xP OUTP cap_mim_2f0_m4m5_noshield c_width=5u c_length=5u
X59 xP OUTP cap_mim_2f0_m4m5_noshield c_width=5u c_length=5u
X60 xP OUTP cap_mim_2f0_m4m5_noshield c_width=5u c_length=5u
X61 xP OUTP cap_mim_2f0_m4m5_noshield c_width=5u c_length=5u
X62 xP OUTP cap_mim_2f0_m4m5_noshield c_width=5u c_length=5u
X63 xP OUTP cap_mim_2f0_m4m5_noshield c_width=5u c_length=5u
X64 xP OUTP cap_mim_2f0_m4m5_noshield c_width=5u c_length=5u
X65 xP OUTP cap_mim_2f0_m4m5_noshield c_width=5u c_length=5u
X66 xP OUTP cap_mim_2f0_m4m5_noshield c_width=5u c_length=5u
X67 xP OUTP cap_mim_2f0_m4m5_noshield c_width=5u c_length=5u
X68 xP OUTP cap_mim_2f0_m4m5_noshield c_width=5u c_length=5u
X69 xP OUTP cap_mim_2f0_m4m5_noshield c_width=5u c_length=5u
X70 xP OUTP cap_mim_2f0_m4m5_noshield c_width=5u c_length=5u
X71 xP OUTP cap_mim_2f0_m4m5_noshield c_width=5u c_length=5u
X72 xP OUTP cap_mim_2f0_m4m5_noshield c_width=5u c_length=5u
X73 xP OUTP cap_mim_2f0_m4m5_noshield c_width=5u c_length=5u
X74 xP OUTP cap_mim_2f0_m4m5_noshield c_width=5u c_length=5u
X75 xP OUTP cap_mim_2f0_m4m5_noshield c_width=5u c_length=5u
X76 xP OUTP cap_mim_2f0_m4m5_noshield c_width=5u c_length=5u
X77 xP OUTP cap_mim_2f0_m4m5_noshield c_width=5u c_length=5u
X78 xP OUTP cap_mim_2f0_m4m5_noshield c_width=5u c_length=5u
X79 xP OUTP cap_mim_2f0_m4m5_noshield c_width=5u c_length=5u
X80 xP OUTP cap_mim_2f0_m4m5_noshield c_width=5u c_length=5u
X81 xP OUTP cap_mim_2f0_m4m5_noshield c_width=5u c_length=5u
X82 xP OUTP cap_mim_2f0_m4m5_noshield c_width=5u c_length=5u
X83 xP OUTP cap_mim_2f0_m4m5_noshield c_width=5u c_length=5u
X84 xP OUTP cap_mim_2f0_m4m5_noshield c_width=5u c_length=5u
X85 xP OUTP cap_mim_2f0_m4m5_noshield c_width=5u c_length=5u
X86 xP OUTP cap_mim_2f0_m4m5_noshield c_width=5u c_length=5u
X87 xP OUTP cap_mim_2f0_m4m5_noshield c_width=5u c_length=5u
X88 xP OUTP cap_mim_2f0_m4m5_noshield c_width=5u c_length=5u
X89 xP OUTP cap_mim_2f0_m4m5_noshield c_width=5u c_length=5u
X90 xP OUTP cap_mim_2f0_m4m5_noshield c_width=5u c_length=5u
X91 xP OUTP cap_mim_2f0_m4m5_noshield c_width=5u c_length=5u
X92 xP OUTP cap_mim_2f0_m4m5_noshield c_width=5u c_length=5u
X93 xP OUTP cap_mim_2f0_m4m5_noshield c_width=5u c_length=5u
X94 xP OUTP cap_mim_2f0_m4m5_noshield c_width=5u c_length=5u
X95 xP OUTP cap_mim_2f0_m4m5_noshield c_width=5u c_length=5u
X96 xP OUTP cap_mim_2f0_m4m5_noshield c_width=5u c_length=5u
X97 xP OUTP cap_mim_2f0_m4m5_noshield c_width=5u c_length=5u
X98 xP OUTP cap_mim_2f0_m4m5_noshield c_width=5u c_length=5u
X99 xP OUTP cap_mim_2f0_m4m5_noshield c_width=5u c_length=5u
X100 xP OUTP cap_mim_2f0_m4m5_noshield c_width=5u c_length=5u
X101 xP OUTP cap_mim_2f0_m4m5_noshield c_width=5u c_length=5u
X102 xP OUTP cap_mim_2f0_m4m5_noshield c_width=5u c_length=5u
X103 xP OUTP cap_mim_2f0_m4m5_noshield c_width=5u c_length=5u
X104 xP OUTP cap_mim_2f0_m4m5_noshield c_width=5u c_length=5u
X105 xP OUTP cap_mim_2f0_m4m5_noshield c_width=5u c_length=5u
X106 xP OUTP cap_mim_2f0_m4m5_noshield c_width=5u c_length=5u
X107 xP OUTP cap_mim_2f0_m4m5_noshield c_width=5u c_length=5u
X108 xP OUTP cap_mim_2f0_m4m5_noshield c_width=5u c_length=5u
X109 xP OUTP cap_mim_2f0_m4m5_noshield c_width=5u c_length=5u
X110 xP OUTP cap_mim_2f0_m4m5_noshield c_width=5u c_length=5u
X111 xP OUTP cap_mim_2f0_m4m5_noshield c_width=5u c_length=5u
X112 xP OUTP cap_mim_2f0_m4m5_noshield c_width=5u c_length=5u
X113 xP OUTP cap_mim_2f0_m4m5_noshield c_width=5u c_length=5u
X114 xP OUTP cap_mim_2f0_m4m5_noshield c_width=5u c_length=5u
X115 xP OUTP cap_mim_2f0_m4m5_noshield c_width=5u c_length=5u
X116 xP OUTP cap_mim_2f0_m4m5_noshield c_width=5u c_length=5u
X117 xP OUTP cap_mim_2f0_m4m5_noshield c_width=5u c_length=5u
X118 xP OUTP cap_mim_2f0_m4m5_noshield c_width=5u c_length=5u
X119 xP OUTP cap_mim_2f0_m4m5_noshield c_width=5u c_length=5u
X120 xP OUTP cap_mim_2f0_m4m5_noshield c_width=5u c_length=5u
X121 xP OUTP cap_mim_2f0_m4m5_noshield c_width=5u c_length=5u
X122 xP OUTP cap_mim_2f0_m4m5_noshield c_width=5u c_length=5u
X123 xP OUTP cap_mim_2f0_m4m5_noshield c_width=5u c_length=5u
X124 xP OUTP cap_mim_2f0_m4m5_noshield c_width=5u c_length=5u
X125 xP OUTP cap_mim_2f0_m4m5_noshield c_width=5u c_length=5u
X126 xP OUTP cap_mim_2f0_m4m5_noshield c_width=5u c_length=5u
X127 xP OUTP cap_mim_2f0_m4m5_noshield c_width=5u c_length=5u
X128 xP OUTP cap_mim_2f0_m4m5_noshield c_width=5u c_length=5u
X129 xP OUTP cap_mim_2f0_m4m5_noshield c_width=5u c_length=5u
X130 xP OUTP cap_mim_2f0_m4m5_noshield c_width=5u c_length=5u
X131 xP OUTP cap_mim_2f0_m4m5_noshield c_width=5u c_length=5u
X132 xP OUTP cap_mim_2f0_m4m5_noshield c_width=5u c_length=5u
X133 xP OUTP cap_mim_2f0_m4m5_noshield c_width=5u c_length=5u
X134 xP OUTP cap_mim_2f0_m4m5_noshield c_width=5u c_length=5u
X135 xP OUTP cap_mim_2f0_m4m5_noshield c_width=5u c_length=5u
X136 xP OUTP cap_mim_2f0_m4m5_noshield c_width=5u c_length=5u
X137 xP OUTP cap_mim_2f0_m4m5_noshield c_width=5u c_length=5u
X138 xP OUTP cap_mim_2f0_m4m5_noshield c_width=5u c_length=5u
X139 xP OUTP cap_mim_2f0_m4m5_noshield c_width=5u c_length=5u
X140 xP OUTP cap_mim_2f0_m4m5_noshield c_width=5u c_length=5u
X141 xP OUTP cap_mim_2f0_m4m5_noshield c_width=5u c_length=5u
X142 xP OUTP cap_mim_2f0_m4m5_noshield c_width=5u c_length=5u
X143 xP OUTP cap_mim_2f0_m4m5_noshield c_width=5u c_length=5u
X144 xP OUTP cap_mim_2f0_m4m5_noshield c_width=5u c_length=5u
X145 xP OUTP cap_mim_2f0_m4m5_noshield c_width=5u c_length=5u
X146 xP OUTP cap_mim_2f0_m4m5_noshield c_width=5u c_length=5u
X147 xP OUTP cap_mim_2f0_m4m5_noshield c_width=5u c_length=5u
X148 xP OUTP cap_mim_2f0_m4m5_noshield c_width=5u c_length=5u
X149 xP OUTP cap_mim_2f0_m4m5_noshield c_width=5u c_length=5u
X150 xP OUTP cap_mim_2f0_m4m5_noshield c_width=5u c_length=5u
X151 xP OUTP cap_mim_2f0_m4m5_noshield c_width=5u c_length=5u
X152 xP OUTP cap_mim_2f0_m4m5_noshield c_width=5u c_length=5u
X153 xP OUTP cap_mim_2f0_m4m5_noshield c_width=5u c_length=5u
X154 xP OUTP cap_mim_2f0_m4m5_noshield c_width=5u c_length=5u
X155 xP OUTP cap_mim_2f0_m4m5_noshield c_width=5u c_length=5u
X156 xP OUTP cap_mim_2f0_m4m5_noshield c_width=5u c_length=5u
X157 xP OUTP cap_mim_2f0_m4m5_noshield c_width=5u c_length=5u
X158 xP OUTP cap_mim_2f0_m4m5_noshield c_width=5u c_length=5u
X159 xP OUTP cap_mim_2f0_m4m5_noshield c_width=5u c_length=5u
X160 xP OUTP cap_mim_2f0_m4m5_noshield c_width=5u c_length=5u
X161 xP OUTP cap_mim_2f0_m4m5_noshield c_width=5u c_length=5u
X162 xP OUTP cap_mim_2f0_m4m5_noshield c_width=5u c_length=5u
X163 xP OUTP cap_mim_2f0_m4m5_noshield c_width=5u c_length=5u
X164 xP OUTP cap_mim_2f0_m4m5_noshield c_width=5u c_length=5u
X165 xP OUTP cap_mim_2f0_m4m5_noshield c_width=5u c_length=5u
X166 xP OUTP cap_mim_2f0_m4m5_noshield c_width=5u c_length=5u
X167 xP OUTP cap_mim_2f0_m4m5_noshield c_width=5u c_length=5u
X168 xP OUTP cap_mim_2f0_m4m5_noshield c_width=5u c_length=5u
X169 xP OUTP cap_mim_2f0_m4m5_noshield c_width=5u c_length=5u
X170 xP OUTP cap_mim_2f0_m4m5_noshield c_width=5u c_length=5u
X171 xP OUTP cap_mim_2f0_m4m5_noshield c_width=5u c_length=5u
X172 xP OUTP cap_mim_2f0_m4m5_noshield c_width=5u c_length=5u
X173 xP OUTP cap_mim_2f0_m4m5_noshield c_width=5u c_length=5u
X174 xP OUTP cap_mim_2f0_m4m5_noshield c_width=5u c_length=5u
X175 xP OUTP cap_mim_2f0_m4m5_noshield c_width=5u c_length=5u
X176 xP OUTP cap_mim_2f0_m4m5_noshield c_width=5u c_length=5u
X177 xP OUTP cap_mim_2f0_m4m5_noshield c_width=5u c_length=5u
X178 xP OUTP cap_mim_2f0_m4m5_noshield c_width=5u c_length=5u
X179 xP OUTP cap_mim_2f0_m4m5_noshield c_width=5u c_length=5u
X180 xP OUTP cap_mim_2f0_m4m5_noshield c_width=5u c_length=5u
X181 xP OUTP cap_mim_2f0_m4m5_noshield c_width=5u c_length=5u
X182 xP OUTP cap_mim_2f0_m4m5_noshield c_width=5u c_length=5u
X183 xP OUTP cap_mim_2f0_m4m5_noshield c_width=5u c_length=5u
X184 xP OUTP cap_mim_2f0_m4m5_noshield c_width=5u c_length=5u
X185 xP OUTP cap_mim_2f0_m4m5_noshield c_width=5u c_length=5u
X186 xP OUTP cap_mim_2f0_m4m5_noshield c_width=5u c_length=5u
X187 xP OUTP cap_mim_2f0_m4m5_noshield c_width=5u c_length=5u
X188 xP OUTP cap_mim_2f0_m4m5_noshield c_width=5u c_length=5u
X189 xP OUTP cap_mim_2f0_m4m5_noshield c_width=5u c_length=5u
X190 xP OUTP cap_mim_2f0_m4m5_noshield c_width=5u c_length=5u
X191 xP OUTP cap_mim_2f0_m4m5_noshield c_width=5u c_length=5u
X192 xP OUTP cap_mim_2f0_m4m5_noshield c_width=5u c_length=5u
X193 xP OUTP cap_mim_2f0_m4m5_noshield c_width=5u c_length=5u
X194 xP OUTP cap_mim_2f0_m4m5_noshield c_width=5u c_length=5u
X195 xP OUTP cap_mim_2f0_m4m5_noshield c_width=5u c_length=5u
X196 xP OUTP cap_mim_2f0_m4m5_noshield c_width=5u c_length=5u
X197 xP OUTP cap_mim_2f0_m4m5_noshield c_width=5u c_length=5u
X198 xP OUTP cap_mim_2f0_m4m5_noshield c_width=5u c_length=5u
X199 xP OUTP cap_mim_2f0_m4m5_noshield c_width=5u c_length=5u
X200 xP OUTP cap_mim_2f0_m4m5_noshield c_width=5u c_length=5u
X201 xP OUTP cap_mim_2f0_m4m5_noshield c_width=5u c_length=5u
X202 xP OUTP cap_mim_2f0_m4m5_noshield c_width=5u c_length=5u
X203 xP OUTP cap_mim_2f0_m4m5_noshield c_width=5u c_length=5u
X204 xP OUTP cap_mim_2f0_m4m5_noshield c_width=5u c_length=5u
X205 xP OUTP cap_mim_2f0_m4m5_noshield c_width=5u c_length=5u
X206 xP OUTP cap_mim_2f0_m4m5_noshield c_width=5u c_length=5u
X207 xP OUTP cap_mim_2f0_m4m5_noshield c_width=5u c_length=5u
X208 xP OUTP cap_mim_2f0_m4m5_noshield c_width=5u c_length=5u
X209 xP OUTP cap_mim_2f0_m4m5_noshield c_width=5u c_length=5u
X210 xP OUTP cap_mim_2f0_m4m5_noshield c_width=5u c_length=5u
X211 xP OUTP cap_mim_2f0_m4m5_noshield c_width=5u c_length=5u
X212 xP OUTP cap_mim_2f0_m4m5_noshield c_width=5u c_length=5u
X213 xP OUTP cap_mim_2f0_m4m5_noshield c_width=5u c_length=5u
X214 xP OUTP cap_mim_2f0_m4m5_noshield c_width=5u c_length=5u
X215 xP OUTP cap_mim_2f0_m4m5_noshield c_width=5u c_length=5u
X216 xP OUTP cap_mim_2f0_m4m5_noshield c_width=5u c_length=5u
X217 xP OUTP cap_mim_2f0_m4m5_noshield c_width=5u c_length=5u
X218 xP OUTP cap_mim_2f0_m4m5_noshield c_width=5u c_length=5u
X219 xP OUTP cap_mim_2f0_m4m5_noshield c_width=5u c_length=5u
X220 xP OUTP cap_mim_2f0_m4m5_noshield c_width=5u c_length=5u
X221 xP OUTP cap_mim_2f0_m4m5_noshield c_width=5u c_length=5u
X222 xP OUTP cap_mim_2f0_m4m5_noshield c_width=5u c_length=5u
X223 xP OUTP cap_mim_2f0_m4m5_noshield c_width=5u c_length=5u
X224 xP OUTP cap_mim_2f0_m4m5_noshield c_width=5u c_length=5u
X225 xP OUTP cap_mim_2f0_m4m5_noshield c_width=5u c_length=5u
X226 xP OUTP cap_mim_2f0_m4m5_noshield c_width=5u c_length=5u
X227 xP OUTP cap_mim_2f0_m4m5_noshield c_width=5u c_length=5u
X228 xP OUTP cap_mim_2f0_m4m5_noshield c_width=5u c_length=5u
X229 xP OUTP cap_mim_2f0_m4m5_noshield c_width=5u c_length=5u
X230 xP OUTP cap_mim_2f0_m4m5_noshield c_width=5u c_length=5u
X231 xP OUTP cap_mim_2f0_m4m5_noshield c_width=5u c_length=5u
X232 xP OUTP cap_mim_2f0_m4m5_noshield c_width=5u c_length=5u
X233 xP OUTP cap_mim_2f0_m4m5_noshield c_width=5u c_length=5u
X234 xP OUTP cap_mim_2f0_m4m5_noshield c_width=5u c_length=5u
X235 xP OUTP cap_mim_2f0_m4m5_noshield c_width=5u c_length=5u
X236 xP OUTP cap_mim_2f0_m4m5_noshield c_width=5u c_length=5u
X237 xP OUTP cap_mim_2f0_m4m5_noshield c_width=5u c_length=5u
X238 xP OUTP cap_mim_2f0_m4m5_noshield c_width=5u c_length=5u
X239 xP OUTP cap_mim_2f0_m4m5_noshield c_width=5u c_length=5u
X240 xP OUTP cap_mim_2f0_m4m5_noshield c_width=5u c_length=5u
X241 xP OUTP cap_mim_2f0_m4m5_noshield c_width=5u c_length=5u
X242 xP OUTP cap_mim_2f0_m4m5_noshield c_width=5u c_length=5u
X243 xP OUTP cap_mim_2f0_m4m5_noshield c_width=5u c_length=5u
X244 xP OUTP cap_mim_2f0_m4m5_noshield c_width=5u c_length=5u
X245 xP OUTP cap_mim_2f0_m4m5_noshield c_width=5u c_length=5u
X246 xP OUTP cap_mim_2f0_m4m5_noshield c_width=5u c_length=5u
X247 xP OUTP cap_mim_2f0_m4m5_noshield c_width=5u c_length=5u
X248 xP OUTP cap_mim_2f0_m4m5_noshield c_width=5u c_length=5u
X249 xP OUTP cap_mim_2f0_m4m5_noshield c_width=5u c_length=5u
X250 xP OUTP cap_mim_2f0_m4m5_noshield c_width=5u c_length=5u
X251 xP OUTP cap_mim_2f0_m4m5_noshield c_width=5u c_length=5u
X252 xP OUTP cap_mim_2f0_m4m5_noshield c_width=5u c_length=5u
X253 xP OUTP cap_mim_2f0_m4m5_noshield c_width=5u c_length=5u
X254 xP OUTP cap_mim_2f0_m4m5_noshield c_width=5u c_length=5u
X255 xP OUTP cap_mim_2f0_m4m5_noshield c_width=5u c_length=5u
X256 xP OUTP cap_mim_2f0_m4m5_noshield c_width=5u c_length=5u
X257 xP OUTP cap_mim_2f0_m4m5_noshield c_width=5u c_length=5u
X258 xP OUTP cap_mim_2f0_m4m5_noshield c_width=5u c_length=5u
X259 xP OUTP cap_mim_2f0_m4m5_noshield c_width=5u c_length=5u
X260 xP OUTP cap_mim_2f0_m4m5_noshield c_width=5u c_length=5u
X261 xP OUTP cap_mim_2f0_m4m5_noshield c_width=5u c_length=5u
X262 xP OUTP cap_mim_2f0_m4m5_noshield c_width=5u c_length=5u
X263 xP OUTP cap_mim_2f0_m4m5_noshield c_width=5u c_length=5u
X264 xP OUTP cap_mim_2f0_m4m5_noshield c_width=5u c_length=5u
X265 xP OUTP cap_mim_2f0_m4m5_noshield c_width=5u c_length=5u
X266 xP OUTP cap_mim_2f0_m4m5_noshield c_width=5u c_length=5u
X267 xP OUTP cap_mim_2f0_m4m5_noshield c_width=5u c_length=5u
X268 xP OUTP cap_mim_2f0_m4m5_noshield c_width=5u c_length=5u
X269 xP OUTP cap_mim_2f0_m4m5_noshield c_width=5u c_length=5u
X270 xP OUTP cap_mim_2f0_m4m5_noshield c_width=5u c_length=5u
X271 xP OUTP cap_mim_2f0_m4m5_noshield c_width=5u c_length=5u
X272 xP OUTP cap_mim_2f0_m4m5_noshield c_width=5u c_length=5u
X273 xP OUTP cap_mim_2f0_m4m5_noshield c_width=5u c_length=5u
X274 xP OUTP cap_mim_2f0_m4m5_noshield c_width=5u c_length=5u
X275 xP OUTP cap_mim_2f0_m4m5_noshield c_width=5u c_length=5u
X276 xP OUTP cap_mim_2f0_m4m5_noshield c_width=5u c_length=5u
X277 xP OUTP cap_mim_2f0_m4m5_noshield c_width=5u c_length=5u
X278 xP OUTP cap_mim_2f0_m4m5_noshield c_width=5u c_length=5u
X279 xP OUTP cap_mim_2f0_m4m5_noshield c_width=5u c_length=5u
X280 xP OUTP cap_mim_2f0_m4m5_noshield c_width=5u c_length=5u
X281 xP OUTP cap_mim_2f0_m4m5_noshield c_width=5u c_length=5u
X282 xP OUTP cap_mim_2f0_m4m5_noshield c_width=5u c_length=5u
X283 xP OUTP cap_mim_2f0_m4m5_noshield c_width=5u c_length=5u
X284 xP OUTP cap_mim_2f0_m4m5_noshield c_width=5u c_length=5u
X285 xP OUTP cap_mim_2f0_m4m5_noshield c_width=5u c_length=5u
X286 xP OUTP cap_mim_2f0_m4m5_noshield c_width=5u c_length=5u
X287 xP OUTP cap_mim_2f0_m4m5_noshield c_width=5u c_length=5u
X288 xP OUTP cap_mim_2f0_m4m5_noshield c_width=5u c_length=5u
X289 xP OUTP cap_mim_2f0_m4m5_noshield c_width=5u c_length=5u
X290 xP OUTP cap_mim_2f0_m4m5_noshield c_width=5u c_length=5u
X291 xP OUTP cap_mim_2f0_m4m5_noshield c_width=5u c_length=5u
X292 xP OUTP cap_mim_2f0_m4m5_noshield c_width=5u c_length=5u
X293 xP OUTP cap_mim_2f0_m4m5_noshield c_width=5u c_length=5u
X294 xP OUTP cap_mim_2f0_m4m5_noshield c_width=5u c_length=5u
X295 xP OUTP cap_mim_2f0_m4m5_noshield c_width=5u c_length=5u
X296 xP OUTP cap_mim_2f0_m4m5_noshield c_width=5u c_length=5u
X297 xP OUTP cap_mim_2f0_m4m5_noshield c_width=5u c_length=5u
X298 xP OUTP cap_mim_2f0_m4m5_noshield c_width=5u c_length=5u
X299 xP OUTP cap_mim_2f0_m4m5_noshield c_width=5u c_length=5u
X300 xP OUTP cap_mim_2f0_m4m5_noshield c_width=5u c_length=5u
X301 xP OUTP cap_mim_2f0_m4m5_noshield c_width=5u c_length=5u
X302 xP OUTP cap_mim_2f0_m4m5_noshield c_width=5u c_length=5u
X303 xP OUTP cap_mim_2f0_m4m5_noshield c_width=5u c_length=5u
X304 xP OUTP cap_mim_2f0_m4m5_noshield c_width=5u c_length=5u
X305 xP OUTP cap_mim_2f0_m4m5_noshield c_width=5u c_length=5u
X306 xP OUTP cap_mim_2f0_m4m5_noshield c_width=5u c_length=5u
X307 xP OUTP cap_mim_2f0_m4m5_noshield c_width=5u c_length=5u
X308 xP OUTP cap_mim_2f0_m4m5_noshield c_width=5u c_length=5u
X309 xP OUTP cap_mim_2f0_m4m5_noshield c_width=5u c_length=5u
X310 xP OUTP cap_mim_2f0_m4m5_noshield c_width=5u c_length=5u
X311 xP OUTP cap_mim_2f0_m4m5_noshield c_width=5u c_length=5u
X312 xP OUTP cap_mim_2f0_m4m5_noshield c_width=5u c_length=5u
X313 xP OUTP cap_mim_2f0_m4m5_noshield c_width=5u c_length=5u
X314 xP OUTP cap_mim_2f0_m4m5_noshield c_width=5u c_length=5u
X315 xP OUTP cap_mim_2f0_m4m5_noshield c_width=5u c_length=5u
X316 xP OUTP cap_mim_2f0_m4m5_noshield c_width=5u c_length=5u
X317 xP OUTP cap_mim_2f0_m4m5_noshield c_width=5u c_length=5u
X318 xP OUTP cap_mim_2f0_m4m5_noshield c_width=5u c_length=5u
X319 xP OUTP cap_mim_2f0_m4m5_noshield c_width=5u c_length=5u
X320 xP OUTP cap_mim_2f0_m4m5_noshield c_width=5u c_length=5u
X321 xP OUTP cap_mim_2f0_m4m5_noshield c_width=5u c_length=5u
X322 xP OUTP cap_mim_2f0_m4m5_noshield c_width=5u c_length=5u
X323 xP OUTP cap_mim_2f0_m4m5_noshield c_width=5u c_length=5u
X324 xP OUTP cap_mim_2f0_m4m5_noshield c_width=5u c_length=5u
X325 xP OUTP cap_mim_2f0_m4m5_noshield c_width=5u c_length=5u
X326 xP OUTP cap_mim_2f0_m4m5_noshield c_width=5u c_length=5u
X327 xP OUTP cap_mim_2f0_m4m5_noshield c_width=5u c_length=5u
X328 xP OUTP cap_mim_2f0_m4m5_noshield c_width=5u c_length=5u
X329 xP OUTP cap_mim_2f0_m4m5_noshield c_width=5u c_length=5u
X330 xP OUTP cap_mim_2f0_m4m5_noshield c_width=5u c_length=5u
X331 xP OUTP cap_mim_2f0_m4m5_noshield c_width=5u c_length=5u
X332 xP OUTP cap_mim_2f0_m4m5_noshield c_width=5u c_length=5u
X333 xP OUTP cap_mim_2f0_m4m5_noshield c_width=5u c_length=5u
X334 xP OUTP cap_mim_2f0_m4m5_noshield c_width=5u c_length=5u
X335 xP OUTP cap_mim_2f0_m4m5_noshield c_width=5u c_length=5u
X336 xP OUTP cap_mim_2f0_m4m5_noshield c_width=5u c_length=5u
X337 xP OUTP cap_mim_2f0_m4m5_noshield c_width=5u c_length=5u
X338 xP OUTP cap_mim_2f0_m4m5_noshield c_width=5u c_length=5u
X339 xP OUTP cap_mim_2f0_m4m5_noshield c_width=5u c_length=5u
X340 xP OUTP cap_mim_2f0_m4m5_noshield c_width=5u c_length=5u
X341 xP OUTP cap_mim_2f0_m4m5_noshield c_width=5u c_length=5u
X342 xP OUTP cap_mim_2f0_m4m5_noshield c_width=5u c_length=5u
X343 xP OUTP cap_mim_2f0_m4m5_noshield c_width=5u c_length=5u
X344 xP OUTP cap_mim_2f0_m4m5_noshield c_width=5u c_length=5u
X345 xP OUTP cap_mim_2f0_m4m5_noshield c_width=5u c_length=5u
X346 xP OUTP cap_mim_2f0_m4m5_noshield c_width=5u c_length=5u
X347 xP OUTP cap_mim_2f0_m4m5_noshield c_width=5u c_length=5u
X348 xP OUTP cap_mim_2f0_m4m5_noshield c_width=5u c_length=5u
X349 xP OUTP cap_mim_2f0_m4m5_noshield c_width=5u c_length=5u
X350 xP OUTP cap_mim_2f0_m4m5_noshield c_width=5u c_length=5u
X351 xP OUTP cap_mim_2f0_m4m5_noshield c_width=5u c_length=5u
X352 xP OUTP cap_mim_2f0_m4m5_noshield c_width=5u c_length=5u
X353 xP OUTP cap_mim_2f0_m4m5_noshield c_width=5u c_length=5u
X354 xP OUTP cap_mim_2f0_m4m5_noshield c_width=5u c_length=5u
X355 xP OUTP cap_mim_2f0_m4m5_noshield c_width=5u c_length=5u
X356 xP OUTP cap_mim_2f0_m4m5_noshield c_width=5u c_length=5u
X357 xP OUTP cap_mim_2f0_m4m5_noshield c_width=5u c_length=5u
X358 xP OUTP cap_mim_2f0_m4m5_noshield c_width=5u c_length=5u
X359 xP OUTP cap_mim_2f0_m4m5_noshield c_width=5u c_length=5u
X360 xP OUTP cap_mim_2f0_m4m5_noshield c_width=5u c_length=5u
X361 xP OUTP cap_mim_2f0_m4m5_noshield c_width=5u c_length=5u
X362 xP OUTP cap_mim_2f0_m4m5_noshield c_width=5u c_length=5u
X363 xP OUTP cap_mim_2f0_m4m5_noshield c_width=5u c_length=5u
X364 xP OUTP cap_mim_2f0_m4m5_noshield c_width=5u c_length=5u
X365 xP OUTP cap_mim_2f0_m4m5_noshield c_width=5u c_length=5u
X366 xP OUTP cap_mim_2f0_m4m5_noshield c_width=5u c_length=5u
.ends

.subckt sk_lpf2_R1u_0 xP INP xN INN yP yN VSS
X0 xN yN VSS ppolyf_u_1k r_width=1u r_length=3u
X1 INN xN VSS ppolyf_u_1k r_width=1u r_length=1u
X2 xP yP VSS ppolyf_u_1k r_width=1u r_length=3u
X3 INP xP VSS ppolyf_u_1k r_width=1u r_length=1u
.ends

.subckt sk_lpf2_MIP_MIN OUTP OUTN PB VDD
X0 VDD PB OUTP VDD pfet_03v3 ad=4.45p pd=20.89u as=2.65p ps=10.53u w=10u l=2u
X1 VDD PB OUTP VDD pfet_03v3 ad=2.65p pd=10.53u as=2.65p ps=10.53u w=10u l=2u
X2 OUTN PB VDD VDD pfet_03v3 ad=2.65p pd=10.53u as=2.65p ps=10.53u w=10u l=2u
X3 OUTP PB VDD VDD pfet_03v3 ad=2.65p pd=10.53u as=2.65p ps=10.53u w=10u l=2u
X4 OUTP PB VDD VDD pfet_03v3 ad=2.65p pd=10.53u as=2.65p ps=10.53u w=10u l=2u
X5 OUTN PB VDD VDD pfet_03v3 ad=2.65p pd=10.53u as=2.65p ps=10.53u w=10u l=2u
X6 VDD PB OUTP VDD pfet_03v3 ad=2.65p pd=10.53u as=2.65p ps=10.53u w=10u l=2u
X7 OUTN PB VDD VDD pfet_03v3 ad=2.65p pd=10.53u as=2.65p ps=10.53u w=10u l=2u
X8 VDD PB OUTN VDD pfet_03v3 ad=2.65p pd=10.53u as=2.65p ps=10.53u w=10u l=2u
X9 VDD PB OUTN VDD pfet_03v3 ad=2.65p pd=10.53u as=2.65p ps=10.53u w=10u l=2u
X10 VDD PB OUTN VDD pfet_03v3 ad=2.65p pd=10.53u as=2.65p ps=10.53u w=10u l=2u
X11 OUTP PB VDD VDD pfet_03v3 ad=2.65p pd=10.53u as=2.65p ps=10.53u w=10u l=2u
X12 OUTN PB VDD VDD pfet_03v3 ad=2.65p pd=10.53u as=2.65p ps=10.53u w=10u l=2u
X13 OUTP PB VDD VDD pfet_03v3 ad=2.65p pd=10.53u as=2.65p ps=10.53u w=10u l=2u
X14 VDD PB OUTN VDD pfet_03v3 ad=2.65p pd=10.53u as=2.65p ps=10.53u w=10u l=2u
X15 VDD PB OUTP VDD pfet_03v3 ad=2.65p pd=10.53u as=2.65p ps=10.53u w=10u l=2u
X16 VDD PB OUTP VDD pfet_03v3 ad=2.65p pd=10.53u as=2.65p ps=10.53u w=10u l=2u
X17 OUTP PB VDD VDD pfet_03v3 ad=2.65p pd=10.53u as=4.45p ps=20.89u w=10u l=2u
X18 OUTP PB VDD VDD pfet_03v3 ad=2.65p pd=10.53u as=2.65p ps=10.53u w=10u l=2u
X19 OUTN PB VDD VDD pfet_03v3 ad=2.65p pd=10.53u as=2.65p ps=10.53u w=10u l=2u
X20 OUTN PB VDD VDD pfet_03v3 ad=2.65p pd=10.53u as=2.65p ps=10.53u w=10u l=2u
X21 VDD PB OUTN VDD pfet_03v3 ad=2.65p pd=10.53u as=2.65p ps=10.53u w=10u l=2u
X22 VDD PB OUTP VDD pfet_03v3 ad=2.65p pd=10.53u as=2.65p ps=10.53u w=10u l=2u
X23 VDD PB OUTN VDD pfet_03v3 ad=2.65p pd=10.53u as=2.65p ps=10.53u w=10u l=2u
X24 VDD PB OUTN VDD pfet_03v3 ad=2.65p pd=10.53u as=2.65p ps=10.53u w=10u l=2u
X25 OUTN PB VDD VDD pfet_03v3 ad=2.65p pd=10.53u as=2.65p ps=10.53u w=10u l=2u
X26 OUTP PB VDD VDD pfet_03v3 ad=2.65p pd=10.53u as=2.65p ps=10.53u w=10u l=2u
X27 OUTP PB VDD VDD pfet_03v3 ad=2.65p pd=10.53u as=2.65p ps=10.53u w=10u l=2u
X28 VDD PB OUTP VDD pfet_03v3 ad=2.65p pd=10.53u as=2.65p ps=10.53u w=10u l=2u
X29 OUTN PB VDD VDD pfet_03v3 ad=2.65p pd=10.53u as=2.65p ps=10.53u w=10u l=2u
X30 VDD PB OUTP VDD pfet_03v3 ad=4.45p pd=20.89u as=2.65p ps=10.53u w=10u l=2u
X31 OUTN PB VDD VDD pfet_03v3 ad=2.65p pd=10.53u as=2.65p ps=10.53u w=10u l=2u
X32 OUTP PB VDD VDD pfet_03v3 ad=2.65p pd=10.53u as=2.65p ps=10.53u w=10u l=2u
X33 OUTN PB VDD VDD pfet_03v3 ad=2.65p pd=10.53u as=2.65p ps=10.53u w=10u l=2u
X34 OUTN PB VDD VDD pfet_03v3 ad=2.65p pd=10.53u as=2.65p ps=10.53u w=10u l=2u
X35 OUTP PB VDD VDD pfet_03v3 ad=2.65p pd=10.53u as=2.65p ps=10.53u w=10u l=2u
X36 VDD PB OUTP VDD pfet_03v3 ad=2.65p pd=10.53u as=2.65p ps=10.53u w=10u l=2u
X37 VDD PB OUTN VDD pfet_03v3 ad=2.65p pd=10.53u as=2.65p ps=10.53u w=10u l=2u
X38 VDD PB OUTP VDD pfet_03v3 ad=2.65p pd=10.53u as=2.65p ps=10.53u w=10u l=2u
X39 OUTN PB VDD VDD pfet_03v3 ad=2.65p pd=10.53u as=2.65p ps=10.53u w=10u l=2u
X40 OUTN PB VDD VDD pfet_03v3 ad=2.65p pd=10.53u as=2.65p ps=10.53u w=10u l=2u
X41 VDD PB OUTN VDD pfet_03v3 ad=2.65p pd=10.53u as=2.65p ps=10.53u w=10u l=2u
X42 VDD PB OUTP VDD pfet_03v3 ad=2.65p pd=10.53u as=2.65p ps=10.53u w=10u l=2u
X43 VDD PB OUTP VDD pfet_03v3 ad=2.65p pd=10.53u as=2.65p ps=10.53u w=10u l=2u
X44 VDD PB OUTN VDD pfet_03v3 ad=2.65p pd=10.53u as=2.65p ps=10.53u w=10u l=2u
X45 OUTP PB VDD VDD pfet_03v3 ad=2.65p pd=10.53u as=2.65p ps=10.53u w=10u l=2u
X46 VDD PB OUTN VDD pfet_03v3 ad=2.65p pd=10.53u as=2.65p ps=10.53u w=10u l=2u
X47 OUTP PB VDD VDD pfet_03v3 ad=2.65p pd=10.53u as=4.45p ps=20.89u w=10u l=2u
X48 VDD PB OUTN VDD pfet_03v3 ad=2.65p pd=10.53u as=2.65p ps=10.53u w=10u l=2u
X49 OUTP PB VDD VDD pfet_03v3 ad=2.65p pd=10.53u as=2.65p ps=10.53u w=10u l=2u
X50 VDD PB OUTP VDD pfet_03v3 ad=2.65p pd=10.53u as=2.65p ps=10.53u w=10u l=2u
X51 VDD PB OUTN VDD pfet_03v3 ad=2.65p pd=10.53u as=2.65p ps=10.53u w=10u l=2u
X52 OUTN PB VDD VDD pfet_03v3 ad=2.65p pd=10.53u as=2.65p ps=10.53u w=10u l=2u
X53 OUTP PB VDD VDD pfet_03v3 ad=2.65p pd=10.53u as=2.65p ps=10.53u w=10u l=2u
X54 OUTP PB VDD VDD pfet_03v3 ad=2.65p pd=10.53u as=2.65p ps=10.53u w=10u l=2u
X55 OUTN PB VDD VDD pfet_03v3 ad=2.65p pd=10.53u as=2.65p ps=10.53u w=10u l=2u
X56 OUTN PB VDD VDD pfet_03v3 ad=2.65p pd=10.53u as=2.65p ps=10.53u w=10u l=2u
X57 OUTP PB VDD VDD pfet_03v3 ad=2.65p pd=10.53u as=2.65p ps=10.53u w=10u l=2u
X58 OUTN PB VDD VDD pfet_03v3 ad=2.65p pd=10.53u as=2.65p ps=10.53u w=10u l=2u
X59 VDD PB OUTP VDD pfet_03v3 ad=2.65p pd=10.53u as=2.65p ps=10.53u w=10u l=2u
X60 VDD PB OUTN VDD pfet_03v3 ad=2.65p pd=10.53u as=2.65p ps=10.53u w=10u l=2u
X61 VDD PB OUTN VDD pfet_03v3 ad=2.65p pd=10.53u as=2.65p ps=10.53u w=10u l=2u
X62 OUTN PB VDD VDD pfet_03v3 ad=2.65p pd=10.53u as=2.65p ps=10.53u w=10u l=2u
X63 OUTP PB VDD VDD pfet_03v3 ad=2.65p pd=10.53u as=2.65p ps=10.53u w=10u l=2u
X64 OUTN PB VDD VDD pfet_03v3 ad=2.65p pd=10.53u as=2.65p ps=10.53u w=10u l=2u
X65 VDD PB OUTP VDD pfet_03v3 ad=2.65p pd=10.53u as=2.65p ps=10.53u w=10u l=2u
X66 OUTN PB VDD VDD pfet_03v3 ad=2.65p pd=10.53u as=2.65p ps=10.53u w=10u l=2u
X67 VDD PB OUTP VDD pfet_03v3 ad=2.65p pd=10.53u as=2.65p ps=10.53u w=10u l=2u
X68 VDD PB OUTN VDD pfet_03v3 ad=2.65p pd=10.53u as=2.65p ps=10.53u w=10u l=2u
X69 VDD PB OUTN VDD pfet_03v3 ad=2.65p pd=10.53u as=2.65p ps=10.53u w=10u l=2u
X70 OUTP PB VDD VDD pfet_03v3 ad=2.65p pd=10.53u as=2.65p ps=10.53u w=10u l=2u
X71 OUTP PB VDD VDD pfet_03v3 ad=2.65p pd=10.53u as=2.65p ps=10.53u w=10u l=2u
X72 VDD PB OUTN VDD pfet_03v3 ad=2.65p pd=10.53u as=2.65p ps=10.53u w=10u l=2u
X73 VDD PB OUTN VDD pfet_03v3 ad=2.65p pd=10.53u as=2.65p ps=10.53u w=10u l=2u
X74 VDD PB OUTP VDD pfet_03v3 ad=2.65p pd=10.53u as=2.65p ps=10.53u w=10u l=2u
X75 VDD PB OUTP VDD pfet_03v3 ad=2.65p pd=10.53u as=2.65p ps=10.53u w=10u l=2u
X76 OUTN PB VDD VDD pfet_03v3 ad=2.65p pd=10.53u as=2.65p ps=10.53u w=10u l=2u
X77 VDD PB OUTN VDD pfet_03v3 ad=2.65p pd=10.53u as=2.65p ps=10.53u w=10u l=2u
X78 OUTP PB VDD VDD pfet_03v3 ad=2.65p pd=10.53u as=2.65p ps=10.53u w=10u l=2u
X79 VDD PB OUTP VDD pfet_03v3 ad=2.65p pd=10.53u as=2.65p ps=10.53u w=10u l=2u
X80 OUTN PB VDD VDD pfet_03v3 ad=2.65p pd=10.53u as=2.65p ps=10.53u w=10u l=2u
X81 OUTN PB VDD VDD pfet_03v3 ad=2.65p pd=10.53u as=2.65p ps=10.53u w=10u l=2u
X82 OUTP PB VDD VDD pfet_03v3 ad=2.65p pd=10.53u as=2.65p ps=10.53u w=10u l=2u
X83 OUTN PB VDD VDD pfet_03v3 ad=2.65p pd=10.53u as=2.65p ps=10.53u w=10u l=2u
X84 OUTP PB VDD VDD pfet_03v3 ad=2.65p pd=10.53u as=2.65p ps=10.53u w=10u l=2u
X85 VDD PB OUTP VDD pfet_03v3 ad=2.65p pd=10.53u as=2.65p ps=10.53u w=10u l=2u
X86 VDD PB OUTN VDD pfet_03v3 ad=2.65p pd=10.53u as=2.65p ps=10.53u w=10u l=2u
X87 OUTN PB VDD VDD pfet_03v3 ad=2.65p pd=10.53u as=2.65p ps=10.53u w=10u l=2u
X88 VDD PB OUTN VDD pfet_03v3 ad=2.65p pd=10.53u as=2.65p ps=10.53u w=10u l=2u
X89 OUTP PB VDD VDD pfet_03v3 ad=2.65p pd=10.53u as=2.65p ps=10.53u w=10u l=2u
X90 OUTN PB VDD VDD pfet_03v3 ad=2.65p pd=10.53u as=2.65p ps=10.53u w=10u l=2u
X91 VDD PB OUTN VDD pfet_03v3 ad=2.65p pd=10.53u as=2.65p ps=10.53u w=10u l=2u
X92 VDD PB OUTN VDD pfet_03v3 ad=2.65p pd=10.53u as=2.65p ps=10.53u w=10u l=2u
X93 OUTP PB VDD VDD pfet_03v3 ad=2.65p pd=10.53u as=2.65p ps=10.53u w=10u l=2u
X94 VDD PB OUTP VDD pfet_03v3 ad=2.65p pd=10.53u as=2.65p ps=10.53u w=10u l=2u
X95 OUTN PB VDD VDD pfet_03v3 ad=2.65p pd=10.53u as=2.65p ps=10.53u w=10u l=2u
X96 VDD PB OUTN VDD pfet_03v3 ad=2.65p pd=10.53u as=2.65p ps=10.53u w=10u l=2u
X97 VDD PB OUTP VDD pfet_03v3 ad=2.65p pd=10.53u as=2.65p ps=10.53u w=10u l=2u
X98 VDD PB OUTN VDD pfet_03v3 ad=2.65p pd=10.53u as=2.65p ps=10.53u w=10u l=2u
X99 OUTP PB VDD VDD pfet_03v3 ad=2.65p pd=10.53u as=2.65p ps=10.53u w=10u l=2u
X100 OUTP PB VDD VDD pfet_03v3 ad=2.65p pd=10.53u as=2.65p ps=10.53u w=10u l=2u
X101 VDD PB OUTP VDD pfet_03v3 ad=2.65p pd=10.53u as=2.65p ps=10.53u w=10u l=2u
X102 VDD PB OUTN VDD pfet_03v3 ad=2.65p pd=10.53u as=2.65p ps=10.53u w=10u l=2u
X103 OUTP PB VDD VDD pfet_03v3 ad=2.65p pd=10.53u as=2.65p ps=10.53u w=10u l=2u
X104 VDD PB OUTP VDD pfet_03v3 ad=2.65p pd=10.53u as=2.65p ps=10.53u w=10u l=2u
X105 OUTN PB VDD VDD pfet_03v3 ad=2.65p pd=10.53u as=2.65p ps=10.53u w=10u l=2u
X106 OUTN PB VDD VDD pfet_03v3 ad=2.65p pd=10.53u as=2.65p ps=10.53u w=10u l=2u
X107 OUTP PB VDD VDD pfet_03v3 ad=2.65p pd=10.53u as=2.65p ps=10.53u w=10u l=2u
X108 OUTP PB VDD VDD pfet_03v3 ad=2.65p pd=10.53u as=2.65p ps=10.53u w=10u l=2u
X109 VDD PB OUTN VDD pfet_03v3 ad=2.65p pd=10.53u as=2.65p ps=10.53u w=10u l=2u
X110 OUTN PB VDD VDD pfet_03v3 ad=2.65p pd=10.53u as=2.65p ps=10.53u w=10u l=2u
X111 VDD PB OUTN VDD pfet_03v3 ad=2.65p pd=10.53u as=2.65p ps=10.53u w=10u l=2u
X112 VDD PB OUTP VDD pfet_03v3 ad=2.65p pd=10.53u as=2.65p ps=10.53u w=10u l=2u
X113 OUTP PB VDD VDD pfet_03v3 ad=2.65p pd=10.53u as=2.65p ps=10.53u w=10u l=2u
X114 OUTN PB VDD VDD pfet_03v3 ad=2.65p pd=10.53u as=2.65p ps=10.53u w=10u l=2u
X115 VDD PB OUTP VDD pfet_03v3 ad=2.65p pd=10.53u as=2.65p ps=10.53u w=10u l=2u
X116 OUTP PB VDD VDD pfet_03v3 ad=2.65p pd=10.53u as=2.65p ps=10.53u w=10u l=2u
X117 VDD PB OUTP VDD pfet_03v3 ad=2.65p pd=10.53u as=2.65p ps=10.53u w=10u l=2u
X118 VDD PB OUTP VDD pfet_03v3 ad=2.65p pd=10.53u as=2.65p ps=10.53u w=10u l=2u
X119 VDD PB OUTP VDD pfet_03v3 ad=2.65p pd=10.53u as=2.65p ps=10.53u w=10u l=2u
X120 VDD PB OUTP VDD pfet_03v3 ad=2.65p pd=10.53u as=2.65p ps=10.53u w=10u l=2u
X121 VDD PB OUTN VDD pfet_03v3 ad=2.65p pd=10.53u as=2.65p ps=10.53u w=10u l=2u
X122 OUTN PB VDD VDD pfet_03v3 ad=2.65p pd=10.53u as=2.65p ps=10.53u w=10u l=2u
X123 VDD PB OUTN VDD pfet_03v3 ad=2.65p pd=10.53u as=2.65p ps=10.53u w=10u l=2u
X124 VDD PB OUTP VDD pfet_03v3 ad=2.65p pd=10.53u as=2.65p ps=10.53u w=10u l=2u
X125 VDD PB OUTP VDD pfet_03v3 ad=2.65p pd=10.53u as=2.65p ps=10.53u w=10u l=2u
X126 VDD PB OUTN VDD pfet_03v3 ad=2.65p pd=10.53u as=2.65p ps=10.53u w=10u l=2u
X127 OUTP PB VDD VDD pfet_03v3 ad=2.65p pd=10.53u as=2.65p ps=10.53u w=10u l=2u
.ends

.subckt sk_lpf2 VSS VDD INP INN PB OUTP OUTN
XXMFN VSS XMFN/yN OUTN sk_lpf2_MFN
XXC2N XMFN/yN VSS sk_lpf2_C2N
XXC1N XC1N/xN OUTN sk_lpf2_C1N
XXMFP VSS XMFP/yP OUTP sk_lpf2_MFP
XXC2P XMFP/yP VSS sk_lpf2_C2P
XXC1P XC1P/xP OUTP sk_lpf2_C1P
XXR1u_0 XC1P/xP INP XC1N/xN INN XMFP/yP XMFN/yN VSS sk_lpf2_R1u_0
XXMIP_MIN OUTP OUTN PB VDD sk_lpf2_MIP_MIN
.ends
