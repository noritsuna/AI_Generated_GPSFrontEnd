* NGSPICE file created from adc2b.ext - technology: gf180mcuD

.subckt sa_comp_M12 x2 CLK VDD
X0 x2 CLK VDD VDD pfet_03v3 ad=0.445p pd=2.89u as=0.445p ps=2.89u w=1u l=0.28u
.ends

.subckt nor2_MP1 n1 A VDD
X0 n1 A VDD VDD pfet_03v3 ad=1.78p pd=8.89u as=1.78p ps=8.89u w=4u l=0.28u
.ends

.subckt nor2_MP2 n1 Y B VDD
X0 Y B n1 VDD pfet_03v3 ad=1.78p pd=8.89u as=1.78p ps=8.89u w=4u l=0.28u
.ends

.subckt nor2_MN1 Y A VSS
X0 Y A VSS VSS nfet_03v3 ad=0.445p pd=2.89u as=0.445p ps=2.89u w=1u l=0.28u
.ends

.subckt nor2_MN2 Y B VSS
X0 Y B VSS VSS nfet_03v3 ad=0.445p pd=2.89u as=0.445p ps=2.89u w=1u l=0.28u
.ends

.subckt nor2 VDD A B Y VSS
XXMP1 XMP2/n1 A VDD nor2_MP1
XXMP2 XMP2/n1 Y B VDD nor2_MP2
XXMN1 Y A VSS nor2_MN1
XXMN2 Y B VSS nor2_MN2
.ends

.subckt sa_comp_MT t CLK VSS
X0 VSS CLK t VSS nfet_03v3 ad=1.78p pd=8.89u as=1.06p ps=4.53u w=4u l=0.28u
X1 t CLK VSS VSS nfet_03v3 ad=1.06p pd=4.53u as=1.78p ps=8.89u w=4u l=0.28u
.ends

.subckt sa_comp_M1 t x1 INP VSS
X0 x1 INP t VSS nfet_03v3 ad=1.78p pd=8.89u as=1.78p ps=8.89u w=4u l=0.28u
.ends

.subckt sa_comp_M2 t x2 INN VSS
X0 x2 INN t VSS nfet_03v3 ad=1.78p pd=8.89u as=1.78p ps=8.89u w=4u l=0.28u
.ends

.subckt sa_comp_M3 t x2 REFP VSS
X0 x2 REFP t VSS nfet_03v3 ad=1.78p pd=8.89u as=1.78p ps=8.89u w=4u l=0.28u
.ends

.subckt sa_comp_M4 t x1 REFN VSS
X0 x1 REFN t VSS nfet_03v3 ad=1.78p pd=8.89u as=1.78p ps=8.89u w=4u l=0.28u
.ends

.subckt inv_dig_MN Y A VSS
X0 Y A VSS VSS nfet_03v3 ad=0.445p pd=2.89u as=0.445p ps=2.89u w=1u l=0.28u
.ends

.subckt inv_dig_MP Y A VDD
X0 Y A VDD VDD pfet_03v3 ad=0.89p pd=4.89u as=0.89p ps=4.89u w=2u l=0.28u
.ends

.subckt inv_dig VDD A Y VSS
XXMN Y A VSS inv_dig_MN
XXMP Y A VDD inv_dig_MP
.ends

.subckt sa_comp_M5 x1 on op VSS
X0 on op x1 VSS nfet_03v3 ad=0.89p pd=4.89u as=0.89p ps=4.89u w=2u l=0.28u
.ends

.subckt sa_comp_M6 x2 op on VSS
X0 op on x2 VSS nfet_03v3 ad=0.89p pd=4.89u as=0.89p ps=4.89u w=2u l=0.28u
.ends

.subckt sa_comp_M7 on op VDD
X0 on op VDD VDD pfet_03v3 ad=0.89p pd=4.89u as=0.89p ps=4.89u w=2u l=0.28u
.ends

.subckt sa_comp_M9 on CLK VDD
X0 on CLK VDD VDD pfet_03v3 ad=0.445p pd=2.89u as=0.445p ps=2.89u w=1u l=0.28u
.ends

.subckt sa_comp_M8 op on VDD
X0 op on VDD VDD pfet_03v3 ad=0.89p pd=4.89u as=0.89p ps=4.89u w=2u l=0.28u
.ends

.subckt sa_comp_M10 op CLK VDD
X0 op CLK VDD VDD pfet_03v3 ad=0.445p pd=2.89u as=0.445p ps=2.89u w=1u l=0.28u
.ends

.subckt sa_comp_M11 x1 CLK VDD
X0 x1 CLK VDD VDD pfet_03v3 ad=0.445p pd=2.89u as=0.445p ps=2.89u w=1u l=0.28u
.ends

.subckt sa_comp VDD INP INN REFP REFN CLK Q QB VSS
XXM12 XM6/x2 CLK VDD sa_comp_M12
XXS1 VDD XS1/A QB Q VSS nor2
XXS2 VDD XS2/A Q QB VSS nor2
XXMT XMT/t CLK VSS sa_comp_MT
XXM1 XMT/t XM5/x1 INP VSS sa_comp_M1
XXM2 XMT/t XM6/x2 INN VSS sa_comp_M2
XXM3 XMT/t XM6/x2 REFP VSS sa_comp_M3
XXM4 XMT/t XM5/x1 REFN VSS sa_comp_M4
XXI1 VDD XI1/A XS1/A VSS inv_dig
XXM5 XM5/x1 XI2/A XI1/A VSS sa_comp_M5
XXI2 VDD XI2/A XS2/A VSS inv_dig
XXM6 XM6/x2 XI1/A XI2/A VSS sa_comp_M6
XXM7 XI2/A XI1/A VDD sa_comp_M7
XXM9 XI2/A CLK VDD sa_comp_M9
XXM8 XI1/A XI2/A VDD sa_comp_M8
XXM10 XI1/A CLK VDD sa_comp_M10
XXM11 XM5/x1 CLK VDD sa_comp_M11
.ends

.subckt adc2b_CT1 thp VSS
X0 thp VSS cap_mim_2f0_m4m5_noshield c_width=5u c_length=5u
X1 thp VSS cap_mim_2f0_m4m5_noshield c_width=5u c_length=5u
X2 thp VSS cap_mim_2f0_m4m5_noshield c_width=5u c_length=5u
X3 thp VSS cap_mim_2f0_m4m5_noshield c_width=5u c_length=5u
X4 thp VSS cap_mim_2f0_m4m5_noshield c_width=5u c_length=5u
X5 thp VSS cap_mim_2f0_m4m5_noshield c_width=5u c_length=5u
X6 thp VSS cap_mim_2f0_m4m5_noshield c_width=5u c_length=5u
X7 thp VSS cap_mim_2f0_m4m5_noshield c_width=5u c_length=5u
X8 thp VSS cap_mim_2f0_m4m5_noshield c_width=5u c_length=5u
X9 thp VSS cap_mim_2f0_m4m5_noshield c_width=5u c_length=5u
X10 thp VSS cap_mim_2f0_m4m5_noshield c_width=5u c_length=5u
X11 thp VSS cap_mim_2f0_m4m5_noshield c_width=5u c_length=5u
X12 thp VSS cap_mim_2f0_m4m5_noshield c_width=5u c_length=5u
X13 thp VSS cap_mim_2f0_m4m5_noshield c_width=5u c_length=5u
X14 thp VSS cap_mim_2f0_m4m5_noshield c_width=5u c_length=5u
X15 thp VSS cap_mim_2f0_m4m5_noshield c_width=5u c_length=5u
X16 thp VSS cap_mim_2f0_m4m5_noshield c_width=5u c_length=5u
X17 thp VSS cap_mim_2f0_m4m5_noshield c_width=5u c_length=5u
X18 thp VSS cap_mim_2f0_m4m5_noshield c_width=5u c_length=5u
X19 thp VSS cap_mim_2f0_m4m5_noshield c_width=5u c_length=5u
X20 thp VSS cap_mim_2f0_m4m5_noshield c_width=5u c_length=5u
X21 thp VSS cap_mim_2f0_m4m5_noshield c_width=5u c_length=5u
X22 thp VSS cap_mim_2f0_m4m5_noshield c_width=5u c_length=5u
X23 thp VSS cap_mim_2f0_m4m5_noshield c_width=5u c_length=5u
X24 thp VSS cap_mim_2f0_m4m5_noshield c_width=5u c_length=5u
X25 thp VSS cap_mim_2f0_m4m5_noshield c_width=5u c_length=5u
X26 thp VSS cap_mim_2f0_m4m5_noshield c_width=5u c_length=5u
X27 thp VSS cap_mim_2f0_m4m5_noshield c_width=5u c_length=5u
X28 thp VSS cap_mim_2f0_m4m5_noshield c_width=5u c_length=5u
X29 thp VSS cap_mim_2f0_m4m5_noshield c_width=5u c_length=5u
X30 thp VSS cap_mim_2f0_m4m5_noshield c_width=5u c_length=5u
X31 thp VSS cap_mim_2f0_m4m5_noshield c_width=5u c_length=5u
X32 thp VSS cap_mim_2f0_m4m5_noshield c_width=5u c_length=5u
X33 thp VSS cap_mim_2f0_m4m5_noshield c_width=5u c_length=5u
X34 thp VSS cap_mim_2f0_m4m5_noshield c_width=5u c_length=5u
X35 thp VSS cap_mim_2f0_m4m5_noshield c_width=5u c_length=5u
X36 thp VSS cap_mim_2f0_m4m5_noshield c_width=5u c_length=5u
X37 thp VSS cap_mim_2f0_m4m5_noshield c_width=5u c_length=5u
X38 thp VSS cap_mim_2f0_m4m5_noshield c_width=5u c_length=5u
X39 thp VSS cap_mim_2f0_m4m5_noshield c_width=5u c_length=5u
X40 thp VSS cap_mim_2f0_m4m5_noshield c_width=5u c_length=5u
X41 thp VSS cap_mim_2f0_m4m5_noshield c_width=5u c_length=5u
X42 thp VSS cap_mim_2f0_m4m5_noshield c_width=5u c_length=5u
X43 thp VSS cap_mim_2f0_m4m5_noshield c_width=5u c_length=5u
X44 thp VSS cap_mim_2f0_m4m5_noshield c_width=5u c_length=5u
X45 thp VSS cap_mim_2f0_m4m5_noshield c_width=5u c_length=5u
X46 thp VSS cap_mim_2f0_m4m5_noshield c_width=5u c_length=5u
X47 thp VSS cap_mim_2f0_m4m5_noshield c_width=5u c_length=5u
X48 thp VSS cap_mim_2f0_m4m5_noshield c_width=5u c_length=5u
X49 thp VSS cap_mim_2f0_m4m5_noshield c_width=5u c_length=5u
X50 thp VSS cap_mim_2f0_m4m5_noshield c_width=5u c_length=5u
X51 thp VSS cap_mim_2f0_m4m5_noshield c_width=5u c_length=5u
X52 thp VSS cap_mim_2f0_m4m5_noshield c_width=5u c_length=5u
X53 thp VSS cap_mim_2f0_m4m5_noshield c_width=5u c_length=5u
X54 thp VSS cap_mim_2f0_m4m5_noshield c_width=5u c_length=5u
X55 thp VSS cap_mim_2f0_m4m5_noshield c_width=5u c_length=5u
X56 thp VSS cap_mim_2f0_m4m5_noshield c_width=5u c_length=5u
X57 thp VSS cap_mim_2f0_m4m5_noshield c_width=5u c_length=5u
X58 thp VSS cap_mim_2f0_m4m5_noshield c_width=5u c_length=5u
X59 thp VSS cap_mim_2f0_m4m5_noshield c_width=5u c_length=5u
X60 thp VSS cap_mim_2f0_m4m5_noshield c_width=5u c_length=5u
X61 thp VSS cap_mim_2f0_m4m5_noshield c_width=5u c_length=5u
X62 thp VSS cap_mim_2f0_m4m5_noshield c_width=5u c_length=5u
X63 thp VSS cap_mim_2f0_m4m5_noshield c_width=5u c_length=5u
X64 thp VSS cap_mim_2f0_m4m5_noshield c_width=5u c_length=5u
X65 thp VSS cap_mim_2f0_m4m5_noshield c_width=5u c_length=5u
X66 thp VSS cap_mim_2f0_m4m5_noshield c_width=5u c_length=5u
X67 thp VSS cap_mim_2f0_m4m5_noshield c_width=5u c_length=5u
X68 thp VSS cap_mim_2f0_m4m5_noshield c_width=5u c_length=5u
X69 thp VSS cap_mim_2f0_m4m5_noshield c_width=5u c_length=5u
X70 thp VSS cap_mim_2f0_m4m5_noshield c_width=5u c_length=5u
X71 thp VSS cap_mim_2f0_m4m5_noshield c_width=5u c_length=5u
X72 thp VSS cap_mim_2f0_m4m5_noshield c_width=5u c_length=5u
X73 thp VSS cap_mim_2f0_m4m5_noshield c_width=5u c_length=5u
X74 thp VSS cap_mim_2f0_m4m5_noshield c_width=5u c_length=5u
X75 thp VSS cap_mim_2f0_m4m5_noshield c_width=5u c_length=5u
X76 thp VSS cap_mim_2f0_m4m5_noshield c_width=5u c_length=5u
X77 thp VSS cap_mim_2f0_m4m5_noshield c_width=5u c_length=5u
X78 thp VSS cap_mim_2f0_m4m5_noshield c_width=5u c_length=5u
X79 thp VSS cap_mim_2f0_m4m5_noshield c_width=5u c_length=5u
X80 thp VSS cap_mim_2f0_m4m5_noshield c_width=5u c_length=5u
X81 thp VSS cap_mim_2f0_m4m5_noshield c_width=5u c_length=5u
X82 thp VSS cap_mim_2f0_m4m5_noshield c_width=5u c_length=5u
X83 thp VSS cap_mim_2f0_m4m5_noshield c_width=5u c_length=5u
X84 thp VSS cap_mim_2f0_m4m5_noshield c_width=5u c_length=5u
X85 thp VSS cap_mim_2f0_m4m5_noshield c_width=5u c_length=5u
X86 thp VSS cap_mim_2f0_m4m5_noshield c_width=5u c_length=5u
X87 thp VSS cap_mim_2f0_m4m5_noshield c_width=5u c_length=5u
X88 thp VSS cap_mim_2f0_m4m5_noshield c_width=5u c_length=5u
X89 thp VSS cap_mim_2f0_m4m5_noshield c_width=5u c_length=5u
X90 thp VSS cap_mim_2f0_m4m5_noshield c_width=5u c_length=5u
X91 thp VSS cap_mim_2f0_m4m5_noshield c_width=5u c_length=5u
X92 thp VSS cap_mim_2f0_m4m5_noshield c_width=5u c_length=5u
X93 thp VSS cap_mim_2f0_m4m5_noshield c_width=5u c_length=5u
X94 thp VSS cap_mim_2f0_m4m5_noshield c_width=5u c_length=5u
X95 thp VSS cap_mim_2f0_m4m5_noshield c_width=5u c_length=5u
X96 thp VSS cap_mim_2f0_m4m5_noshield c_width=5u c_length=5u
X97 thp VSS cap_mim_2f0_m4m5_noshield c_width=5u c_length=5u
X98 thp VSS cap_mim_2f0_m4m5_noshield c_width=5u c_length=5u
X99 thp VSS cap_mim_2f0_m4m5_noshield c_width=5u c_length=5u
.ends

.subckt adc2b_CT2 thm VSS
X0 thm VSS cap_mim_2f0_m4m5_noshield c_width=5u c_length=5u
X1 thm VSS cap_mim_2f0_m4m5_noshield c_width=5u c_length=5u
X2 thm VSS cap_mim_2f0_m4m5_noshield c_width=5u c_length=5u
X3 thm VSS cap_mim_2f0_m4m5_noshield c_width=5u c_length=5u
X4 thm VSS cap_mim_2f0_m4m5_noshield c_width=5u c_length=5u
X5 thm VSS cap_mim_2f0_m4m5_noshield c_width=5u c_length=5u
X6 thm VSS cap_mim_2f0_m4m5_noshield c_width=5u c_length=5u
X7 thm VSS cap_mim_2f0_m4m5_noshield c_width=5u c_length=5u
X8 thm VSS cap_mim_2f0_m4m5_noshield c_width=5u c_length=5u
X9 thm VSS cap_mim_2f0_m4m5_noshield c_width=5u c_length=5u
X10 thm VSS cap_mim_2f0_m4m5_noshield c_width=5u c_length=5u
X11 thm VSS cap_mim_2f0_m4m5_noshield c_width=5u c_length=5u
X12 thm VSS cap_mim_2f0_m4m5_noshield c_width=5u c_length=5u
X13 thm VSS cap_mim_2f0_m4m5_noshield c_width=5u c_length=5u
X14 thm VSS cap_mim_2f0_m4m5_noshield c_width=5u c_length=5u
X15 thm VSS cap_mim_2f0_m4m5_noshield c_width=5u c_length=5u
X16 thm VSS cap_mim_2f0_m4m5_noshield c_width=5u c_length=5u
X17 thm VSS cap_mim_2f0_m4m5_noshield c_width=5u c_length=5u
X18 thm VSS cap_mim_2f0_m4m5_noshield c_width=5u c_length=5u
X19 thm VSS cap_mim_2f0_m4m5_noshield c_width=5u c_length=5u
X20 thm VSS cap_mim_2f0_m4m5_noshield c_width=5u c_length=5u
X21 thm VSS cap_mim_2f0_m4m5_noshield c_width=5u c_length=5u
X22 thm VSS cap_mim_2f0_m4m5_noshield c_width=5u c_length=5u
X23 thm VSS cap_mim_2f0_m4m5_noshield c_width=5u c_length=5u
X24 thm VSS cap_mim_2f0_m4m5_noshield c_width=5u c_length=5u
X25 thm VSS cap_mim_2f0_m4m5_noshield c_width=5u c_length=5u
X26 thm VSS cap_mim_2f0_m4m5_noshield c_width=5u c_length=5u
X27 thm VSS cap_mim_2f0_m4m5_noshield c_width=5u c_length=5u
X28 thm VSS cap_mim_2f0_m4m5_noshield c_width=5u c_length=5u
X29 thm VSS cap_mim_2f0_m4m5_noshield c_width=5u c_length=5u
X30 thm VSS cap_mim_2f0_m4m5_noshield c_width=5u c_length=5u
X31 thm VSS cap_mim_2f0_m4m5_noshield c_width=5u c_length=5u
X32 thm VSS cap_mim_2f0_m4m5_noshield c_width=5u c_length=5u
X33 thm VSS cap_mim_2f0_m4m5_noshield c_width=5u c_length=5u
X34 thm VSS cap_mim_2f0_m4m5_noshield c_width=5u c_length=5u
X35 thm VSS cap_mim_2f0_m4m5_noshield c_width=5u c_length=5u
X36 thm VSS cap_mim_2f0_m4m5_noshield c_width=5u c_length=5u
X37 thm VSS cap_mim_2f0_m4m5_noshield c_width=5u c_length=5u
X38 thm VSS cap_mim_2f0_m4m5_noshield c_width=5u c_length=5u
X39 thm VSS cap_mim_2f0_m4m5_noshield c_width=5u c_length=5u
X40 thm VSS cap_mim_2f0_m4m5_noshield c_width=5u c_length=5u
X41 thm VSS cap_mim_2f0_m4m5_noshield c_width=5u c_length=5u
X42 thm VSS cap_mim_2f0_m4m5_noshield c_width=5u c_length=5u
X43 thm VSS cap_mim_2f0_m4m5_noshield c_width=5u c_length=5u
X44 thm VSS cap_mim_2f0_m4m5_noshield c_width=5u c_length=5u
X45 thm VSS cap_mim_2f0_m4m5_noshield c_width=5u c_length=5u
X46 thm VSS cap_mim_2f0_m4m5_noshield c_width=5u c_length=5u
X47 thm VSS cap_mim_2f0_m4m5_noshield c_width=5u c_length=5u
X48 thm VSS cap_mim_2f0_m4m5_noshield c_width=5u c_length=5u
X49 thm VSS cap_mim_2f0_m4m5_noshield c_width=5u c_length=5u
X50 thm VSS cap_mim_2f0_m4m5_noshield c_width=5u c_length=5u
X51 thm VSS cap_mim_2f0_m4m5_noshield c_width=5u c_length=5u
X52 thm VSS cap_mim_2f0_m4m5_noshield c_width=5u c_length=5u
X53 thm VSS cap_mim_2f0_m4m5_noshield c_width=5u c_length=5u
X54 thm VSS cap_mim_2f0_m4m5_noshield c_width=5u c_length=5u
X55 thm VSS cap_mim_2f0_m4m5_noshield c_width=5u c_length=5u
X56 thm VSS cap_mim_2f0_m4m5_noshield c_width=5u c_length=5u
X57 thm VSS cap_mim_2f0_m4m5_noshield c_width=5u c_length=5u
X58 thm VSS cap_mim_2f0_m4m5_noshield c_width=5u c_length=5u
X59 thm VSS cap_mim_2f0_m4m5_noshield c_width=5u c_length=5u
X60 thm VSS cap_mim_2f0_m4m5_noshield c_width=5u c_length=5u
X61 thm VSS cap_mim_2f0_m4m5_noshield c_width=5u c_length=5u
X62 thm VSS cap_mim_2f0_m4m5_noshield c_width=5u c_length=5u
X63 thm VSS cap_mim_2f0_m4m5_noshield c_width=5u c_length=5u
X64 thm VSS cap_mim_2f0_m4m5_noshield c_width=5u c_length=5u
X65 thm VSS cap_mim_2f0_m4m5_noshield c_width=5u c_length=5u
X66 thm VSS cap_mim_2f0_m4m5_noshield c_width=5u c_length=5u
X67 thm VSS cap_mim_2f0_m4m5_noshield c_width=5u c_length=5u
X68 thm VSS cap_mim_2f0_m4m5_noshield c_width=5u c_length=5u
X69 thm VSS cap_mim_2f0_m4m5_noshield c_width=5u c_length=5u
X70 thm VSS cap_mim_2f0_m4m5_noshield c_width=5u c_length=5u
X71 thm VSS cap_mim_2f0_m4m5_noshield c_width=5u c_length=5u
X72 thm VSS cap_mim_2f0_m4m5_noshield c_width=5u c_length=5u
X73 thm VSS cap_mim_2f0_m4m5_noshield c_width=5u c_length=5u
X74 thm VSS cap_mim_2f0_m4m5_noshield c_width=5u c_length=5u
X75 thm VSS cap_mim_2f0_m4m5_noshield c_width=5u c_length=5u
X76 thm VSS cap_mim_2f0_m4m5_noshield c_width=5u c_length=5u
X77 thm VSS cap_mim_2f0_m4m5_noshield c_width=5u c_length=5u
X78 thm VSS cap_mim_2f0_m4m5_noshield c_width=5u c_length=5u
X79 thm VSS cap_mim_2f0_m4m5_noshield c_width=5u c_length=5u
X80 thm VSS cap_mim_2f0_m4m5_noshield c_width=5u c_length=5u
X81 thm VSS cap_mim_2f0_m4m5_noshield c_width=5u c_length=5u
X82 thm VSS cap_mim_2f0_m4m5_noshield c_width=5u c_length=5u
X83 thm VSS cap_mim_2f0_m4m5_noshield c_width=5u c_length=5u
X84 thm VSS cap_mim_2f0_m4m5_noshield c_width=5u c_length=5u
X85 thm VSS cap_mim_2f0_m4m5_noshield c_width=5u c_length=5u
X86 thm VSS cap_mim_2f0_m4m5_noshield c_width=5u c_length=5u
X87 thm VSS cap_mim_2f0_m4m5_noshield c_width=5u c_length=5u
X88 thm VSS cap_mim_2f0_m4m5_noshield c_width=5u c_length=5u
X89 thm VSS cap_mim_2f0_m4m5_noshield c_width=5u c_length=5u
X90 thm VSS cap_mim_2f0_m4m5_noshield c_width=5u c_length=5u
X91 thm VSS cap_mim_2f0_m4m5_noshield c_width=5u c_length=5u
X92 thm VSS cap_mim_2f0_m4m5_noshield c_width=5u c_length=5u
X93 thm VSS cap_mim_2f0_m4m5_noshield c_width=5u c_length=5u
X94 thm VSS cap_mim_2f0_m4m5_noshield c_width=5u c_length=5u
X95 thm VSS cap_mim_2f0_m4m5_noshield c_width=5u c_length=5u
X96 thm VSS cap_mim_2f0_m4m5_noshield c_width=5u c_length=5u
X97 thm VSS cap_mim_2f0_m4m5_noshield c_width=5u c_length=5u
X98 thm VSS cap_mim_2f0_m4m5_noshield c_width=5u c_length=5u
X99 thm VSS cap_mim_2f0_m4m5_noshield c_width=5u c_length=5u
.ends

.subckt adc2b_CT3 thn VSS
X0 thn VSS cap_mim_2f0_m4m5_noshield c_width=5u c_length=5u
X1 thn VSS cap_mim_2f0_m4m5_noshield c_width=5u c_length=5u
X2 thn VSS cap_mim_2f0_m4m5_noshield c_width=5u c_length=5u
X3 thn VSS cap_mim_2f0_m4m5_noshield c_width=5u c_length=5u
X4 thn VSS cap_mim_2f0_m4m5_noshield c_width=5u c_length=5u
X5 thn VSS cap_mim_2f0_m4m5_noshield c_width=5u c_length=5u
X6 thn VSS cap_mim_2f0_m4m5_noshield c_width=5u c_length=5u
X7 thn VSS cap_mim_2f0_m4m5_noshield c_width=5u c_length=5u
X8 thn VSS cap_mim_2f0_m4m5_noshield c_width=5u c_length=5u
X9 thn VSS cap_mim_2f0_m4m5_noshield c_width=5u c_length=5u
X10 thn VSS cap_mim_2f0_m4m5_noshield c_width=5u c_length=5u
X11 thn VSS cap_mim_2f0_m4m5_noshield c_width=5u c_length=5u
X12 thn VSS cap_mim_2f0_m4m5_noshield c_width=5u c_length=5u
X13 thn VSS cap_mim_2f0_m4m5_noshield c_width=5u c_length=5u
X14 thn VSS cap_mim_2f0_m4m5_noshield c_width=5u c_length=5u
X15 thn VSS cap_mim_2f0_m4m5_noshield c_width=5u c_length=5u
X16 thn VSS cap_mim_2f0_m4m5_noshield c_width=5u c_length=5u
X17 thn VSS cap_mim_2f0_m4m5_noshield c_width=5u c_length=5u
X18 thn VSS cap_mim_2f0_m4m5_noshield c_width=5u c_length=5u
X19 thn VSS cap_mim_2f0_m4m5_noshield c_width=5u c_length=5u
X20 thn VSS cap_mim_2f0_m4m5_noshield c_width=5u c_length=5u
X21 thn VSS cap_mim_2f0_m4m5_noshield c_width=5u c_length=5u
X22 thn VSS cap_mim_2f0_m4m5_noshield c_width=5u c_length=5u
X23 thn VSS cap_mim_2f0_m4m5_noshield c_width=5u c_length=5u
X24 thn VSS cap_mim_2f0_m4m5_noshield c_width=5u c_length=5u
X25 thn VSS cap_mim_2f0_m4m5_noshield c_width=5u c_length=5u
X26 thn VSS cap_mim_2f0_m4m5_noshield c_width=5u c_length=5u
X27 thn VSS cap_mim_2f0_m4m5_noshield c_width=5u c_length=5u
X28 thn VSS cap_mim_2f0_m4m5_noshield c_width=5u c_length=5u
X29 thn VSS cap_mim_2f0_m4m5_noshield c_width=5u c_length=5u
X30 thn VSS cap_mim_2f0_m4m5_noshield c_width=5u c_length=5u
X31 thn VSS cap_mim_2f0_m4m5_noshield c_width=5u c_length=5u
X32 thn VSS cap_mim_2f0_m4m5_noshield c_width=5u c_length=5u
X33 thn VSS cap_mim_2f0_m4m5_noshield c_width=5u c_length=5u
X34 thn VSS cap_mim_2f0_m4m5_noshield c_width=5u c_length=5u
X35 thn VSS cap_mim_2f0_m4m5_noshield c_width=5u c_length=5u
X36 thn VSS cap_mim_2f0_m4m5_noshield c_width=5u c_length=5u
X37 thn VSS cap_mim_2f0_m4m5_noshield c_width=5u c_length=5u
X38 thn VSS cap_mim_2f0_m4m5_noshield c_width=5u c_length=5u
X39 thn VSS cap_mim_2f0_m4m5_noshield c_width=5u c_length=5u
X40 thn VSS cap_mim_2f0_m4m5_noshield c_width=5u c_length=5u
X41 thn VSS cap_mim_2f0_m4m5_noshield c_width=5u c_length=5u
X42 thn VSS cap_mim_2f0_m4m5_noshield c_width=5u c_length=5u
X43 thn VSS cap_mim_2f0_m4m5_noshield c_width=5u c_length=5u
X44 thn VSS cap_mim_2f0_m4m5_noshield c_width=5u c_length=5u
X45 thn VSS cap_mim_2f0_m4m5_noshield c_width=5u c_length=5u
X46 thn VSS cap_mim_2f0_m4m5_noshield c_width=5u c_length=5u
X47 thn VSS cap_mim_2f0_m4m5_noshield c_width=5u c_length=5u
X48 thn VSS cap_mim_2f0_m4m5_noshield c_width=5u c_length=5u
X49 thn VSS cap_mim_2f0_m4m5_noshield c_width=5u c_length=5u
X50 thn VSS cap_mim_2f0_m4m5_noshield c_width=5u c_length=5u
X51 thn VSS cap_mim_2f0_m4m5_noshield c_width=5u c_length=5u
X52 thn VSS cap_mim_2f0_m4m5_noshield c_width=5u c_length=5u
X53 thn VSS cap_mim_2f0_m4m5_noshield c_width=5u c_length=5u
X54 thn VSS cap_mim_2f0_m4m5_noshield c_width=5u c_length=5u
X55 thn VSS cap_mim_2f0_m4m5_noshield c_width=5u c_length=5u
X56 thn VSS cap_mim_2f0_m4m5_noshield c_width=5u c_length=5u
X57 thn VSS cap_mim_2f0_m4m5_noshield c_width=5u c_length=5u
X58 thn VSS cap_mim_2f0_m4m5_noshield c_width=5u c_length=5u
X59 thn VSS cap_mim_2f0_m4m5_noshield c_width=5u c_length=5u
X60 thn VSS cap_mim_2f0_m4m5_noshield c_width=5u c_length=5u
X61 thn VSS cap_mim_2f0_m4m5_noshield c_width=5u c_length=5u
X62 thn VSS cap_mim_2f0_m4m5_noshield c_width=5u c_length=5u
X63 thn VSS cap_mim_2f0_m4m5_noshield c_width=5u c_length=5u
X64 thn VSS cap_mim_2f0_m4m5_noshield c_width=5u c_length=5u
X65 thn VSS cap_mim_2f0_m4m5_noshield c_width=5u c_length=5u
X66 thn VSS cap_mim_2f0_m4m5_noshield c_width=5u c_length=5u
X67 thn VSS cap_mim_2f0_m4m5_noshield c_width=5u c_length=5u
X68 thn VSS cap_mim_2f0_m4m5_noshield c_width=5u c_length=5u
X69 thn VSS cap_mim_2f0_m4m5_noshield c_width=5u c_length=5u
X70 thn VSS cap_mim_2f0_m4m5_noshield c_width=5u c_length=5u
X71 thn VSS cap_mim_2f0_m4m5_noshield c_width=5u c_length=5u
X72 thn VSS cap_mim_2f0_m4m5_noshield c_width=5u c_length=5u
X73 thn VSS cap_mim_2f0_m4m5_noshield c_width=5u c_length=5u
X74 thn VSS cap_mim_2f0_m4m5_noshield c_width=5u c_length=5u
X75 thn VSS cap_mim_2f0_m4m5_noshield c_width=5u c_length=5u
X76 thn VSS cap_mim_2f0_m4m5_noshield c_width=5u c_length=5u
X77 thn VSS cap_mim_2f0_m4m5_noshield c_width=5u c_length=5u
X78 thn VSS cap_mim_2f0_m4m5_noshield c_width=5u c_length=5u
X79 thn VSS cap_mim_2f0_m4m5_noshield c_width=5u c_length=5u
X80 thn VSS cap_mim_2f0_m4m5_noshield c_width=5u c_length=5u
X81 thn VSS cap_mim_2f0_m4m5_noshield c_width=5u c_length=5u
X82 thn VSS cap_mim_2f0_m4m5_noshield c_width=5u c_length=5u
X83 thn VSS cap_mim_2f0_m4m5_noshield c_width=5u c_length=5u
X84 thn VSS cap_mim_2f0_m4m5_noshield c_width=5u c_length=5u
X85 thn VSS cap_mim_2f0_m4m5_noshield c_width=5u c_length=5u
X86 thn VSS cap_mim_2f0_m4m5_noshield c_width=5u c_length=5u
X87 thn VSS cap_mim_2f0_m4m5_noshield c_width=5u c_length=5u
X88 thn VSS cap_mim_2f0_m4m5_noshield c_width=5u c_length=5u
X89 thn VSS cap_mim_2f0_m4m5_noshield c_width=5u c_length=5u
X90 thn VSS cap_mim_2f0_m4m5_noshield c_width=5u c_length=5u
X91 thn VSS cap_mim_2f0_m4m5_noshield c_width=5u c_length=5u
X92 thn VSS cap_mim_2f0_m4m5_noshield c_width=5u c_length=5u
X93 thn VSS cap_mim_2f0_m4m5_noshield c_width=5u c_length=5u
X94 thn VSS cap_mim_2f0_m4m5_noshield c_width=5u c_length=5u
X95 thn VSS cap_mim_2f0_m4m5_noshield c_width=5u c_length=5u
X96 thn VSS cap_mim_2f0_m4m5_noshield c_width=5u c_length=5u
X97 thn VSS cap_mim_2f0_m4m5_noshield c_width=5u c_length=5u
X98 thn VSS cap_mim_2f0_m4m5_noshield c_width=5u c_length=5u
X99 thn VSS cap_mim_2f0_m4m5_noshield c_width=5u c_length=5u
.ends

.subckt nand2_MP1 Y A VDD
X0 Y A VDD VDD pfet_03v3 ad=0.89p pd=4.89u as=0.89p ps=4.89u w=2u l=0.28u
.ends

.subckt nand2_MP2 Y B VDD
X0 Y B VDD VDD pfet_03v3 ad=0.89p pd=4.89u as=0.89p ps=4.89u w=2u l=0.28u
.ends

.subckt nand2_MN1 n1 Y A VSS
X0 Y A n1 VSS nfet_03v3 ad=0.89p pd=4.89u as=0.89p ps=4.89u w=2u l=0.28u
.ends

.subckt nand2_MN2 n1 B VSS
X0 n1 B VSS VSS nfet_03v3 ad=0.89p pd=4.89u as=0.89p ps=4.89u w=2u l=0.28u
.ends

.subckt nand2 VDD A B Y VSS
XXMP1 Y A VDD nand2_MP1
XXMP2 Y B VDD nand2_MP2
XXMN1 XMN2/n1 Y A VSS nand2_MN1
XXMN2 XMN2/n1 B VSS nand2_MN2
.ends

.subckt adc2b_R10u_0 thp VDD thm thn VSS
X0 a_3480_1690# a_1240_n36# VSS ppolyf_u_1k r_width=10u r_length=8.02u
X1 thp thm VSS ppolyf_u_1k r_width=10u r_length=1.4u
X2 VDD a_5720_n36# VSS ppolyf_u_1k r_width=10u r_length=8.02u
X3 a_14680_1573# VSS VSS ppolyf_u_1k r_width=10u r_length=7.435u
X4 a_n1000_1690# thp VSS ppolyf_u_1k r_width=10u r_length=8.02u
X5 a_n1000_1690# a_1240_n36# VSS ppolyf_u_1k r_width=10u r_length=8.02u
X6 a_3480_1690# a_5720_n36# VSS ppolyf_u_1k r_width=10u r_length=8.02u
X7 thm thn VSS ppolyf_u_1k r_width=10u r_length=1.4u
X8 thn a_16920_n36# VSS ppolyf_u_1k r_width=10u r_length=7.435u
X9 a_14680_1573# a_16920_n36# VSS ppolyf_u_1k r_width=10u r_length=7.435u
.ends

.subckt adc2b VSS VDD INP INN CLK SIGN MAG
XXCH VDD INP INN XCT1/thp XCT3/thn CLK XCH/Q XM/A VSS sa_comp
XXCL VDD INP INN XCT3/thn XCT1/thp CLK XM/B XCL/QB VSS sa_comp
XXCT1 XCT1/thp VSS adc2b_CT1
XXCT2 XCT2/thm VSS adc2b_CT2
XXCT3 XCT3/thn VSS adc2b_CT3
XXCS VDD INP INN XCT2/thm XCT2/thm CLK SIGN XCS/QB VSS sa_comp
XXM VDD XM/A XM/B MAG VSS nand2
XXR10u_0 XCT1/thp VDD XCT2/thm XCT3/thn VSS adc2b_R10u_0
.ends
