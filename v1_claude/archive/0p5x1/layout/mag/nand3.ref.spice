.subckt nand3 A B C Y VDD VSS
XMN1 Y A n1 VSS nfet_03v3 L=0.28u W=3u nf=1  m=1
XMN2 n1 B n2 VSS nfet_03v3 L=0.28u W=3u nf=1  m=1
XMN3 n2 C VSS VSS nfet_03v3 L=0.28u W=3u nf=1  m=1
XMP1 Y A VDD VDD pfet_03v3 L=0.28u W=2u nf=1  m=1
XMP2 Y B VDD VDD pfet_03v3 L=0.28u W=2u nf=1  m=1
XMP3 Y C VDD VDD pfet_03v3 L=0.28u W=2u nf=1  m=1
.ends
