* NGSPICE file created from nand3.ext - technology: gf180mcuD

.subckt nand3_MP1 Y A VDD
X0 Y A VDD VDD pfet_03v3 ad=0.89p pd=4.89u as=0.89p ps=4.89u w=2u l=0.28u
.ends

.subckt nand3_MP2 Y B VDD
X0 Y B VDD VDD pfet_03v3 ad=0.89p pd=4.89u as=0.89p ps=4.89u w=2u l=0.28u
.ends

.subckt nand3_MP3 Y C VDD
X0 Y C VDD VDD pfet_03v3 ad=0.89p pd=4.89u as=0.89p ps=4.89u w=2u l=0.28u
.ends

.subckt nand3_MN1 n1 Y A VSS
X0 Y A n1 VSS nfet_03v3 ad=1.335p pd=6.89u as=1.335p ps=6.89u w=3u l=0.28u
.ends

.subckt nand3_MN2 n2 n1 B VSS
X0 n1 B n2 VSS nfet_03v3 ad=1.335p pd=6.89u as=1.335p ps=6.89u w=3u l=0.28u
.ends

.subckt nand3_MN3 n2 C VSS
X0 n2 C VSS VSS nfet_03v3 ad=1.335p pd=6.89u as=1.335p ps=6.89u w=3u l=0.28u
.ends

.subckt nand3 VSS VDD A B C Y
XXMP1 Y A VDD nand3_MP1
XXMP2 Y B VDD nand3_MP2
XXMP3 Y C VDD nand3_MP3
XXMN1 XMN2/n1 Y A VSS nand3_MN1
XXMN2 XMN3/n2 XMN2/n1 B VSS nand3_MN2
XXMN3 XMN3/n2 C VSS nand3_MN3
.ends
