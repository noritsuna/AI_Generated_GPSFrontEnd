* NGSPICE file created from top_wires_flat.ext - technology: gf180mcuD

.subckt top_wires_flat
C0 I_MAG aqn 0.04457f
C1 mqn l2n 0.03791f
C2 mip l3p 0.02929f
C3 aqp nb 0.04457f
C4 pb Q_MAG 0.04457f
C5 AFC4 aqp 0.04457f
C6 min refck 0.04457f
C7 B1 ain 0.04457f
C8 IG1A IG2B 0.16836f
C9 AFC5 ICP2 0.04322f
C10 mqp nb 0.08306f
C11 mqp AFC4 0.08779f
C12 mip IG1A 0.02093f
C13 min B0 0.04359f
C14 AFC7 aqn 0.04457f
C15 AFC1 I_SIGN 0.04457f
C16 ain ICP2 0.04359f
C17 B1 nb 0.08206f
C18 AFC5 AFC3 0.04427f
C19 AFC0 aip 0.04359f
C20 fs AFC7 0.13273f
C21 pb IG1A 18.4944f
C22 B1 AFC4 0.19241f
C23 vctrl l3p 0.03124f
C24 mqn l3n 0.03791f
C25 mqp l2n 0.03791f
C26 l4p l4n 0.27831f
C27 ICP2 nb 0.13175f
C28 pb I_MAG 0.08914f
C29 B0 refck 0.04457f
C30 AFC4 ICP2 0.04322f
C31 AFC3 ain 0.04359f
C32 aip aqp 21.8193f
C33 IG1A IG3B 0.08578f
C34 l3n VCTRL 0.86803f
C35 mqn AFC1 0.08816f
C36 AFC2 I_SIGN 0.04457f
C37 AFC0 AFC1 0.04457f
C38 fs IG1B 0.04457f
C39 mip l2p 0.04262f
C40 B1 aip 0.04359f
C41 pb AFC7 0.04359f
C42 AFC4 AFC3 11.7491f
C43 mip ckr 0.04457f
C44 mqp l3n 0.03791f
C45 mqn min 0.30456f
C46 l4n l2n 0.23022f
C47 Q_MAG nb 0.04457f
C48 fs aqn 0.04457f
C49 AFC5 I_MAG 0.04457f
C50 AFC6 refck 0.04457f
C51 AFC1 aqp 0.04457f
C52 IG1A ain 0.04457f
C53 aip ICP2 0.04359f
C54 IG1B IG2B 0.19303f
C55 mqp AFC1 0.08816f
C56 mqn AFC2 0.08816f
C57 min AFC0 0.08816f
C58 ckr pb 15.0509f
C59 ain I_MAG 0.04457f
C60 mqn refck 0.04457f
C61 AFC0 AFC2 0.04457f
C62 B1 AFC1 0.08914f
C63 AFC3 aip 0.04359f
C64 pb IG1B 2.22832f
C65 AFC5 AFC7 0.13235f
C66 vctrl l2p 0.07725f
C67 vctrl ckr 0.76167f
C68 mqn B0 0.04359f
C69 l2n l3p 3.00617f
C70 mqp min 0.40455f
C71 I_MAG nb 0.08914f
C72 aip Q_MAG 0.03901f
C73 pb aqn 0.04457f
C74 AFC6 I_SIGN 0.04457f
C75 AFC7 ain 0.04457f
C76 AFC4 I_MAG 0.04457f
C77 AFC2 aqp 0.04457f
C78 AFC1 ICP2 0.04359f
C79 IG1B IG3B 0.04359f
C80 IG2A IG3A 0.29808f
C81 fs pb 0.13175f
C82 mqp AFC2 0.08816f
C83 min B1 0.04359f
C84 Q_MAG CLKOUT 0.10194f
C85 AFC7 nb 0.08914f
C86 AFC4 AFC7 0.03564f
C87 mqp refck 0.04457f
C88 AFC3 AFC1 0.04457f
C89 B1 AFC2 0.08914f
C90 aip IG1A 0.04457f
C91 pb IG2B 0.01374f
C92 l4p l2p 0.08783f
C93 fs IG3B 0.04359f
C94 min ICP2 0.04359f
C95 vctrl fs 0.03564f
C96 mqp B0 0.04359f
C97 mip pb 0.05551f
C98 l3p l3n 2.67715f
C99 refck AFCOUT 0.31858f
C100 AFC5 aqn 0.04457f
C101 B1 refck 0.04457f
C102 IG1B ain 0.04457f
C103 aip I_MAG 0.04359f
C104 AFC2 ICP2 0.04359f
C105 IG2B IG3B 0.0377f
C106 ckr nb 2.07469f
C107 pb RFIN 2.47436f
C108 min AFC3 0.08134f
C109 fs AFC5 7.72783f
C110 aqp I_SIGN 0.04457f
C111 ain aqn 9.8592f
C112 ICP2 refck 0.04457f
C113 mip vctrl 0.03849f
C114 AFC6 aqp 0.04457f
C115 AFC3 AFC2 1.79937f
C116 aip AFC7 0.04359f
C117 B0 ICP2 0.04359f
C118 fs ain 0.43391f
C119 pb IG3B 0.09873f
C120 rfn nb 0.28539f
C121 l3p min 0.02929f
C122 mqn AFC0 0.08816f
C123 aqn nb 0.04457f
C124 AFC4 aqn 0.04457f
C125 AFC1 I_MAG 0.04457f
C126 fs nb 0.14993f
C127 fs AFC4 0.08786f
C128 pb AFC5 0.04322f
C129 min IG1A 0.02093f
C130 ICP2 I_SIGN 0.04457f
C131 mqn mqp 45.7753f
C132 fs Q_SIGN 0.04457f
C133 AFC1 AFC7 0.03564f
C134 aip IG1B 2.44667f
C135 AFC6 ICP2 0.04359f
C136 pb ain 0.04359f
C137 mip nb 0.08306f
C138 mqp AFC0 0.08816f
C139 mqn B1 0.04359f
C140 mip AFC4 0.08134f
C141 AFC3 I_SIGN 0.04457f
C142 AFC2 I_MAG 0.04457f
C143 IG3B ain 0.04457f
C144 aip aqn 6.14597f
C145 pb nb 0.08707f
C146 fs aip 0.04359f
C147 pb AFC4 0.04322f
C148 mqn ICP2 0.04359f
C149 AFC0 B1 1.27956f
C150 mip l2n 0.03596f
C151 AFC7 AFC2 0.03564f
C152 min l2p 0.04262f
C153 AFC0 ICP2 0.04359f
C154 AFC5 ain 0.04322f
C155 IG1A IG2A 10.5017f
C156 vctrl nb 9.17417f
C157 min ckr 0.04457f
C158 mqp B1 0.04359f
C159 mqn AFC3 0.08816f
C160 aqp ICP2 0.04457f
C161 AFC7 refck 0.04457f
C162 AFC1 aqn 0.04457f
C163 AFC0 AFC3 0.04457f
C164 pb aip 0.04359f
C165 fs AFC1 0.08786f
C166 mqp ICP2 0.03676f
C167 AFC5 AFC4 6.2454f
C168 vctrl l2n 0.03791f
C169 mqn l3p 0.03124f
C170 mip l3n 0.03596f
C171 ain nb 0.04457f
C172 AFC6 I_MAG 0.04457f
C173 AFC3 aqp 0.04457f
C174 IG1A IG3A 0.10608f
C175 aip IG3B 0.04359f
C176 B1 ICP2 0.04359f
C177 AFC4 ain 0.04322f
C178 l3p VCTRL 0.78142f
C179 ckr B0 0.04326f
C180 mqp AFC3 0.08816f
C181 mqn IG1A 0.04359f
C182 mip AFC1 0.08816f
C183 aqp Q_MAG 0.03344f
C184 AFC7 I_SIGN 0.04457f
C185 AFC2 aqn 0.04457f
C186 AFC6 AFC7 0.08021f
C187 AFC5 aip 0.04359f
C188 fs AFC2 0.08786f
C189 pb AFC1 0.04359f
C190 B1 AFC3 0.13913f
C191 vctrl l3n 0.03791f
C192 mqp l3p 0.03124f
C193 mip min 14.5913f
C194 Q_SIGN nb 0.04457f
C195 fs refck 0.04457f
C196 AFC3 ICP2 0.04359f
C197 IG1B IG2A 10.338f
C198 aip ain 17.8017f
C199 B0 fs 0.04359f
C200 mqp IG1A 0.03676f
C201 mip AFC2 0.08816f
C202 min pb 0.05551f
C203 aqp I_MAG 0.04457f
C204 aip nb 0.04359f
C205 AFC0 AFC7 0.03564f
C206 AFC5 AFC1 0.04427f
C207 mip refck 0.04457f
C208 mqn l2p 0.04457f
C209 AFC4 aip 0.04359f
C210 pb AFC2 0.04359f
C211 mqn ckr 0.04457f
C212 l4n l3p 0.45941f
C213 mip B0 0.04359f
C214 vctrl min 0.03849f
C215 AFC7 aqp 0.04457f
C216 AFC6 aqn 0.04457f
C217 pb refck 0.03564f
C218 AFC1 ain 0.04359f
C219 IG1A ICP2 6.19901f
C220 IG2A IG2B 64.1726f
C221 IG1B IG3A 0.04016f
C222 fs AFC6 0.04359f
C223 B0 pb 0.04359f
C224 mqn IG1B 0.04359f
C225 ICP2 I_MAG 0.04457f
C226 AFC5 AFC2 0.04427f
C227 AFC4 AFC1 0.04457f
C228 pb IG2A 0.01374f
C229 mqp l2p 0.04457f
C230 B0 IG3B 0.11263f
C231 l4p l1n 0.13989f
C232 mqp ckr 0.04457f
C233 l2n l3n 2.60252f
C234 vctrl B0 0.03849f
C235 l1n nb 0.07116f
C236 refck REFIN 0.12061f
C237 AFC3 I_MAG 0.04457f
C238 AFC7 ICP2 0.04359f
C239 AFC2 ain 0.04359f
C240 IG2B IG3A 72.3873f
C241 IG2A IG3B 0.04837f
C242 min nb 0.08306f
C243 ckr B1 0.04326f
C244 fs AFC0 0.08786f
C245 AFC6 pb 0.04359f
C246 mqp IG1B 0.04359f
C247 min AFC4 0.08134f
C248 Q_MAG I_MAG 0.00528f
C249 aqp aqn 8.10256f
C250 mip mqn 0.59201f
C251 ckr ICP2 0.00102f
C252 fs aqp 0.04457f
C253 AFC3 AFC7 0.03564f
C254 AFC4 AFC2 0.04457f
C255 B0 ain 0.04457f
C256 pb IG3A 0.01374f
C257 aip AFC1 0.04359f
C258 l4n l2p 0.0848f
C259 l2n min 0.03596f
C260 mqn pb 0.05551f
C261 mip AFC0 0.08816f
C262 refck nb 0.04457f
C263 AFC5 I_SIGN 0.09672f
C264 IG1B ICP2 0.08718f
C265 IG3A IG3B 29.5492f
C266 B0 nb 0.08206f
C267 fs B1 0.04359f
C268 pb AFC0 0.04359f
C269 mqn IG3B 0.04359f
C270 ICP2 aqn 0.04457f
C271 mqn vctrl 0.03849f
C272 mip mqp 0.59888f
C273 pb aqp 0.04457f
C274 AFC6 ain 0.04457f
C275 aip AFC2 0.04359f
C276 fs ICP2 0.08718f
C277 vctrl VCTRL 0.03264f
C278 rfp nb 0.20649f
C279 l3n min 0.03596f
C280 mqp pb 0.05551f
C281 mqn AFC5 2.35935f
C282 mip B1 0.04359f
C283 I_SIGN nb 0.08914f
C284 AFC7 I_MAG 0.04457f
C285 AFC3 aqn 0.04457f
C286 AFC4 I_SIGN 0.05724f
C287 AFC0 AFC5 0.04427f
C288 B0 aip 0.04359f
C289 fs AFC3 0.08786f
C290 pb B1 0.04359f
C291 mqp IG3B 0.04359f
C292 mip ICP2 0.04359f
C293 min AFC1 0.08816f
C294 Q_MAG aqn 0.03901f
C295 vctrl mqp 0.03849f
C296 fs Q_MAG 0.04457f
C297 AFC5 aqp 0.04457f
C298 AFC0 ain 0.04457f
C299 AFC1 AFC2 0.04457f
C300 pb ICP2 0.0724f
C301 IG1A IG1B 2.79437f
C302 mqn nb 0.08306f
C303 mqn AFC4 1.55226f
C304 mqp AFC5 0.52205f
C305 mip AFC3 0.08134f
C306 vctrl B1 0.03849f
C307 REFIN AFCOUT 0.06476f
C308 IG3B ICP2 0.08718f
C309 AFC0 AFC4 0.04457f
C310 fs IG1A 0.04457f
C311 AFC6 aip 0.04359f
C312 pb AFC3 0.04359f
C313 min AFC2 0.08816f
C314 fsb VSUBS 0.44457f ; **FLOATING
C315 I_SIGN VSUBS 29.0777f
C316 aqn VSUBS 50.1772f
C317 refck VSUBS 0.11019p
C318 l2p VSUBS 10.0727f
C319 l1n VSUBS 4.43042f
C320 I_MAG VSUBS 39.3857f
C321 CLKOUT VSUBS 6.6495f
C322 Q_MAG VSUBS 22.9154f
C323 Q_SIGN VSUBS 11.2832f
C324 ICP2 VSUBS 0.22706p
C325 ain VSUBS 0.12028p
C326 aqp VSUBS 38.2314f
C327 IG3B VSUBS 0.1172p
C328 IG3A VSUBS 52.9028f
C329 IG2B VSUBS 19.5317f
C330 IG2A VSUBS 39.9818f
C331 IG1B VSUBS 89.0891f
C332 AFC2 VSUBS 0.14522p
C333 AFC7 VSUBS 0.15381p
C334 AFC1 VSUBS 0.1483p
C335 IG1A VSUBS 49.3888f
C336 aip VSUBS 0.1005p
C337 AFC3 VSUBS 0.13783p
C338 AFC4 VSUBS 0.12929p
C339 B1 VSUBS 0.20679p
C340 AFC5 VSUBS 0.13384p
C341 AFC0 VSUBS 0.1472p
C342 pb VSUBS 0.23717p
C343 AFC6 VSUBS 0.14499p
C344 fs VSUBS 0.21987p
C345 B0 VSUBS 0.21385p
C346 ckr VSUBS 70.4898f
C347 min VSUBS 0.166p
C348 l1p VSUBS 2.94193f ; **FLOATING
C349 l3n VSUBS 12.7891f
C350 l3p VSUBS 9.78628f
C351 l2n VSUBS 8.96904f
C352 l4n VSUBS 8.67783f
C353 l4p VSUBS 6.68709f
C354 mqp VSUBS 0.20716p
C355 vctrl VSUBS 83.61171f
C356 mqn VSUBS 0.20191p
C357 mip VSUBS 0.16626p
C358 rfp VSUBS 3.54752f
C359 rfn VSUBS 5.16683f
C360 nb VSUBS 0.30892p
C361 AFCOUT VSUBS 0.10909p
C362 REFIN VSUBS 46.5628f
C363 VCTRL VSUBS 34.6165f
C364 RFIN VSUBS 42.5605f
.ends
