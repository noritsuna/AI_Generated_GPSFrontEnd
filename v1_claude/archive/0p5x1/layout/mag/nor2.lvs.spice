* NGSPICE file created from nor2.ext - technology: gf180mcuD

.subckt nor2_MP1 n1 A VDD
X0 n1 A VDD VDD pfet_03v3 ad=1.78p pd=8.89u as=1.78p ps=8.89u w=4u l=0.28u
.ends

.subckt nor2_MP2 n1 Y B VDD
X0 Y B n1 VDD pfet_03v3 ad=1.78p pd=8.89u as=1.78p ps=8.89u w=4u l=0.28u
.ends

.subckt nor2_MN1 Y A VSS
X0 Y A VSS VSS nfet_03v3 ad=0.445p pd=2.89u as=0.445p ps=2.89u w=1u l=0.28u
.ends

.subckt nor2_MN2 Y B VSS
X0 Y B VSS VSS nfet_03v3 ad=0.445p pd=2.89u as=0.445p ps=2.89u w=1u l=0.28u
.ends

.subckt nor2 VSS VDD A B Y
XXMP1 XMP2/n1 A VDD nor2_MP1
XXMP2 XMP2/n1 Y B VDD nor2_MP2
XXMN1 Y A VSS nor2_MN1
XXMN2 Y B VSS nor2_MN2
.ends
