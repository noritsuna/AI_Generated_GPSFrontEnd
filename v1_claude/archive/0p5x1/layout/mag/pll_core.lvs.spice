* NGSPICE file created from pll_core.ext - technology: gf180mcuD

.subckt divbuf_MP1 b a VDD
X0 b a VDD VDD pfet_03v3 ad=3.56p pd=16.89u as=3.56p ps=16.89u w=8u l=0.28u
.ends

.subckt divbuf_MP2 OUT b VDD
X0 OUT b VDD VDD pfet_03v3 ad=3.56p pd=16.89u as=3.56p ps=16.89u w=8u l=0.28u
.ends

.subckt divbuf_MN1 b a VSS
X0 b a VSS VSS nfet_03v3 ad=1.78p pd=8.89u as=1.78p ps=8.89u w=4u l=0.28u
.ends

.subckt divbuf_MN2 OUT b VSS
X0 OUT b VSS VSS nfet_03v3 ad=1.78p pd=8.89u as=1.78p ps=8.89u w=4u l=0.28u
.ends

.subckt divbuf_R1u_0 b a VSS
X0 a_n100_2086# a VSS ppolyf_u_1k r_width=1u r_length=10u
X1 a_n100_2086# b VSS ppolyf_u_1k r_width=1u r_length=10u
.ends

.subckt divbuf_CIN IN a
X0 IN a cap_mim_2f0_m4m5_noshield c_width=5u c_length=5u
X1 IN a cap_mim_2f0_m4m5_noshield c_width=5u c_length=5u
X2 IN a cap_mim_2f0_m4m5_noshield c_width=5u c_length=5u
X3 IN a cap_mim_2f0_m4m5_noshield c_width=5u c_length=5u
X4 IN a cap_mim_2f0_m4m5_noshield c_width=5u c_length=5u
X5 IN a cap_mim_2f0_m4m5_noshield c_width=5u c_length=5u
.ends

.subckt divbuf VSS VDD IN OUT
XXMP1 XMP2/b XMP1/a VDD divbuf_MP1
XXMP2 OUT XMP2/b VDD divbuf_MP2
XXMN1 XMP2/b XMP1/a VSS divbuf_MN1
XXMN2 OUT XMP2/b VSS divbuf_MN2
XXR1u_0 XMP2/b XMP1/a VSS divbuf_R1u_0
XXCIN IN XMP1/a divbuf_CIN
.ends

.subckt pll_core_MTX tx VSS
X0 tx tx VSS VSS nfet_03v3 ad=0.445p pd=2.89u as=0.445p ps=2.89u w=1u l=0.28u
.ends

.subckt inv_lo1_MN Y A VSS
X0 Y A VSS VSS nfet_03v3 ad=0.89p pd=4.89u as=0.89p ps=4.89u w=2u l=0.28u
.ends

.subckt inv_lo1_MP Y A VDD
X0 Y A VDD VDD pfet_03v3 ad=1.78p pd=8.89u as=1.78p ps=8.89u w=4u l=0.28u
.ends

.subckt inv_lo1 VDD A Y VSS
XXMN Y A VSS inv_lo1_MN
XXMP Y A VDD inv_lo1_MP
.ends

.subckt inv_lo2_MN Y A VSS
X0 VSS A Y VSS nfet_03v3 ad=1.335p pd=6.89u as=0.795p ps=3.53u w=3u l=0.28u
X1 Y A VSS VSS nfet_03v3 ad=0.795p pd=3.53u as=1.335p ps=6.89u w=3u l=0.28u
.ends

.subckt inv_lo2_MP Y A VDD
X0 VDD A Y VDD pfet_03v3 ad=0.795p pd=3.53u as=0.795p ps=3.53u w=3u l=0.28u
X1 Y A VDD VDD pfet_03v3 ad=0.795p pd=3.53u as=1.335p ps=6.89u w=3u l=0.28u
X2 VDD A Y VDD pfet_03v3 ad=1.335p pd=6.89u as=0.795p ps=3.53u w=3u l=0.28u
X3 Y A VDD VDD pfet_03v3 ad=0.795p pd=3.53u as=0.795p ps=3.53u w=3u l=0.28u
.ends

.subckt inv_lo2 VDD A Y VSS
XXMN Y A VSS inv_lo2_MN
XXMP Y A VDD inv_lo2_MP
.ends

.subckt tspc_dff_MP1 a1 D VDD
X0 a1 D VDD VDD pfet_03v3 ad=0.89p pd=4.89u as=0.89p ps=4.89u w=2u l=0.28u
.ends

.subckt tspc_dff_MP2 a1 x CK VDD
X0 x CK a1 VDD pfet_03v3 ad=0.89p pd=4.89u as=0.89p ps=4.89u w=2u l=0.28u
.ends

.subckt tspc_dff_MP3 y CK VDD
X0 y CK VDD VDD pfet_03v3 ad=0.89p pd=4.89u as=0.89p ps=4.89u w=2u l=0.28u
.ends

.subckt tspc_dff_MN1 x D VSS
X0 x D VSS VSS nfet_03v3 ad=0.445p pd=2.89u as=0.445p ps=2.89u w=1u l=0.28u
.ends

.subckt tspc_dff_MP4 QB y VDD
X0 QB y VDD VDD pfet_03v3 ad=1.335p pd=6.89u as=1.335p ps=6.89u w=3u l=0.28u
.ends

.subckt tspc_dff_MN2 b2 y x VSS
X0 y x b2 VSS nfet_03v3 ad=0.6675p pd=3.89u as=0.6675p ps=3.89u w=1.5u l=0.28u
.ends

.subckt tspc_dff_MP5 Q QB VDD
X0 Q QB VDD VDD pfet_03v3 ad=0.89p pd=4.89u as=0.89p ps=4.89u w=2u l=0.28u
.ends

.subckt tspc_dff_MN3 b2 CK VSS
X0 b2 CK VSS VSS nfet_03v3 ad=0.6675p pd=3.89u as=0.6675p ps=3.89u w=1.5u l=0.28u
.ends

.subckt tspc_dff_MN4 c3 QB CK VSS
X0 QB CK c3 VSS nfet_03v3 ad=0.6675p pd=3.89u as=0.6675p ps=3.89u w=1.5u l=0.28u
.ends

.subckt tspc_dff_MN5 c3 y VSS
X0 c3 y VSS VSS nfet_03v3 ad=0.6675p pd=3.89u as=0.6675p ps=3.89u w=1.5u l=0.28u
.ends

.subckt tspc_dff_MN6 Q QB VSS
X0 Q QB VSS VSS nfet_03v3 ad=0.445p pd=2.89u as=0.445p ps=2.89u w=1u l=0.28u
.ends

.subckt tspc_dff VDD D CK Q QB VSS
XXMP1 XMP2/a1 D VDD tspc_dff_MP1
XXMP2 XMP2/a1 XMP2/x CK VDD tspc_dff_MP2
XXMP3 XMP4/y CK VDD tspc_dff_MP3
XXMN1 XMP2/x D VSS tspc_dff_MN1
XXMP4 QB XMP4/y VDD tspc_dff_MP4
XXMN2 XMN3/b2 XMP4/y XMP2/x VSS tspc_dff_MN2
XXMP5 Q QB VDD tspc_dff_MP5
XXMN3 XMN3/b2 CK VSS tspc_dff_MN3
XXMN4 XMN5/c3 QB CK VSS tspc_dff_MN4
XXMN5 XMN5/c3 XMP4/y VSS tspc_dff_MN5
XXMN6 Q QB VSS tspc_dff_MN6
.ends

.subckt div2 VDD CK Q QB VSS
XXF VDD QB CK Q QB VSS tspc_dff
.ends

.subckt nor2_MP1 n1 A VDD
X0 n1 A VDD VDD pfet_03v3 ad=1.78p pd=8.89u as=1.78p ps=8.89u w=4u l=0.28u
.ends

.subckt nor2_MP2 n1 Y B VDD
X0 Y B n1 VDD pfet_03v3 ad=1.78p pd=8.89u as=1.78p ps=8.89u w=4u l=0.28u
.ends

.subckt nor2_MN1 Y A VSS
X0 Y A VSS VSS nfet_03v3 ad=0.445p pd=2.89u as=0.445p ps=2.89u w=1u l=0.28u
.ends

.subckt nor2_MN2 Y B VSS
X0 Y B VSS VSS nfet_03v3 ad=0.445p pd=2.89u as=0.445p ps=2.89u w=1u l=0.28u
.ends

.subckt nor2 VDD A B Y VSS
XXMP1 XMP2/n1 A VDD nor2_MP1
XXMP2 XMP2/n1 Y B VDD nor2_MP2
XXMN1 Y A VSS nor2_MN1
XXMN2 Y B VSS nor2_MN2
.ends

.subckt div3 VDD CK Q VSS
XXF1 VDD XN/Y CK Q XF1/QB VSS tspc_dff
XXF2 VDD Q CK XN/B XF2/QB VSS tspc_dff
XXN VDD Q XN/B XN/Y VSS nor2
.ends

.subckt div48 VDD CK FS FB VSS
XXFB1 VDD FB XFB2/A VSS inv_lo1
XXFB2 VDD XFB2/A FS VSS inv_lo2
XXD1 VDD CK XD1/Q XD1/QB VSS div2
XXD2 VDD XD1/Q XD2/Q XD2/QB VSS div2
XXD3 VDD XD2/Q XD3/Q XD3/QB VSS div2
XXD5 VDD XD3/Q XD5/Q VSS div3
XXD6 VDD XD5/Q FB XD6/QB VSS div2
.ends

.subckt inv_dig_MN Y A VSS
X0 Y A VSS VSS nfet_03v3 ad=0.445p pd=2.89u as=0.445p ps=2.89u w=1u l=0.28u
.ends

.subckt inv_dig_MP Y A VDD
X0 Y A VDD VDD pfet_03v3 ad=0.89p pd=4.89u as=0.89p ps=4.89u w=2u l=0.28u
.ends

.subckt inv_dig VDD A Y VSS
XXMN Y A VSS inv_dig_MN
XXMP Y A VDD inv_dig_MP
.ends

.subckt nand2_MP1 Y A VDD
X0 Y A VDD VDD pfet_03v3 ad=0.89p pd=4.89u as=0.89p ps=4.89u w=2u l=0.28u
.ends

.subckt nand2_MP2 Y B VDD
X0 Y B VDD VDD pfet_03v3 ad=0.89p pd=4.89u as=0.89p ps=4.89u w=2u l=0.28u
.ends

.subckt nand2_MN1 n1 Y A VSS
X0 Y A n1 VSS nfet_03v3 ad=0.89p pd=4.89u as=0.89p ps=4.89u w=2u l=0.28u
.ends

.subckt nand2_MN2 n1 B VSS
X0 n1 B VSS VSS nfet_03v3 ad=0.89p pd=4.89u as=0.89p ps=4.89u w=2u l=0.28u
.ends

.subckt nand2 VDD A B Y VSS
XXMP1 Y A VDD nand2_MP1
XXMP2 Y B VDD nand2_MP2
XXMN1 XMN2/n1 Y A VSS nand2_MN1
XXMN2 XMN2/n1 B VSS nand2_MN2
.ends

.subckt nand3_MP1 Y A VDD
X0 Y A VDD VDD pfet_03v3 ad=0.89p pd=4.89u as=0.89p ps=4.89u w=2u l=0.28u
.ends

.subckt nand3_MP2 Y B VDD
X0 Y B VDD VDD pfet_03v3 ad=0.89p pd=4.89u as=0.89p ps=4.89u w=2u l=0.28u
.ends

.subckt nand3_MP3 Y C VDD
X0 Y C VDD VDD pfet_03v3 ad=0.89p pd=4.89u as=0.89p ps=4.89u w=2u l=0.28u
.ends

.subckt nand3_MN1 n1 Y A VSS
X0 Y A n1 VSS nfet_03v3 ad=1.335p pd=6.89u as=1.335p ps=6.89u w=3u l=0.28u
.ends

.subckt nand3_MN2 n2 n1 B VSS
X0 n1 B n2 VSS nfet_03v3 ad=1.335p pd=6.89u as=1.335p ps=6.89u w=3u l=0.28u
.ends

.subckt nand3_MN3 n2 C VSS
X0 n2 C VSS VSS nfet_03v3 ad=1.335p pd=6.89u as=1.335p ps=6.89u w=3u l=0.28u
.ends

.subckt nand3 VDD A B C Y VSS
XXMP1 Y A VDD nand3_MP1
XXMP2 Y B VDD nand3_MP2
XXMP3 Y C VDD nand3_MP3
XXMN1 XMN2/n1 Y A VSS nand3_MN1
XXMN2 XMN3/n2 XMN2/n1 B VSS nand3_MN2
XXMN3 XMN3/n2 C VSS nand3_MN3
.ends

.subckt dff_r VDD CK RB Q VSS
XX4 VDD X6/B RB X4/Y VSS nand2
XX5 VDD X5/A X6/Y Q VSS nand2
XX6 VDD Q X6/B RB X6/Y VSS nand3
XX1 VDD X4/Y X5/A X2/A VSS nand2
XX2 VDD X2/A CK RB X5/A VSS nand3
XX3 VDD X5/A CK X4/Y X6/B VSS nand3
.ends

.subckt pfd VDD REF FB UP UPB DN DNB VSS
XXO1 VDD UP UPB VSS inv_dig
XXO2 VDD DN DNB VSS inv_dig
XXD VDD FB XU/RB DN VSS dff_r
XXD1 VDD XR/Y XD2/A VSS inv_dig
XXD2 VDD XD2/A XD3/A VSS inv_dig
XXD3 VDD XD3/A XD4/A VSS inv_dig
XXD4 VDD XD4/A XU/RB VSS inv_dig
XXR VDD UP DN XR/Y VSS nand2
XXU VDD REF XU/RB UP VSS dff_r
.ends

.subckt pll_core_MTHI thi tx VDD
X0 thi tx VDD VDD pfet_03v3 ad=0.445p pd=2.89u as=0.445p ps=2.89u w=1u l=0.28u
.ends

.subckt cp_MPE2 pc2 pe2 hib VDD
X0 pc2 hib pe2 VDD pfet_03v3 ad=1.59p pd=6.53u as=1.59p ps=6.53u w=6u l=0.28u
X1 pe2 hib pc2 VDD pfet_03v3 ad=1.59p pd=6.53u as=2.67p ps=12.89u w=6u l=0.28u
X2 pc2 hib pe2 VDD pfet_03v3 ad=2.67p pd=12.89u as=1.59p ps=6.53u w=6u l=0.28u
X3 pe2 hib pc2 VDD pfet_03v3 ad=1.59p pd=6.53u as=1.59p ps=6.53u w=6u l=0.28u
.ends

.subckt cp_MNS nc OUT DN VSS
X0 OUT DN nc VSS nfet_03v3 ad=0.89p pd=4.89u as=0.89p ps=4.89u w=2u l=0.28u
.ends

.subckt cp_MNE2 nc2 ne2 HI VSS
X0 nc2 HI ne2 VSS nfet_03v3 ad=0.89p pd=4.89u as=0.53p ps=2.53u w=2u l=0.28u
X1 ne2 HI nc2 VSS nfet_03v3 ad=0.53p pd=2.53u as=0.89p ps=4.89u w=2u l=0.28u
.ends

.subckt cp_MND2 ne2 vd DNB VSS
X0 vd DNB ne2 VSS nfet_03v3 ad=0.89p pd=4.89u as=0.89p ps=4.89u w=2u l=0.28u
.ends

.subckt cp_MBL1_MBL2 b1 vd VDD
X0 b1 b1 VDD VDD pfet_03v3 ad=1.06p pd=4.53u as=1.78p ps=8.89u w=4u l=1u
X1 VDD b1 b1 VDD pfet_03v3 ad=1.06p pd=4.53u as=1.06p ps=4.53u w=4u l=1u
X2 VDD b1 vd VDD pfet_03v3 ad=1.78p pd=8.89u as=1.06p ps=4.53u w=4u l=1u
X3 vd b1 VDD VDD pfet_03v3 ad=1.06p pd=4.53u as=1.06p ps=4.53u w=4u l=1u
.ends

.subckt cp_MB1_MB2 bt b1 vd OUT VSS
X0 bt OUT b1 VSS nfet_03v3 ad=1.06p pd=4.53u as=1.06p ps=4.53u w=4u l=1u
X1 b1 OUT bt VSS nfet_03v3 ad=1.06p pd=4.53u as=1.78p ps=8.89u w=4u l=1u
X2 vd vd bt VSS nfet_03v3 ad=1.06p pd=4.53u as=1.06p ps=4.53u w=4u l=1u
X3 bt vd vd VSS nfet_03v3 ad=1.78p pd=8.89u as=1.06p ps=4.53u w=4u l=1u
.ends

.subckt cp_MNC_MNC2_MBT nc nc2 bt NB VSS
X0 nc2 NB VSS VSS nfet_03v3 ad=2.12p pd=8.53u as=2.12p ps=8.53u w=8u l=2u
X1 VSS NB nc VSS nfet_03v3 ad=3.56p pd=16.89u as=2.12p ps=8.53u w=8u l=2u
X2 VSS NB nc2 VSS nfet_03v3 ad=2.12p pd=8.53u as=2.12p ps=8.53u w=8u l=2u
X3 VSS NB nc VSS nfet_03v3 ad=2.12p pd=8.53u as=2.12p ps=8.53u w=8u l=2u
X4 nc NB VSS VSS nfet_03v3 ad=2.12p pd=8.53u as=3.56p ps=16.89u w=8u l=2u
X5 nc2 NB VSS VSS nfet_03v3 ad=2.12p pd=8.53u as=2.12p ps=8.53u w=8u l=2u
X6 bt NB VSS VSS nfet_03v3 ad=2.12p pd=8.53u as=2.12p ps=8.53u w=8u l=2u
X7 VSS NB bt VSS nfet_03v3 ad=2.12p pd=8.53u as=2.12p ps=8.53u w=8u l=2u
X8 VSS NB nc2 VSS nfet_03v3 ad=2.12p pd=8.53u as=2.12p ps=8.53u w=8u l=2u
X9 nc NB VSS VSS nfet_03v3 ad=2.12p pd=8.53u as=2.12p ps=8.53u w=8u l=2u
X10 nc2 NB VSS VSS nfet_03v3 ad=2.12p pd=8.53u as=2.12p ps=8.53u w=8u l=2u
X11 VSS NB nc2 VSS nfet_03v3 ad=2.12p pd=8.53u as=2.12p ps=8.53u w=8u l=2u
X12 nc NB VSS VSS nfet_03v3 ad=2.12p pd=8.53u as=2.12p ps=8.53u w=8u l=2u
X13 VSS NB nc2 VSS nfet_03v3 ad=2.12p pd=8.53u as=2.12p ps=8.53u w=8u l=2u
X14 nc2 NB VSS VSS nfet_03v3 ad=2.12p pd=8.53u as=2.12p ps=8.53u w=8u l=2u
X15 VSS NB nc VSS nfet_03v3 ad=2.12p pd=8.53u as=2.12p ps=8.53u w=8u l=2u
X16 VSS NB nc VSS nfet_03v3 ad=2.12p pd=8.53u as=2.12p ps=8.53u w=8u l=2u
X17 nc NB VSS VSS nfet_03v3 ad=2.12p pd=8.53u as=2.12p ps=8.53u w=8u l=2u
.ends

.subckt cp_MPC_MPC2 pc pc2 PB VDD
X0 pc2 PB VDD VDD pfet_03v3 ad=2.12p pd=8.53u as=2.12p ps=8.53u w=8u l=2u
X1 pc PB VDD VDD pfet_03v3 ad=2.12p pd=8.53u as=2.12p ps=8.53u w=8u l=2u
X2 pc2 PB VDD VDD pfet_03v3 ad=2.12p pd=8.53u as=2.12p ps=8.53u w=8u l=2u
X3 VDD PB pc2 VDD pfet_03v3 ad=2.12p pd=8.53u as=2.12p ps=8.53u w=8u l=2u
X4 VDD PB pc2 VDD pfet_03v3 ad=2.12p pd=8.53u as=2.12p ps=8.53u w=8u l=2u
X5 VDD PB pc VDD pfet_03v3 ad=2.12p pd=8.53u as=2.12p ps=8.53u w=8u l=2u
X6 pc PB VDD VDD pfet_03v3 ad=2.12p pd=8.53u as=3.56p ps=16.89u w=8u l=2u
X7 pc2 PB VDD VDD pfet_03v3 ad=2.12p pd=8.53u as=2.12p ps=8.53u w=8u l=2u
X8 pc PB VDD VDD pfet_03v3 ad=2.12p pd=8.53u as=2.12p ps=8.53u w=8u l=2u
X9 pc PB VDD VDD pfet_03v3 ad=2.12p pd=8.53u as=2.12p ps=8.53u w=8u l=2u
X10 VDD PB pc VDD pfet_03v3 ad=2.12p pd=8.53u as=2.12p ps=8.53u w=8u l=2u
X11 VDD PB pc VDD pfet_03v3 ad=3.56p pd=16.89u as=2.12p ps=8.53u w=8u l=2u
X12 VDD PB pc2 VDD pfet_03v3 ad=2.12p pd=8.53u as=2.12p ps=8.53u w=8u l=2u
X13 VDD PB pc2 VDD pfet_03v3 ad=2.12p pd=8.53u as=2.12p ps=8.53u w=8u l=2u
X14 pc PB VDD VDD pfet_03v3 ad=2.12p pd=8.53u as=2.12p ps=8.53u w=8u l=2u
X15 pc2 PB VDD VDD pfet_03v3 ad=2.12p pd=8.53u as=2.12p ps=8.53u w=8u l=2u
X16 pc2 PB VDD VDD pfet_03v3 ad=2.12p pd=8.53u as=2.12p ps=8.53u w=8u l=2u
X17 VDD PB pc2 VDD pfet_03v3 ad=2.12p pd=8.53u as=2.12p ps=8.53u w=8u l=2u
X18 VDD PB pc2 VDD pfet_03v3 ad=2.12p pd=8.53u as=2.12p ps=8.53u w=8u l=2u
X19 VDD PB pc VDD pfet_03v3 ad=2.12p pd=8.53u as=2.12p ps=8.53u w=8u l=2u
X20 pc PB VDD VDD pfet_03v3 ad=2.12p pd=8.53u as=2.12p ps=8.53u w=8u l=2u
X21 pc PB VDD VDD pfet_03v3 ad=2.12p pd=8.53u as=2.12p ps=8.53u w=8u l=2u
X22 pc2 PB VDD VDD pfet_03v3 ad=2.12p pd=8.53u as=2.12p ps=8.53u w=8u l=2u
X23 VDD PB pc VDD pfet_03v3 ad=2.12p pd=8.53u as=2.12p ps=8.53u w=8u l=2u
X24 VDD PB pc2 VDD pfet_03v3 ad=2.12p pd=8.53u as=2.12p ps=8.53u w=8u l=2u
X25 VDD PB pc2 VDD pfet_03v3 ad=2.12p pd=8.53u as=2.12p ps=8.53u w=8u l=2u
X26 pc2 PB VDD VDD pfet_03v3 ad=2.12p pd=8.53u as=2.12p ps=8.53u w=8u l=2u
X27 pc PB VDD VDD pfet_03v3 ad=2.12p pd=8.53u as=2.12p ps=8.53u w=8u l=2u
X28 VDD PB pc VDD pfet_03v3 ad=2.12p pd=8.53u as=2.12p ps=8.53u w=8u l=2u
X29 pc2 PB VDD VDD pfet_03v3 ad=2.12p pd=8.53u as=2.12p ps=8.53u w=8u l=2u
X30 VDD PB pc VDD pfet_03v3 ad=2.12p pd=8.53u as=2.12p ps=8.53u w=8u l=2u
X31 VDD PB pc VDD pfet_03v3 ad=2.12p pd=8.53u as=2.12p ps=8.53u w=8u l=2u
.ends

.subckt cp_MND nc vd DNB VSS
X0 vd DNB nc VSS nfet_03v3 ad=0.89p pd=4.89u as=0.89p ps=4.89u w=2u l=0.28u
.ends

.subckt cp_MNS2 ne2 OUT DN VSS
X0 OUT DN ne2 VSS nfet_03v3 ad=0.89p pd=4.89u as=0.89p ps=4.89u w=2u l=0.28u
.ends

.subckt cp_MPS2_MPD2 pe2 OUT vd UPB upd VDD
X0 pe2 upd vd VDD pfet_03v3 ad=1.78p pd=8.89u as=1.06p ps=4.53u w=4u l=0.28u
X1 OUT UPB pe2 VDD pfet_03v3 ad=1.06p pd=4.53u as=1.78p ps=8.89u w=4u l=0.28u
X2 vd upd pe2 VDD pfet_03v3 ad=1.06p pd=4.53u as=1.06p ps=4.53u w=4u l=0.28u
X3 pe2 UPB OUT VDD pfet_03v3 ad=1.06p pd=4.53u as=1.06p ps=4.53u w=4u l=0.28u
.ends

.subckt cp_MPS_MPD pc OUT vd UPB upd VDD
X0 pc upd vd VDD pfet_03v3 ad=1.78p pd=8.89u as=1.06p ps=4.53u w=4u l=0.28u
X1 OUT UPB pc VDD pfet_03v3 ad=1.06p pd=4.53u as=1.78p ps=8.89u w=4u l=0.28u
X2 vd upd pc VDD pfet_03v3 ad=1.06p pd=4.53u as=1.06p ps=4.53u w=4u l=0.28u
X3 pc UPB OUT VDD pfet_03v3 ad=1.06p pd=4.53u as=1.06p ps=4.53u w=4u l=0.28u
.ends

.subckt cp_CVD vd VSS
X0 vd VSS cap_mim_2f0_m4m5_noshield c_width=5u c_length=5u
X1 vd VSS cap_mim_2f0_m4m5_noshield c_width=5u c_length=5u
X2 vd VSS cap_mim_2f0_m4m5_noshield c_width=5u c_length=5u
X3 vd VSS cap_mim_2f0_m4m5_noshield c_width=5u c_length=5u
X4 vd VSS cap_mim_2f0_m4m5_noshield c_width=5u c_length=5u
X5 vd VSS cap_mim_2f0_m4m5_noshield c_width=5u c_length=5u
X6 vd VSS cap_mim_2f0_m4m5_noshield c_width=5u c_length=5u
X7 vd VSS cap_mim_2f0_m4m5_noshield c_width=5u c_length=5u
X8 vd VSS cap_mim_2f0_m4m5_noshield c_width=5u c_length=5u
X9 vd VSS cap_mim_2f0_m4m5_noshield c_width=5u c_length=5u
X10 vd VSS cap_mim_2f0_m4m5_noshield c_width=5u c_length=5u
X11 vd VSS cap_mim_2f0_m4m5_noshield c_width=5u c_length=5u
X12 vd VSS cap_mim_2f0_m4m5_noshield c_width=5u c_length=5u
X13 vd VSS cap_mim_2f0_m4m5_noshield c_width=5u c_length=5u
X14 vd VSS cap_mim_2f0_m4m5_noshield c_width=5u c_length=5u
X15 vd VSS cap_mim_2f0_m4m5_noshield c_width=5u c_length=5u
X16 vd VSS cap_mim_2f0_m4m5_noshield c_width=5u c_length=5u
X17 vd VSS cap_mim_2f0_m4m5_noshield c_width=5u c_length=5u
X18 vd VSS cap_mim_2f0_m4m5_noshield c_width=5u c_length=5u
X19 vd VSS cap_mim_2f0_m4m5_noshield c_width=5u c_length=5u
X20 vd VSS cap_mim_2f0_m4m5_noshield c_width=5u c_length=5u
X21 vd VSS cap_mim_2f0_m4m5_noshield c_width=5u c_length=5u
X22 vd VSS cap_mim_2f0_m4m5_noshield c_width=5u c_length=5u
X23 vd VSS cap_mim_2f0_m4m5_noshield c_width=5u c_length=5u
X24 vd VSS cap_mim_2f0_m4m5_noshield c_width=5u c_length=5u
X25 vd VSS cap_mim_2f0_m4m5_noshield c_width=5u c_length=5u
X26 vd VSS cap_mim_2f0_m4m5_noshield c_width=5u c_length=5u
X27 vd VSS cap_mim_2f0_m4m5_noshield c_width=5u c_length=5u
X28 vd VSS cap_mim_2f0_m4m5_noshield c_width=5u c_length=5u
X29 vd VSS cap_mim_2f0_m4m5_noshield c_width=5u c_length=5u
X30 vd VSS cap_mim_2f0_m4m5_noshield c_width=5u c_length=5u
X31 vd VSS cap_mim_2f0_m4m5_noshield c_width=5u c_length=5u
X32 vd VSS cap_mim_2f0_m4m5_noshield c_width=5u c_length=5u
X33 vd VSS cap_mim_2f0_m4m5_noshield c_width=5u c_length=5u
X34 vd VSS cap_mim_2f0_m4m5_noshield c_width=5u c_length=5u
X35 vd VSS cap_mim_2f0_m4m5_noshield c_width=5u c_length=5u
X36 vd VSS cap_mim_2f0_m4m5_noshield c_width=5u c_length=5u
X37 vd VSS cap_mim_2f0_m4m5_noshield c_width=5u c_length=5u
X38 vd VSS cap_mim_2f0_m4m5_noshield c_width=5u c_length=5u
X39 vd VSS cap_mim_2f0_m4m5_noshield c_width=5u c_length=5u
X40 vd VSS cap_mim_2f0_m4m5_noshield c_width=5u c_length=5u
.ends

.subckt cp VDD UPB DN DNB PB NB HI OUT VSS
XXMPE2 XMPE2/pc2 XMPE2/pe2 XHI/Y VDD cp_MPE2
XXMNS XMNS/nc OUT DN VSS cp_MNS
XXHI VDD HI XHI/Y VSS inv_dig
XXMNE2 XMNE2/nc2 XMNS2/ne2 HI VSS cp_MNE2
XXMND2 XMNS2/ne2 XMND/vd DNB VSS cp_MND2
XXMBL1_MBL2 XMB1_MB2/b1 XMND/vd VDD cp_MBL1_MBL2
XXMB1_MB2 XMB1_MB2/bt XMB1_MB2/b1 XMND/vd OUT VSS cp_MB1_MB2
XXMNC_MNC2_MBT XMNS/nc XMNE2/nc2 XMB1_MB2/bt NB VSS cp_MNC_MNC2_MBT
XXUD VDD UPB XUD/Y VSS inv_dig
XXMPC_MPC2 XMPS_MPD/pc XMPE2/pc2 PB VDD cp_MPC_MPC2
XXMND XMNS/nc XMND/vd DNB VSS cp_MND
XXMNS2 XMNS2/ne2 OUT DN VSS cp_MNS2
XXMPS2_MPD2 XMPE2/pe2 OUT XMND/vd UPB XUD/Y VDD cp_MPS2_MPD2
XXMPS_MPD XMPS_MPD/pc OUT XMND/vd UPB XUD/Y VDD cp_MPS_MPD
XXCVD XMND/vd VSS cp_CVD
.ends

.subckt pll_core_MTLO tlo thi VSS
X0 tlo thi VSS VSS nfet_03v3 ad=0.445p pd=2.89u as=0.445p ps=2.89u w=1u l=0.28u
.ends

.subckt pll_core_R2u_0 refck_i REFCK VSS
X0 REFCK refck_i VSS ppolyf_u_1k r_width=2u r_length=2u
.ends

.subckt pll_core_MCLN refck_i tlo VSS
X0 refck_i tlo VSS VSS nfet_03v3 ad=0.89p pd=4.89u as=0.89p ps=4.89u w=2u l=0.28u
.ends

.subckt pll_core_MCLP refck_i thi VDD
X0 refck_i thi VDD VDD pfet_03v3 ad=0.89p pd=4.89u as=0.89p ps=4.89u w=2u l=0.28u
.ends

.subckt loop_filter_R1u_0 z VC VSS
X0 VC z VSS ppolyf_u_1k r_width=1u r_length=5u
.ends

.subckt loop_filter_C1 z VSS
X0 z VSS cap_mim_2f0_m4m5_noshield c_width=5u c_length=5u
X1 z VSS cap_mim_2f0_m4m5_noshield c_width=5u c_length=5u
X2 z VSS cap_mim_2f0_m4m5_noshield c_width=5u c_length=5u
X3 z VSS cap_mim_2f0_m4m5_noshield c_width=5u c_length=5u
X4 z VSS cap_mim_2f0_m4m5_noshield c_width=5u c_length=5u
X5 z VSS cap_mim_2f0_m4m5_noshield c_width=5u c_length=5u
X6 z VSS cap_mim_2f0_m4m5_noshield c_width=5u c_length=5u
X7 z VSS cap_mim_2f0_m4m5_noshield c_width=5u c_length=5u
X8 z VSS cap_mim_2f0_m4m5_noshield c_width=5u c_length=5u
X9 z VSS cap_mim_2f0_m4m5_noshield c_width=5u c_length=5u
X10 z VSS cap_mim_2f0_m4m5_noshield c_width=5u c_length=5u
X11 z VSS cap_mim_2f0_m4m5_noshield c_width=5u c_length=5u
X12 z VSS cap_mim_2f0_m4m5_noshield c_width=5u c_length=5u
X13 z VSS cap_mim_2f0_m4m5_noshield c_width=5u c_length=5u
X14 z VSS cap_mim_2f0_m4m5_noshield c_width=5u c_length=5u
X15 z VSS cap_mim_2f0_m4m5_noshield c_width=5u c_length=5u
X16 z VSS cap_mim_2f0_m4m5_noshield c_width=5u c_length=5u
X17 z VSS cap_mim_2f0_m4m5_noshield c_width=5u c_length=5u
X18 z VSS cap_mim_2f0_m4m5_noshield c_width=5u c_length=5u
X19 z VSS cap_mim_2f0_m4m5_noshield c_width=5u c_length=5u
X20 z VSS cap_mim_2f0_m4m5_noshield c_width=5u c_length=5u
X21 z VSS cap_mim_2f0_m4m5_noshield c_width=5u c_length=5u
X22 z VSS cap_mim_2f0_m4m5_noshield c_width=5u c_length=5u
X23 z VSS cap_mim_2f0_m4m5_noshield c_width=5u c_length=5u
X24 z VSS cap_mim_2f0_m4m5_noshield c_width=5u c_length=5u
X25 z VSS cap_mim_2f0_m4m5_noshield c_width=5u c_length=5u
X26 z VSS cap_mim_2f0_m4m5_noshield c_width=5u c_length=5u
X27 z VSS cap_mim_2f0_m4m5_noshield c_width=5u c_length=5u
X28 z VSS cap_mim_2f0_m4m5_noshield c_width=5u c_length=5u
X29 z VSS cap_mim_2f0_m4m5_noshield c_width=5u c_length=5u
X30 z VSS cap_mim_2f0_m4m5_noshield c_width=5u c_length=5u
X31 z VSS cap_mim_2f0_m4m5_noshield c_width=5u c_length=5u
X32 z VSS cap_mim_2f0_m4m5_noshield c_width=5u c_length=5u
X33 z VSS cap_mim_2f0_m4m5_noshield c_width=5u c_length=5u
X34 z VSS cap_mim_2f0_m4m5_noshield c_width=5u c_length=5u
X35 z VSS cap_mim_2f0_m4m5_noshield c_width=5u c_length=5u
X36 z VSS cap_mim_2f0_m4m5_noshield c_width=5u c_length=5u
X37 z VSS cap_mim_2f0_m4m5_noshield c_width=5u c_length=5u
X38 z VSS cap_mim_2f0_m4m5_noshield c_width=5u c_length=5u
X39 z VSS cap_mim_2f0_m4m5_noshield c_width=5u c_length=5u
X40 z VSS cap_mim_2f0_m4m5_noshield c_width=5u c_length=5u
X41 z VSS cap_mim_2f0_m4m5_noshield c_width=5u c_length=5u
X42 z VSS cap_mim_2f0_m4m5_noshield c_width=5u c_length=5u
X43 z VSS cap_mim_2f0_m4m5_noshield c_width=5u c_length=5u
X44 z VSS cap_mim_2f0_m4m5_noshield c_width=5u c_length=5u
X45 z VSS cap_mim_2f0_m4m5_noshield c_width=5u c_length=5u
X46 z VSS cap_mim_2f0_m4m5_noshield c_width=5u c_length=5u
X47 z VSS cap_mim_2f0_m4m5_noshield c_width=5u c_length=5u
X48 z VSS cap_mim_2f0_m4m5_noshield c_width=5u c_length=5u
X49 z VSS cap_mim_2f0_m4m5_noshield c_width=5u c_length=5u
X50 z VSS cap_mim_2f0_m4m5_noshield c_width=5u c_length=5u
X51 z VSS cap_mim_2f0_m4m5_noshield c_width=5u c_length=5u
X52 z VSS cap_mim_2f0_m4m5_noshield c_width=5u c_length=5u
X53 z VSS cap_mim_2f0_m4m5_noshield c_width=5u c_length=5u
X54 z VSS cap_mim_2f0_m4m5_noshield c_width=5u c_length=5u
X55 z VSS cap_mim_2f0_m4m5_noshield c_width=5u c_length=5u
X56 z VSS cap_mim_2f0_m4m5_noshield c_width=5u c_length=5u
X57 z VSS cap_mim_2f0_m4m5_noshield c_width=5u c_length=5u
X58 z VSS cap_mim_2f0_m4m5_noshield c_width=5u c_length=5u
X59 z VSS cap_mim_2f0_m4m5_noshield c_width=5u c_length=5u
X60 z VSS cap_mim_2f0_m4m5_noshield c_width=5u c_length=5u
X61 z VSS cap_mim_2f0_m4m5_noshield c_width=5u c_length=5u
X62 z VSS cap_mim_2f0_m4m5_noshield c_width=5u c_length=5u
X63 z VSS cap_mim_2f0_m4m5_noshield c_width=5u c_length=5u
X64 z VSS cap_mim_2f0_m4m5_noshield c_width=5u c_length=5u
X65 z VSS cap_mim_2f0_m4m5_noshield c_width=5u c_length=5u
X66 z VSS cap_mim_2f0_m4m5_noshield c_width=5u c_length=5u
X67 z VSS cap_mim_2f0_m4m5_noshield c_width=5u c_length=5u
X68 z VSS cap_mim_2f0_m4m5_noshield c_width=5u c_length=5u
X69 z VSS cap_mim_2f0_m4m5_noshield c_width=5u c_length=5u
X70 z VSS cap_mim_2f0_m4m5_noshield c_width=5u c_length=5u
X71 z VSS cap_mim_2f0_m4m5_noshield c_width=5u c_length=5u
X72 z VSS cap_mim_2f0_m4m5_noshield c_width=5u c_length=5u
X73 z VSS cap_mim_2f0_m4m5_noshield c_width=5u c_length=5u
X74 z VSS cap_mim_2f0_m4m5_noshield c_width=5u c_length=5u
X75 z VSS cap_mim_2f0_m4m5_noshield c_width=5u c_length=5u
X76 z VSS cap_mim_2f0_m4m5_noshield c_width=5u c_length=5u
X77 z VSS cap_mim_2f0_m4m5_noshield c_width=5u c_length=5u
X78 z VSS cap_mim_2f0_m4m5_noshield c_width=5u c_length=5u
X79 z VSS cap_mim_2f0_m4m5_noshield c_width=5u c_length=5u
X80 z VSS cap_mim_2f0_m4m5_noshield c_width=5u c_length=5u
X81 z VSS cap_mim_2f0_m4m5_noshield c_width=5u c_length=5u
X82 z VSS cap_mim_2f0_m4m5_noshield c_width=5u c_length=5u
X83 z VSS cap_mim_2f0_m4m5_noshield c_width=5u c_length=5u
X84 z VSS cap_mim_2f0_m4m5_noshield c_width=5u c_length=5u
X85 z VSS cap_mim_2f0_m4m5_noshield c_width=5u c_length=5u
X86 z VSS cap_mim_2f0_m4m5_noshield c_width=5u c_length=5u
X87 z VSS cap_mim_2f0_m4m5_noshield c_width=5u c_length=5u
X88 z VSS cap_mim_2f0_m4m5_noshield c_width=5u c_length=5u
X89 z VSS cap_mim_2f0_m4m5_noshield c_width=5u c_length=5u
X90 z VSS cap_mim_2f0_m4m5_noshield c_width=5u c_length=5u
X91 z VSS cap_mim_2f0_m4m5_noshield c_width=5u c_length=5u
X92 z VSS cap_mim_2f0_m4m5_noshield c_width=5u c_length=5u
X93 z VSS cap_mim_2f0_m4m5_noshield c_width=5u c_length=5u
X94 z VSS cap_mim_2f0_m4m5_noshield c_width=5u c_length=5u
X95 z VSS cap_mim_2f0_m4m5_noshield c_width=5u c_length=5u
X96 z VSS cap_mim_2f0_m4m5_noshield c_width=5u c_length=5u
X97 z VSS cap_mim_2f0_m4m5_noshield c_width=5u c_length=5u
X98 z VSS cap_mim_2f0_m4m5_noshield c_width=5u c_length=5u
X99 z VSS cap_mim_2f0_m4m5_noshield c_width=5u c_length=5u
X100 z VSS cap_mim_2f0_m4m5_noshield c_width=5u c_length=5u
X101 z VSS cap_mim_2f0_m4m5_noshield c_width=5u c_length=5u
X102 z VSS cap_mim_2f0_m4m5_noshield c_width=5u c_length=5u
X103 z VSS cap_mim_2f0_m4m5_noshield c_width=5u c_length=5u
X104 z VSS cap_mim_2f0_m4m5_noshield c_width=5u c_length=5u
X105 z VSS cap_mim_2f0_m4m5_noshield c_width=5u c_length=5u
X106 z VSS cap_mim_2f0_m4m5_noshield c_width=5u c_length=5u
X107 z VSS cap_mim_2f0_m4m5_noshield c_width=5u c_length=5u
X108 z VSS cap_mim_2f0_m4m5_noshield c_width=5u c_length=5u
X109 z VSS cap_mim_2f0_m4m5_noshield c_width=5u c_length=5u
X110 z VSS cap_mim_2f0_m4m5_noshield c_width=5u c_length=5u
X111 z VSS cap_mim_2f0_m4m5_noshield c_width=5u c_length=5u
X112 z VSS cap_mim_2f0_m4m5_noshield c_width=5u c_length=5u
X113 z VSS cap_mim_2f0_m4m5_noshield c_width=5u c_length=5u
X114 z VSS cap_mim_2f0_m4m5_noshield c_width=5u c_length=5u
X115 z VSS cap_mim_2f0_m4m5_noshield c_width=5u c_length=5u
X116 z VSS cap_mim_2f0_m4m5_noshield c_width=5u c_length=5u
X117 z VSS cap_mim_2f0_m4m5_noshield c_width=5u c_length=5u
X118 z VSS cap_mim_2f0_m4m5_noshield c_width=5u c_length=5u
X119 z VSS cap_mim_2f0_m4m5_noshield c_width=5u c_length=5u
X120 z VSS cap_mim_2f0_m4m5_noshield c_width=5u c_length=5u
X121 z VSS cap_mim_2f0_m4m5_noshield c_width=5u c_length=5u
X122 z VSS cap_mim_2f0_m4m5_noshield c_width=5u c_length=5u
X123 z VSS cap_mim_2f0_m4m5_noshield c_width=5u c_length=5u
X124 z VSS cap_mim_2f0_m4m5_noshield c_width=5u c_length=5u
X125 z VSS cap_mim_2f0_m4m5_noshield c_width=5u c_length=5u
X126 z VSS cap_mim_2f0_m4m5_noshield c_width=5u c_length=5u
X127 z VSS cap_mim_2f0_m4m5_noshield c_width=5u c_length=5u
X128 z VSS cap_mim_2f0_m4m5_noshield c_width=5u c_length=5u
X129 z VSS cap_mim_2f0_m4m5_noshield c_width=5u c_length=5u
X130 z VSS cap_mim_2f0_m4m5_noshield c_width=5u c_length=5u
X131 z VSS cap_mim_2f0_m4m5_noshield c_width=5u c_length=5u
X132 z VSS cap_mim_2f0_m4m5_noshield c_width=5u c_length=5u
X133 z VSS cap_mim_2f0_m4m5_noshield c_width=5u c_length=5u
X134 z VSS cap_mim_2f0_m4m5_noshield c_width=5u c_length=5u
X135 z VSS cap_mim_2f0_m4m5_noshield c_width=5u c_length=5u
X136 z VSS cap_mim_2f0_m4m5_noshield c_width=5u c_length=5u
X137 z VSS cap_mim_2f0_m4m5_noshield c_width=5u c_length=5u
X138 z VSS cap_mim_2f0_m4m5_noshield c_width=5u c_length=5u
X139 z VSS cap_mim_2f0_m4m5_noshield c_width=5u c_length=5u
X140 z VSS cap_mim_2f0_m4m5_noshield c_width=5u c_length=5u
X141 z VSS cap_mim_2f0_m4m5_noshield c_width=5u c_length=5u
X142 z VSS cap_mim_2f0_m4m5_noshield c_width=5u c_length=5u
X143 z VSS cap_mim_2f0_m4m5_noshield c_width=5u c_length=5u
X144 z VSS cap_mim_2f0_m4m5_noshield c_width=5u c_length=5u
X145 z VSS cap_mim_2f0_m4m5_noshield c_width=5u c_length=5u
X146 z VSS cap_mim_2f0_m4m5_noshield c_width=5u c_length=5u
X147 z VSS cap_mim_2f0_m4m5_noshield c_width=5u c_length=5u
X148 z VSS cap_mim_2f0_m4m5_noshield c_width=5u c_length=5u
X149 z VSS cap_mim_2f0_m4m5_noshield c_width=5u c_length=5u
X150 z VSS cap_mim_2f0_m4m5_noshield c_width=5u c_length=5u
X151 z VSS cap_mim_2f0_m4m5_noshield c_width=5u c_length=5u
X152 z VSS cap_mim_2f0_m4m5_noshield c_width=5u c_length=5u
X153 z VSS cap_mim_2f0_m4m5_noshield c_width=5u c_length=5u
X154 z VSS cap_mim_2f0_m4m5_noshield c_width=5u c_length=5u
X155 z VSS cap_mim_2f0_m4m5_noshield c_width=5u c_length=5u
X156 z VSS cap_mim_2f0_m4m5_noshield c_width=5u c_length=5u
X157 z VSS cap_mim_2f0_m4m5_noshield c_width=5u c_length=5u
X158 z VSS cap_mim_2f0_m4m5_noshield c_width=5u c_length=5u
X159 z VSS cap_mim_2f0_m4m5_noshield c_width=5u c_length=5u
X160 z VSS cap_mim_2f0_m4m5_noshield c_width=5u c_length=5u
X161 z VSS cap_mim_2f0_m4m5_noshield c_width=5u c_length=5u
X162 z VSS cap_mim_2f0_m4m5_noshield c_width=5u c_length=5u
X163 z VSS cap_mim_2f0_m4m5_noshield c_width=5u c_length=5u
X164 z VSS cap_mim_2f0_m4m5_noshield c_width=5u c_length=5u
X165 z VSS cap_mim_2f0_m4m5_noshield c_width=5u c_length=5u
X166 z VSS cap_mim_2f0_m4m5_noshield c_width=5u c_length=5u
X167 z VSS cap_mim_2f0_m4m5_noshield c_width=5u c_length=5u
X168 z VSS cap_mim_2f0_m4m5_noshield c_width=5u c_length=5u
X169 z VSS cap_mim_2f0_m4m5_noshield c_width=5u c_length=5u
X170 z VSS cap_mim_2f0_m4m5_noshield c_width=5u c_length=5u
X171 z VSS cap_mim_2f0_m4m5_noshield c_width=5u c_length=5u
X172 z VSS cap_mim_2f0_m4m5_noshield c_width=5u c_length=5u
X173 z VSS cap_mim_2f0_m4m5_noshield c_width=5u c_length=5u
X174 z VSS cap_mim_2f0_m4m5_noshield c_width=5u c_length=5u
X175 z VSS cap_mim_2f0_m4m5_noshield c_width=5u c_length=5u
X176 z VSS cap_mim_2f0_m4m5_noshield c_width=5u c_length=5u
X177 z VSS cap_mim_2f0_m4m5_noshield c_width=5u c_length=5u
X178 z VSS cap_mim_2f0_m4m5_noshield c_width=5u c_length=5u
X179 z VSS cap_mim_2f0_m4m5_noshield c_width=5u c_length=5u
X180 z VSS cap_mim_2f0_m4m5_noshield c_width=5u c_length=5u
X181 z VSS cap_mim_2f0_m4m5_noshield c_width=5u c_length=5u
X182 z VSS cap_mim_2f0_m4m5_noshield c_width=5u c_length=5u
X183 z VSS cap_mim_2f0_m4m5_noshield c_width=5u c_length=5u
X184 z VSS cap_mim_2f0_m4m5_noshield c_width=5u c_length=5u
X185 z VSS cap_mim_2f0_m4m5_noshield c_width=5u c_length=5u
X186 z VSS cap_mim_2f0_m4m5_noshield c_width=5u c_length=5u
X187 z VSS cap_mim_2f0_m4m5_noshield c_width=5u c_length=5u
X188 z VSS cap_mim_2f0_m4m5_noshield c_width=5u c_length=5u
X189 z VSS cap_mim_2f0_m4m5_noshield c_width=5u c_length=5u
X190 z VSS cap_mim_2f0_m4m5_noshield c_width=5u c_length=5u
X191 z VSS cap_mim_2f0_m4m5_noshield c_width=5u c_length=5u
X192 z VSS cap_mim_2f0_m4m5_noshield c_width=5u c_length=5u
X193 z VSS cap_mim_2f0_m4m5_noshield c_width=5u c_length=5u
X194 z VSS cap_mim_2f0_m4m5_noshield c_width=5u c_length=5u
X195 z VSS cap_mim_2f0_m4m5_noshield c_width=5u c_length=5u
X196 z VSS cap_mim_2f0_m4m5_noshield c_width=5u c_length=5u
X197 z VSS cap_mim_2f0_m4m5_noshield c_width=5u c_length=5u
X198 z VSS cap_mim_2f0_m4m5_noshield c_width=5u c_length=5u
X199 z VSS cap_mim_2f0_m4m5_noshield c_width=5u c_length=5u
X200 z VSS cap_mim_2f0_m4m5_noshield c_width=5u c_length=5u
X201 z VSS cap_mim_2f0_m4m5_noshield c_width=5u c_length=5u
X202 z VSS cap_mim_2f0_m4m5_noshield c_width=5u c_length=5u
X203 z VSS cap_mim_2f0_m4m5_noshield c_width=5u c_length=5u
X204 z VSS cap_mim_2f0_m4m5_noshield c_width=5u c_length=5u
X205 z VSS cap_mim_2f0_m4m5_noshield c_width=5u c_length=5u
X206 z VSS cap_mim_2f0_m4m5_noshield c_width=5u c_length=5u
X207 z VSS cap_mim_2f0_m4m5_noshield c_width=5u c_length=5u
X208 z VSS cap_mim_2f0_m4m5_noshield c_width=5u c_length=5u
X209 z VSS cap_mim_2f0_m4m5_noshield c_width=5u c_length=5u
X210 z VSS cap_mim_2f0_m4m5_noshield c_width=5u c_length=5u
X211 z VSS cap_mim_2f0_m4m5_noshield c_width=5u c_length=5u
X212 z VSS cap_mim_2f0_m4m5_noshield c_width=5u c_length=5u
X213 z VSS cap_mim_2f0_m4m5_noshield c_width=5u c_length=5u
X214 z VSS cap_mim_2f0_m4m5_noshield c_width=5u c_length=5u
X215 z VSS cap_mim_2f0_m4m5_noshield c_width=5u c_length=5u
X216 z VSS cap_mim_2f0_m4m5_noshield c_width=5u c_length=5u
X217 z VSS cap_mim_2f0_m4m5_noshield c_width=5u c_length=5u
X218 z VSS cap_mim_2f0_m4m5_noshield c_width=5u c_length=5u
X219 z VSS cap_mim_2f0_m4m5_noshield c_width=5u c_length=5u
X220 z VSS cap_mim_2f0_m4m5_noshield c_width=5u c_length=5u
X221 z VSS cap_mim_2f0_m4m5_noshield c_width=5u c_length=5u
X222 z VSS cap_mim_2f0_m4m5_noshield c_width=5u c_length=5u
X223 z VSS cap_mim_2f0_m4m5_noshield c_width=5u c_length=5u
X224 z VSS cap_mim_2f0_m4m5_noshield c_width=5u c_length=5u
X225 z VSS cap_mim_2f0_m4m5_noshield c_width=5u c_length=5u
X226 z VSS cap_mim_2f0_m4m5_noshield c_width=5u c_length=5u
X227 z VSS cap_mim_2f0_m4m5_noshield c_width=5u c_length=5u
X228 z VSS cap_mim_2f0_m4m5_noshield c_width=5u c_length=5u
X229 z VSS cap_mim_2f0_m4m5_noshield c_width=5u c_length=5u
X230 z VSS cap_mim_2f0_m4m5_noshield c_width=5u c_length=5u
X231 z VSS cap_mim_2f0_m4m5_noshield c_width=5u c_length=5u
X232 z VSS cap_mim_2f0_m4m5_noshield c_width=5u c_length=5u
X233 z VSS cap_mim_2f0_m4m5_noshield c_width=5u c_length=5u
X234 z VSS cap_mim_2f0_m4m5_noshield c_width=5u c_length=5u
X235 z VSS cap_mim_2f0_m4m5_noshield c_width=5u c_length=5u
X236 z VSS cap_mim_2f0_m4m5_noshield c_width=5u c_length=5u
X237 z VSS cap_mim_2f0_m4m5_noshield c_width=5u c_length=5u
X238 z VSS cap_mim_2f0_m4m5_noshield c_width=5u c_length=5u
X239 z VSS cap_mim_2f0_m4m5_noshield c_width=5u c_length=5u
X240 z VSS cap_mim_2f0_m4m5_noshield c_width=5u c_length=5u
X241 z VSS cap_mim_2f0_m4m5_noshield c_width=5u c_length=5u
X242 z VSS cap_mim_2f0_m4m5_noshield c_width=5u c_length=5u
X243 z VSS cap_mim_2f0_m4m5_noshield c_width=5u c_length=5u
X244 z VSS cap_mim_2f0_m4m5_noshield c_width=5u c_length=5u
X245 z VSS cap_mim_2f0_m4m5_noshield c_width=5u c_length=5u
X246 z VSS cap_mim_2f0_m4m5_noshield c_width=5u c_length=5u
X247 z VSS cap_mim_2f0_m4m5_noshield c_width=5u c_length=5u
X248 z VSS cap_mim_2f0_m4m5_noshield c_width=5u c_length=5u
X249 z VSS cap_mim_2f0_m4m5_noshield c_width=5u c_length=5u
X250 z VSS cap_mim_2f0_m4m5_noshield c_width=5u c_length=5u
X251 z VSS cap_mim_2f0_m4m5_noshield c_width=5u c_length=5u
X252 z VSS cap_mim_2f0_m4m5_noshield c_width=5u c_length=5u
X253 z VSS cap_mim_2f0_m4m5_noshield c_width=5u c_length=5u
X254 z VSS cap_mim_2f0_m4m5_noshield c_width=5u c_length=5u
X255 z VSS cap_mim_2f0_m4m5_noshield c_width=5u c_length=5u
X256 z VSS cap_mim_2f0_m4m5_noshield c_width=5u c_length=5u
X257 z VSS cap_mim_2f0_m4m5_noshield c_width=5u c_length=5u
X258 z VSS cap_mim_2f0_m4m5_noshield c_width=5u c_length=5u
X259 z VSS cap_mim_2f0_m4m5_noshield c_width=5u c_length=5u
X260 z VSS cap_mim_2f0_m4m5_noshield c_width=5u c_length=5u
X261 z VSS cap_mim_2f0_m4m5_noshield c_width=5u c_length=5u
X262 z VSS cap_mim_2f0_m4m5_noshield c_width=5u c_length=5u
X263 z VSS cap_mim_2f0_m4m5_noshield c_width=5u c_length=5u
X264 z VSS cap_mim_2f0_m4m5_noshield c_width=5u c_length=5u
X265 z VSS cap_mim_2f0_m4m5_noshield c_width=5u c_length=5u
X266 z VSS cap_mim_2f0_m4m5_noshield c_width=5u c_length=5u
X267 z VSS cap_mim_2f0_m4m5_noshield c_width=5u c_length=5u
X268 z VSS cap_mim_2f0_m4m5_noshield c_width=5u c_length=5u
X269 z VSS cap_mim_2f0_m4m5_noshield c_width=5u c_length=5u
X270 z VSS cap_mim_2f0_m4m5_noshield c_width=5u c_length=5u
X271 z VSS cap_mim_2f0_m4m5_noshield c_width=5u c_length=5u
X272 z VSS cap_mim_2f0_m4m5_noshield c_width=5u c_length=5u
X273 z VSS cap_mim_2f0_m4m5_noshield c_width=5u c_length=5u
X274 z VSS cap_mim_2f0_m4m5_noshield c_width=5u c_length=5u
X275 z VSS cap_mim_2f0_m4m5_noshield c_width=5u c_length=5u
X276 z VSS cap_mim_2f0_m4m5_noshield c_width=5u c_length=5u
X277 z VSS cap_mim_2f0_m4m5_noshield c_width=5u c_length=5u
X278 z VSS cap_mim_2f0_m4m5_noshield c_width=5u c_length=5u
X279 z VSS cap_mim_2f0_m4m5_noshield c_width=5u c_length=5u
X280 z VSS cap_mim_2f0_m4m5_noshield c_width=5u c_length=5u
X281 z VSS cap_mim_2f0_m4m5_noshield c_width=5u c_length=5u
X282 z VSS cap_mim_2f0_m4m5_noshield c_width=5u c_length=5u
X283 z VSS cap_mim_2f0_m4m5_noshield c_width=5u c_length=5u
X284 z VSS cap_mim_2f0_m4m5_noshield c_width=5u c_length=5u
X285 z VSS cap_mim_2f0_m4m5_noshield c_width=5u c_length=5u
X286 z VSS cap_mim_2f0_m4m5_noshield c_width=5u c_length=5u
X287 z VSS cap_mim_2f0_m4m5_noshield c_width=5u c_length=5u
X288 z VSS cap_mim_2f0_m4m5_noshield c_width=5u c_length=5u
X289 z VSS cap_mim_2f0_m4m5_noshield c_width=5u c_length=5u
X290 z VSS cap_mim_2f0_m4m5_noshield c_width=5u c_length=5u
X291 z VSS cap_mim_2f0_m4m5_noshield c_width=5u c_length=5u
X292 z VSS cap_mim_2f0_m4m5_noshield c_width=5u c_length=5u
X293 z VSS cap_mim_2f0_m4m5_noshield c_width=5u c_length=5u
X294 z VSS cap_mim_2f0_m4m5_noshield c_width=5u c_length=5u
X295 z VSS cap_mim_2f0_m4m5_noshield c_width=5u c_length=5u
X296 z VSS cap_mim_2f0_m4m5_noshield c_width=5u c_length=5u
X297 z VSS cap_mim_2f0_m4m5_noshield c_width=5u c_length=5u
X298 z VSS cap_mim_2f0_m4m5_noshield c_width=5u c_length=5u
X299 z VSS cap_mim_2f0_m4m5_noshield c_width=5u c_length=5u
X300 z VSS cap_mim_2f0_m4m5_noshield c_width=5u c_length=5u
X301 z VSS cap_mim_2f0_m4m5_noshield c_width=5u c_length=5u
X302 z VSS cap_mim_2f0_m4m5_noshield c_width=5u c_length=5u
X303 z VSS cap_mim_2f0_m4m5_noshield c_width=5u c_length=5u
X304 z VSS cap_mim_2f0_m4m5_noshield c_width=5u c_length=5u
X305 z VSS cap_mim_2f0_m4m5_noshield c_width=5u c_length=5u
X306 z VSS cap_mim_2f0_m4m5_noshield c_width=5u c_length=5u
X307 z VSS cap_mim_2f0_m4m5_noshield c_width=5u c_length=5u
X308 z VSS cap_mim_2f0_m4m5_noshield c_width=5u c_length=5u
X309 z VSS cap_mim_2f0_m4m5_noshield c_width=5u c_length=5u
X310 z VSS cap_mim_2f0_m4m5_noshield c_width=5u c_length=5u
X311 z VSS cap_mim_2f0_m4m5_noshield c_width=5u c_length=5u
X312 z VSS cap_mim_2f0_m4m5_noshield c_width=5u c_length=5u
X313 z VSS cap_mim_2f0_m4m5_noshield c_width=5u c_length=5u
X314 z VSS cap_mim_2f0_m4m5_noshield c_width=5u c_length=5u
X315 z VSS cap_mim_2f0_m4m5_noshield c_width=5u c_length=5u
X316 z VSS cap_mim_2f0_m4m5_noshield c_width=5u c_length=5u
X317 z VSS cap_mim_2f0_m4m5_noshield c_width=5u c_length=5u
X318 z VSS cap_mim_2f0_m4m5_noshield c_width=5u c_length=5u
X319 z VSS cap_mim_2f0_m4m5_noshield c_width=5u c_length=5u
X320 z VSS cap_mim_2f0_m4m5_noshield c_width=5u c_length=5u
X321 z VSS cap_mim_2f0_m4m5_noshield c_width=5u c_length=5u
X322 z VSS cap_mim_2f0_m4m5_noshield c_width=5u c_length=5u
X323 z VSS cap_mim_2f0_m4m5_noshield c_width=5u c_length=5u
X324 z VSS cap_mim_2f0_m4m5_noshield c_width=5u c_length=5u
X325 z VSS cap_mim_2f0_m4m5_noshield c_width=5u c_length=5u
X326 z VSS cap_mim_2f0_m4m5_noshield c_width=5u c_length=5u
X327 z VSS cap_mim_2f0_m4m5_noshield c_width=5u c_length=5u
X328 z VSS cap_mim_2f0_m4m5_noshield c_width=5u c_length=5u
X329 z VSS cap_mim_2f0_m4m5_noshield c_width=5u c_length=5u
X330 z VSS cap_mim_2f0_m4m5_noshield c_width=5u c_length=5u
X331 z VSS cap_mim_2f0_m4m5_noshield c_width=5u c_length=5u
X332 z VSS cap_mim_2f0_m4m5_noshield c_width=5u c_length=5u
X333 z VSS cap_mim_2f0_m4m5_noshield c_width=5u c_length=5u
X334 z VSS cap_mim_2f0_m4m5_noshield c_width=5u c_length=5u
X335 z VSS cap_mim_2f0_m4m5_noshield c_width=5u c_length=5u
X336 z VSS cap_mim_2f0_m4m5_noshield c_width=5u c_length=5u
X337 z VSS cap_mim_2f0_m4m5_noshield c_width=5u c_length=5u
X338 z VSS cap_mim_2f0_m4m5_noshield c_width=5u c_length=5u
X339 z VSS cap_mim_2f0_m4m5_noshield c_width=5u c_length=5u
X340 z VSS cap_mim_2f0_m4m5_noshield c_width=5u c_length=5u
X341 z VSS cap_mim_2f0_m4m5_noshield c_width=5u c_length=5u
X342 z VSS cap_mim_2f0_m4m5_noshield c_width=5u c_length=5u
X343 z VSS cap_mim_2f0_m4m5_noshield c_width=5u c_length=5u
X344 z VSS cap_mim_2f0_m4m5_noshield c_width=5u c_length=5u
X345 z VSS cap_mim_2f0_m4m5_noshield c_width=5u c_length=5u
X346 z VSS cap_mim_2f0_m4m5_noshield c_width=5u c_length=5u
X347 z VSS cap_mim_2f0_m4m5_noshield c_width=5u c_length=5u
X348 z VSS cap_mim_2f0_m4m5_noshield c_width=5u c_length=5u
X349 z VSS cap_mim_2f0_m4m5_noshield c_width=5u c_length=5u
X350 z VSS cap_mim_2f0_m4m5_noshield c_width=5u c_length=5u
X351 z VSS cap_mim_2f0_m4m5_noshield c_width=5u c_length=5u
X352 z VSS cap_mim_2f0_m4m5_noshield c_width=5u c_length=5u
X353 z VSS cap_mim_2f0_m4m5_noshield c_width=5u c_length=5u
X354 z VSS cap_mim_2f0_m4m5_noshield c_width=5u c_length=5u
X355 z VSS cap_mim_2f0_m4m5_noshield c_width=5u c_length=5u
X356 z VSS cap_mim_2f0_m4m5_noshield c_width=5u c_length=5u
X357 z VSS cap_mim_2f0_m4m5_noshield c_width=5u c_length=5u
X358 z VSS cap_mim_2f0_m4m5_noshield c_width=5u c_length=5u
X359 z VSS cap_mim_2f0_m4m5_noshield c_width=5u c_length=5u
X360 z VSS cap_mim_2f0_m4m5_noshield c_width=5u c_length=5u
X361 z VSS cap_mim_2f0_m4m5_noshield c_width=5u c_length=5u
X362 z VSS cap_mim_2f0_m4m5_noshield c_width=5u c_length=5u
X363 z VSS cap_mim_2f0_m4m5_noshield c_width=5u c_length=5u
X364 z VSS cap_mim_2f0_m4m5_noshield c_width=5u c_length=5u
X365 z VSS cap_mim_2f0_m4m5_noshield c_width=5u c_length=5u
X366 z VSS cap_mim_2f0_m4m5_noshield c_width=5u c_length=5u
X367 z VSS cap_mim_2f0_m4m5_noshield c_width=5u c_length=5u
X368 z VSS cap_mim_2f0_m4m5_noshield c_width=5u c_length=5u
X369 z VSS cap_mim_2f0_m4m5_noshield c_width=5u c_length=5u
X370 z VSS cap_mim_2f0_m4m5_noshield c_width=5u c_length=5u
X371 z VSS cap_mim_2f0_m4m5_noshield c_width=5u c_length=5u
X372 z VSS cap_mim_2f0_m4m5_noshield c_width=5u c_length=5u
X373 z VSS cap_mim_2f0_m4m5_noshield c_width=5u c_length=5u
X374 z VSS cap_mim_2f0_m4m5_noshield c_width=5u c_length=5u
X375 z VSS cap_mim_2f0_m4m5_noshield c_width=5u c_length=5u
X376 z VSS cap_mim_2f0_m4m5_noshield c_width=5u c_length=5u
X377 z VSS cap_mim_2f0_m4m5_noshield c_width=5u c_length=5u
X378 z VSS cap_mim_2f0_m4m5_noshield c_width=5u c_length=5u
X379 z VSS cap_mim_2f0_m4m5_noshield c_width=5u c_length=5u
X380 z VSS cap_mim_2f0_m4m5_noshield c_width=5u c_length=5u
X381 z VSS cap_mim_2f0_m4m5_noshield c_width=5u c_length=5u
X382 z VSS cap_mim_2f0_m4m5_noshield c_width=5u c_length=5u
X383 z VSS cap_mim_2f0_m4m5_noshield c_width=5u c_length=5u
X384 z VSS cap_mim_2f0_m4m5_noshield c_width=5u c_length=5u
X385 z VSS cap_mim_2f0_m4m5_noshield c_width=5u c_length=5u
X386 z VSS cap_mim_2f0_m4m5_noshield c_width=5u c_length=5u
X387 z VSS cap_mim_2f0_m4m5_noshield c_width=5u c_length=5u
X388 z VSS cap_mim_2f0_m4m5_noshield c_width=5u c_length=5u
X389 z VSS cap_mim_2f0_m4m5_noshield c_width=5u c_length=5u
X390 z VSS cap_mim_2f0_m4m5_noshield c_width=5u c_length=5u
X391 z VSS cap_mim_2f0_m4m5_noshield c_width=5u c_length=5u
X392 z VSS cap_mim_2f0_m4m5_noshield c_width=5u c_length=5u
X393 z VSS cap_mim_2f0_m4m5_noshield c_width=5u c_length=5u
X394 z VSS cap_mim_2f0_m4m5_noshield c_width=5u c_length=5u
X395 z VSS cap_mim_2f0_m4m5_noshield c_width=5u c_length=5u
X396 z VSS cap_mim_2f0_m4m5_noshield c_width=5u c_length=5u
X397 z VSS cap_mim_2f0_m4m5_noshield c_width=5u c_length=5u
X398 z VSS cap_mim_2f0_m4m5_noshield c_width=5u c_length=5u
X399 z VSS cap_mim_2f0_m4m5_noshield c_width=5u c_length=5u
X400 z VSS cap_mim_2f0_m4m5_noshield c_width=5u c_length=5u
X401 z VSS cap_mim_2f0_m4m5_noshield c_width=5u c_length=5u
X402 z VSS cap_mim_2f0_m4m5_noshield c_width=5u c_length=5u
X403 z VSS cap_mim_2f0_m4m5_noshield c_width=5u c_length=5u
X404 z VSS cap_mim_2f0_m4m5_noshield c_width=5u c_length=5u
X405 z VSS cap_mim_2f0_m4m5_noshield c_width=5u c_length=5u
X406 z VSS cap_mim_2f0_m4m5_noshield c_width=5u c_length=5u
X407 z VSS cap_mim_2f0_m4m5_noshield c_width=5u c_length=5u
X408 z VSS cap_mim_2f0_m4m5_noshield c_width=5u c_length=5u
X409 z VSS cap_mim_2f0_m4m5_noshield c_width=5u c_length=5u
X410 z VSS cap_mim_2f0_m4m5_noshield c_width=5u c_length=5u
X411 z VSS cap_mim_2f0_m4m5_noshield c_width=5u c_length=5u
X412 z VSS cap_mim_2f0_m4m5_noshield c_width=5u c_length=5u
X413 z VSS cap_mim_2f0_m4m5_noshield c_width=5u c_length=5u
X414 z VSS cap_mim_2f0_m4m5_noshield c_width=5u c_length=5u
X415 z VSS cap_mim_2f0_m4m5_noshield c_width=5u c_length=5u
X416 z VSS cap_mim_2f0_m4m5_noshield c_width=5u c_length=5u
X417 z VSS cap_mim_2f0_m4m5_noshield c_width=5u c_length=5u
X418 z VSS cap_mim_2f0_m4m5_noshield c_width=5u c_length=5u
X419 z VSS cap_mim_2f0_m4m5_noshield c_width=5u c_length=5u
X420 z VSS cap_mim_2f0_m4m5_noshield c_width=5u c_length=5u
X421 z VSS cap_mim_2f0_m4m5_noshield c_width=5u c_length=5u
X422 z VSS cap_mim_2f0_m4m5_noshield c_width=5u c_length=5u
X423 z VSS cap_mim_2f0_m4m5_noshield c_width=5u c_length=5u
X424 z VSS cap_mim_2f0_m4m5_noshield c_width=5u c_length=5u
X425 z VSS cap_mim_2f0_m4m5_noshield c_width=5u c_length=5u
X426 z VSS cap_mim_2f0_m4m5_noshield c_width=5u c_length=5u
X427 z VSS cap_mim_2f0_m4m5_noshield c_width=5u c_length=5u
X428 z VSS cap_mim_2f0_m4m5_noshield c_width=5u c_length=5u
X429 z VSS cap_mim_2f0_m4m5_noshield c_width=5u c_length=5u
X430 z VSS cap_mim_2f0_m4m5_noshield c_width=5u c_length=5u
X431 z VSS cap_mim_2f0_m4m5_noshield c_width=5u c_length=5u
X432 z VSS cap_mim_2f0_m4m5_noshield c_width=5u c_length=5u
X433 z VSS cap_mim_2f0_m4m5_noshield c_width=5u c_length=5u
X434 z VSS cap_mim_2f0_m4m5_noshield c_width=5u c_length=5u
X435 z VSS cap_mim_2f0_m4m5_noshield c_width=5u c_length=5u
X436 z VSS cap_mim_2f0_m4m5_noshield c_width=5u c_length=5u
X437 z VSS cap_mim_2f0_m4m5_noshield c_width=5u c_length=5u
X438 z VSS cap_mim_2f0_m4m5_noshield c_width=5u c_length=5u
X439 z VSS cap_mim_2f0_m4m5_noshield c_width=5u c_length=5u
X440 z VSS cap_mim_2f0_m4m5_noshield c_width=5u c_length=5u
X441 z VSS cap_mim_2f0_m4m5_noshield c_width=5u c_length=5u
X442 z VSS cap_mim_2f0_m4m5_noshield c_width=5u c_length=5u
X443 z VSS cap_mim_2f0_m4m5_noshield c_width=5u c_length=5u
X444 z VSS cap_mim_2f0_m4m5_noshield c_width=5u c_length=5u
X445 z VSS cap_mim_2f0_m4m5_noshield c_width=5u c_length=5u
X446 z VSS cap_mim_2f0_m4m5_noshield c_width=5u c_length=5u
X447 z VSS cap_mim_2f0_m4m5_noshield c_width=5u c_length=5u
X448 z VSS cap_mim_2f0_m4m5_noshield c_width=5u c_length=5u
X449 z VSS cap_mim_2f0_m4m5_noshield c_width=5u c_length=5u
X450 z VSS cap_mim_2f0_m4m5_noshield c_width=5u c_length=5u
X451 z VSS cap_mim_2f0_m4m5_noshield c_width=5u c_length=5u
X452 z VSS cap_mim_2f0_m4m5_noshield c_width=5u c_length=5u
X453 z VSS cap_mim_2f0_m4m5_noshield c_width=5u c_length=5u
X454 z VSS cap_mim_2f0_m4m5_noshield c_width=5u c_length=5u
X455 z VSS cap_mim_2f0_m4m5_noshield c_width=5u c_length=5u
X456 z VSS cap_mim_2f0_m4m5_noshield c_width=5u c_length=5u
X457 z VSS cap_mim_2f0_m4m5_noshield c_width=5u c_length=5u
X458 z VSS cap_mim_2f0_m4m5_noshield c_width=5u c_length=5u
X459 z VSS cap_mim_2f0_m4m5_noshield c_width=5u c_length=5u
X460 z VSS cap_mim_2f0_m4m5_noshield c_width=5u c_length=5u
X461 z VSS cap_mim_2f0_m4m5_noshield c_width=5u c_length=5u
X462 z VSS cap_mim_2f0_m4m5_noshield c_width=5u c_length=5u
X463 z VSS cap_mim_2f0_m4m5_noshield c_width=5u c_length=5u
X464 z VSS cap_mim_2f0_m4m5_noshield c_width=5u c_length=5u
X465 z VSS cap_mim_2f0_m4m5_noshield c_width=5u c_length=5u
X466 z VSS cap_mim_2f0_m4m5_noshield c_width=5u c_length=5u
X467 z VSS cap_mim_2f0_m4m5_noshield c_width=5u c_length=5u
X468 z VSS cap_mim_2f0_m4m5_noshield c_width=5u c_length=5u
X469 z VSS cap_mim_2f0_m4m5_noshield c_width=5u c_length=5u
X470 z VSS cap_mim_2f0_m4m5_noshield c_width=5u c_length=5u
X471 z VSS cap_mim_2f0_m4m5_noshield c_width=5u c_length=5u
X472 z VSS cap_mim_2f0_m4m5_noshield c_width=5u c_length=5u
X473 z VSS cap_mim_2f0_m4m5_noshield c_width=5u c_length=5u
X474 z VSS cap_mim_2f0_m4m5_noshield c_width=5u c_length=5u
X475 z VSS cap_mim_2f0_m4m5_noshield c_width=5u c_length=5u
X476 z VSS cap_mim_2f0_m4m5_noshield c_width=5u c_length=5u
X477 z VSS cap_mim_2f0_m4m5_noshield c_width=5u c_length=5u
X478 z VSS cap_mim_2f0_m4m5_noshield c_width=5u c_length=5u
X479 z VSS cap_mim_2f0_m4m5_noshield c_width=5u c_length=5u
X480 z VSS cap_mim_2f0_m4m5_noshield c_width=5u c_length=5u
X481 z VSS cap_mim_2f0_m4m5_noshield c_width=5u c_length=5u
X482 z VSS cap_mim_2f0_m4m5_noshield c_width=5u c_length=5u
X483 z VSS cap_mim_2f0_m4m5_noshield c_width=5u c_length=5u
X484 z VSS cap_mim_2f0_m4m5_noshield c_width=5u c_length=5u
X485 z VSS cap_mim_2f0_m4m5_noshield c_width=5u c_length=5u
X486 z VSS cap_mim_2f0_m4m5_noshield c_width=5u c_length=5u
X487 z VSS cap_mim_2f0_m4m5_noshield c_width=5u c_length=5u
X488 z VSS cap_mim_2f0_m4m5_noshield c_width=5u c_length=5u
X489 z VSS cap_mim_2f0_m4m5_noshield c_width=5u c_length=5u
X490 z VSS cap_mim_2f0_m4m5_noshield c_width=5u c_length=5u
X491 z VSS cap_mim_2f0_m4m5_noshield c_width=5u c_length=5u
X492 z VSS cap_mim_2f0_m4m5_noshield c_width=5u c_length=5u
X493 z VSS cap_mim_2f0_m4m5_noshield c_width=5u c_length=5u
X494 z VSS cap_mim_2f0_m4m5_noshield c_width=5u c_length=5u
X495 z VSS cap_mim_2f0_m4m5_noshield c_width=5u c_length=5u
X496 z VSS cap_mim_2f0_m4m5_noshield c_width=5u c_length=5u
X497 z VSS cap_mim_2f0_m4m5_noshield c_width=5u c_length=5u
X498 z VSS cap_mim_2f0_m4m5_noshield c_width=5u c_length=5u
X499 z VSS cap_mim_2f0_m4m5_noshield c_width=5u c_length=5u
X500 z VSS cap_mim_2f0_m4m5_noshield c_width=5u c_length=5u
X501 z VSS cap_mim_2f0_m4m5_noshield c_width=5u c_length=5u
X502 z VSS cap_mim_2f0_m4m5_noshield c_width=5u c_length=5u
X503 z VSS cap_mim_2f0_m4m5_noshield c_width=5u c_length=5u
X504 z VSS cap_mim_2f0_m4m5_noshield c_width=5u c_length=5u
X505 z VSS cap_mim_2f0_m4m5_noshield c_width=5u c_length=5u
X506 z VSS cap_mim_2f0_m4m5_noshield c_width=5u c_length=5u
X507 z VSS cap_mim_2f0_m4m5_noshield c_width=5u c_length=5u
X508 z VSS cap_mim_2f0_m4m5_noshield c_width=5u c_length=5u
X509 z VSS cap_mim_2f0_m4m5_noshield c_width=5u c_length=5u
X510 z VSS cap_mim_2f0_m4m5_noshield c_width=5u c_length=5u
X511 z VSS cap_mim_2f0_m4m5_noshield c_width=5u c_length=5u
X512 z VSS cap_mim_2f0_m4m5_noshield c_width=5u c_length=5u
X513 z VSS cap_mim_2f0_m4m5_noshield c_width=5u c_length=5u
X514 z VSS cap_mim_2f0_m4m5_noshield c_width=5u c_length=5u
X515 z VSS cap_mim_2f0_m4m5_noshield c_width=5u c_length=5u
X516 z VSS cap_mim_2f0_m4m5_noshield c_width=5u c_length=5u
X517 z VSS cap_mim_2f0_m4m5_noshield c_width=5u c_length=5u
X518 z VSS cap_mim_2f0_m4m5_noshield c_width=5u c_length=5u
X519 z VSS cap_mim_2f0_m4m5_noshield c_width=5u c_length=5u
X520 z VSS cap_mim_2f0_m4m5_noshield c_width=5u c_length=5u
X521 z VSS cap_mim_2f0_m4m5_noshield c_width=5u c_length=5u
X522 z VSS cap_mim_2f0_m4m5_noshield c_width=5u c_length=5u
X523 z VSS cap_mim_2f0_m4m5_noshield c_width=5u c_length=5u
X524 z VSS cap_mim_2f0_m4m5_noshield c_width=5u c_length=5u
X525 z VSS cap_mim_2f0_m4m5_noshield c_width=5u c_length=5u
X526 z VSS cap_mim_2f0_m4m5_noshield c_width=5u c_length=5u
X527 z VSS cap_mim_2f0_m4m5_noshield c_width=5u c_length=5u
X528 z VSS cap_mim_2f0_m4m5_noshield c_width=5u c_length=5u
X529 z VSS cap_mim_2f0_m4m5_noshield c_width=5u c_length=5u
X530 z VSS cap_mim_2f0_m4m5_noshield c_width=5u c_length=5u
X531 z VSS cap_mim_2f0_m4m5_noshield c_width=5u c_length=5u
X532 z VSS cap_mim_2f0_m4m5_noshield c_width=5u c_length=5u
X533 z VSS cap_mim_2f0_m4m5_noshield c_width=5u c_length=5u
X534 z VSS cap_mim_2f0_m4m5_noshield c_width=5u c_length=5u
X535 z VSS cap_mim_2f0_m4m5_noshield c_width=5u c_length=5u
X536 z VSS cap_mim_2f0_m4m5_noshield c_width=5u c_length=5u
X537 z VSS cap_mim_2f0_m4m5_noshield c_width=5u c_length=5u
X538 z VSS cap_mim_2f0_m4m5_noshield c_width=5u c_length=5u
X539 z VSS cap_mim_2f0_m4m5_noshield c_width=5u c_length=5u
X540 z VSS cap_mim_2f0_m4m5_noshield c_width=5u c_length=5u
X541 z VSS cap_mim_2f0_m4m5_noshield c_width=5u c_length=5u
X542 z VSS cap_mim_2f0_m4m5_noshield c_width=5u c_length=5u
X543 z VSS cap_mim_2f0_m4m5_noshield c_width=5u c_length=5u
X544 z VSS cap_mim_2f0_m4m5_noshield c_width=5u c_length=5u
X545 z VSS cap_mim_2f0_m4m5_noshield c_width=5u c_length=5u
X546 z VSS cap_mim_2f0_m4m5_noshield c_width=5u c_length=5u
X547 z VSS cap_mim_2f0_m4m5_noshield c_width=5u c_length=5u
X548 z VSS cap_mim_2f0_m4m5_noshield c_width=5u c_length=5u
X549 z VSS cap_mim_2f0_m4m5_noshield c_width=5u c_length=5u
X550 z VSS cap_mim_2f0_m4m5_noshield c_width=5u c_length=5u
X551 z VSS cap_mim_2f0_m4m5_noshield c_width=5u c_length=5u
X552 z VSS cap_mim_2f0_m4m5_noshield c_width=5u c_length=5u
X553 z VSS cap_mim_2f0_m4m5_noshield c_width=5u c_length=5u
X554 z VSS cap_mim_2f0_m4m5_noshield c_width=5u c_length=5u
X555 z VSS cap_mim_2f0_m4m5_noshield c_width=5u c_length=5u
X556 z VSS cap_mim_2f0_m4m5_noshield c_width=5u c_length=5u
X557 z VSS cap_mim_2f0_m4m5_noshield c_width=5u c_length=5u
X558 z VSS cap_mim_2f0_m4m5_noshield c_width=5u c_length=5u
X559 z VSS cap_mim_2f0_m4m5_noshield c_width=5u c_length=5u
X560 z VSS cap_mim_2f0_m4m5_noshield c_width=5u c_length=5u
X561 z VSS cap_mim_2f0_m4m5_noshield c_width=5u c_length=5u
X562 z VSS cap_mim_2f0_m4m5_noshield c_width=5u c_length=5u
X563 z VSS cap_mim_2f0_m4m5_noshield c_width=5u c_length=5u
X564 z VSS cap_mim_2f0_m4m5_noshield c_width=5u c_length=5u
X565 z VSS cap_mim_2f0_m4m5_noshield c_width=5u c_length=5u
X566 z VSS cap_mim_2f0_m4m5_noshield c_width=5u c_length=5u
X567 z VSS cap_mim_2f0_m4m5_noshield c_width=5u c_length=5u
X568 z VSS cap_mim_2f0_m4m5_noshield c_width=5u c_length=5u
X569 z VSS cap_mim_2f0_m4m5_noshield c_width=5u c_length=5u
X570 z VSS cap_mim_2f0_m4m5_noshield c_width=5u c_length=5u
X571 z VSS cap_mim_2f0_m4m5_noshield c_width=5u c_length=5u
X572 z VSS cap_mim_2f0_m4m5_noshield c_width=5u c_length=5u
X573 z VSS cap_mim_2f0_m4m5_noshield c_width=5u c_length=5u
X574 z VSS cap_mim_2f0_m4m5_noshield c_width=5u c_length=5u
X575 z VSS cap_mim_2f0_m4m5_noshield c_width=5u c_length=5u
X576 z VSS cap_mim_2f0_m4m5_noshield c_width=5u c_length=5u
X577 z VSS cap_mim_2f0_m4m5_noshield c_width=5u c_length=5u
X578 z VSS cap_mim_2f0_m4m5_noshield c_width=5u c_length=5u
X579 z VSS cap_mim_2f0_m4m5_noshield c_width=5u c_length=5u
X580 z VSS cap_mim_2f0_m4m5_noshield c_width=5u c_length=5u
X581 z VSS cap_mim_2f0_m4m5_noshield c_width=5u c_length=5u
X582 z VSS cap_mim_2f0_m4m5_noshield c_width=5u c_length=5u
X583 z VSS cap_mim_2f0_m4m5_noshield c_width=5u c_length=5u
X584 z VSS cap_mim_2f0_m4m5_noshield c_width=5u c_length=5u
X585 z VSS cap_mim_2f0_m4m5_noshield c_width=5u c_length=5u
X586 z VSS cap_mim_2f0_m4m5_noshield c_width=5u c_length=5u
X587 z VSS cap_mim_2f0_m4m5_noshield c_width=5u c_length=5u
X588 z VSS cap_mim_2f0_m4m5_noshield c_width=5u c_length=5u
X589 z VSS cap_mim_2f0_m4m5_noshield c_width=5u c_length=5u
X590 z VSS cap_mim_2f0_m4m5_noshield c_width=5u c_length=5u
X591 z VSS cap_mim_2f0_m4m5_noshield c_width=5u c_length=5u
X592 z VSS cap_mim_2f0_m4m5_noshield c_width=5u c_length=5u
X593 z VSS cap_mim_2f0_m4m5_noshield c_width=5u c_length=5u
X594 z VSS cap_mim_2f0_m4m5_noshield c_width=5u c_length=5u
X595 z VSS cap_mim_2f0_m4m5_noshield c_width=5u c_length=5u
X596 z VSS cap_mim_2f0_m4m5_noshield c_width=5u c_length=5u
X597 z VSS cap_mim_2f0_m4m5_noshield c_width=5u c_length=5u
X598 z VSS cap_mim_2f0_m4m5_noshield c_width=5u c_length=5u
X599 z VSS cap_mim_2f0_m4m5_noshield c_width=5u c_length=5u
X600 z VSS cap_mim_2f0_m4m5_noshield c_width=5u c_length=5u
X601 z VSS cap_mim_2f0_m4m5_noshield c_width=5u c_length=5u
X602 z VSS cap_mim_2f0_m4m5_noshield c_width=5u c_length=5u
X603 z VSS cap_mim_2f0_m4m5_noshield c_width=5u c_length=5u
X604 z VSS cap_mim_2f0_m4m5_noshield c_width=5u c_length=5u
X605 z VSS cap_mim_2f0_m4m5_noshield c_width=5u c_length=5u
X606 z VSS cap_mim_2f0_m4m5_noshield c_width=5u c_length=5u
X607 z VSS cap_mim_2f0_m4m5_noshield c_width=5u c_length=5u
X608 z VSS cap_mim_2f0_m4m5_noshield c_width=5u c_length=5u
X609 z VSS cap_mim_2f0_m4m5_noshield c_width=5u c_length=5u
X610 z VSS cap_mim_2f0_m4m5_noshield c_width=5u c_length=5u
X611 z VSS cap_mim_2f0_m4m5_noshield c_width=5u c_length=5u
X612 z VSS cap_mim_2f0_m4m5_noshield c_width=5u c_length=5u
X613 z VSS cap_mim_2f0_m4m5_noshield c_width=5u c_length=5u
X614 z VSS cap_mim_2f0_m4m5_noshield c_width=5u c_length=5u
X615 z VSS cap_mim_2f0_m4m5_noshield c_width=5u c_length=5u
X616 z VSS cap_mim_2f0_m4m5_noshield c_width=5u c_length=5u
X617 z VSS cap_mim_2f0_m4m5_noshield c_width=5u c_length=5u
X618 z VSS cap_mim_2f0_m4m5_noshield c_width=5u c_length=5u
X619 z VSS cap_mim_2f0_m4m5_noshield c_width=5u c_length=5u
X620 z VSS cap_mim_2f0_m4m5_noshield c_width=5u c_length=5u
X621 z VSS cap_mim_2f0_m4m5_noshield c_width=5u c_length=5u
X622 z VSS cap_mim_2f0_m4m5_noshield c_width=5u c_length=5u
X623 z VSS cap_mim_2f0_m4m5_noshield c_width=5u c_length=5u
X624 z VSS cap_mim_2f0_m4m5_noshield c_width=5u c_length=5u
X625 z VSS cap_mim_2f0_m4m5_noshield c_width=5u c_length=5u
X626 z VSS cap_mim_2f0_m4m5_noshield c_width=5u c_length=5u
X627 z VSS cap_mim_2f0_m4m5_noshield c_width=5u c_length=5u
X628 z VSS cap_mim_2f0_m4m5_noshield c_width=5u c_length=5u
X629 z VSS cap_mim_2f0_m4m5_noshield c_width=5u c_length=5u
X630 z VSS cap_mim_2f0_m4m5_noshield c_width=5u c_length=5u
X631 z VSS cap_mim_2f0_m4m5_noshield c_width=5u c_length=5u
X632 z VSS cap_mim_2f0_m4m5_noshield c_width=5u c_length=5u
X633 z VSS cap_mim_2f0_m4m5_noshield c_width=5u c_length=5u
X634 z VSS cap_mim_2f0_m4m5_noshield c_width=5u c_length=5u
X635 z VSS cap_mim_2f0_m4m5_noshield c_width=5u c_length=5u
X636 z VSS cap_mim_2f0_m4m5_noshield c_width=5u c_length=5u
X637 z VSS cap_mim_2f0_m4m5_noshield c_width=5u c_length=5u
X638 z VSS cap_mim_2f0_m4m5_noshield c_width=5u c_length=5u
X639 z VSS cap_mim_2f0_m4m5_noshield c_width=5u c_length=5u
X640 z VSS cap_mim_2f0_m4m5_noshield c_width=5u c_length=5u
X641 z VSS cap_mim_2f0_m4m5_noshield c_width=5u c_length=5u
X642 z VSS cap_mim_2f0_m4m5_noshield c_width=5u c_length=5u
X643 z VSS cap_mim_2f0_m4m5_noshield c_width=5u c_length=5u
X644 z VSS cap_mim_2f0_m4m5_noshield c_width=5u c_length=5u
X645 z VSS cap_mim_2f0_m4m5_noshield c_width=5u c_length=5u
X646 z VSS cap_mim_2f0_m4m5_noshield c_width=5u c_length=5u
X647 z VSS cap_mim_2f0_m4m5_noshield c_width=5u c_length=5u
X648 z VSS cap_mim_2f0_m4m5_noshield c_width=5u c_length=5u
X649 z VSS cap_mim_2f0_m4m5_noshield c_width=5u c_length=5u
X650 z VSS cap_mim_2f0_m4m5_noshield c_width=5u c_length=5u
X651 z VSS cap_mim_2f0_m4m5_noshield c_width=5u c_length=5u
X652 z VSS cap_mim_2f0_m4m5_noshield c_width=5u c_length=5u
X653 z VSS cap_mim_2f0_m4m5_noshield c_width=5u c_length=5u
X654 z VSS cap_mim_2f0_m4m5_noshield c_width=5u c_length=5u
X655 z VSS cap_mim_2f0_m4m5_noshield c_width=5u c_length=5u
X656 z VSS cap_mim_2f0_m4m5_noshield c_width=5u c_length=5u
X657 z VSS cap_mim_2f0_m4m5_noshield c_width=5u c_length=5u
X658 z VSS cap_mim_2f0_m4m5_noshield c_width=5u c_length=5u
X659 z VSS cap_mim_2f0_m4m5_noshield c_width=5u c_length=5u
X660 z VSS cap_mim_2f0_m4m5_noshield c_width=5u c_length=5u
X661 z VSS cap_mim_2f0_m4m5_noshield c_width=5u c_length=5u
X662 z VSS cap_mim_2f0_m4m5_noshield c_width=5u c_length=5u
X663 z VSS cap_mim_2f0_m4m5_noshield c_width=5u c_length=5u
X664 z VSS cap_mim_2f0_m4m5_noshield c_width=5u c_length=5u
X665 z VSS cap_mim_2f0_m4m5_noshield c_width=5u c_length=5u
X666 z VSS cap_mim_2f0_m4m5_noshield c_width=5u c_length=5u
X667 z VSS cap_mim_2f0_m4m5_noshield c_width=5u c_length=5u
X668 z VSS cap_mim_2f0_m4m5_noshield c_width=5u c_length=5u
X669 z VSS cap_mim_2f0_m4m5_noshield c_width=5u c_length=5u
X670 z VSS cap_mim_2f0_m4m5_noshield c_width=5u c_length=5u
X671 z VSS cap_mim_2f0_m4m5_noshield c_width=5u c_length=5u
X672 z VSS cap_mim_2f0_m4m5_noshield c_width=5u c_length=5u
X673 z VSS cap_mim_2f0_m4m5_noshield c_width=5u c_length=5u
X674 z VSS cap_mim_2f0_m4m5_noshield c_width=5u c_length=5u
X675 z VSS cap_mim_2f0_m4m5_noshield c_width=5u c_length=5u
X676 z VSS cap_mim_2f0_m4m5_noshield c_width=5u c_length=5u
X677 z VSS cap_mim_2f0_m4m5_noshield c_width=5u c_length=5u
X678 z VSS cap_mim_2f0_m4m5_noshield c_width=5u c_length=5u
X679 z VSS cap_mim_2f0_m4m5_noshield c_width=5u c_length=5u
X680 z VSS cap_mim_2f0_m4m5_noshield c_width=5u c_length=5u
X681 z VSS cap_mim_2f0_m4m5_noshield c_width=5u c_length=5u
X682 z VSS cap_mim_2f0_m4m5_noshield c_width=5u c_length=5u
X683 z VSS cap_mim_2f0_m4m5_noshield c_width=5u c_length=5u
X684 z VSS cap_mim_2f0_m4m5_noshield c_width=5u c_length=5u
X685 z VSS cap_mim_2f0_m4m5_noshield c_width=5u c_length=5u
X686 z VSS cap_mim_2f0_m4m5_noshield c_width=5u c_length=5u
X687 z VSS cap_mim_2f0_m4m5_noshield c_width=5u c_length=5u
X688 z VSS cap_mim_2f0_m4m5_noshield c_width=5u c_length=5u
X689 z VSS cap_mim_2f0_m4m5_noshield c_width=5u c_length=5u
X690 z VSS cap_mim_2f0_m4m5_noshield c_width=5u c_length=5u
X691 z VSS cap_mim_2f0_m4m5_noshield c_width=5u c_length=5u
X692 z VSS cap_mim_2f0_m4m5_noshield c_width=5u c_length=5u
X693 z VSS cap_mim_2f0_m4m5_noshield c_width=5u c_length=5u
X694 z VSS cap_mim_2f0_m4m5_noshield c_width=5u c_length=5u
X695 z VSS cap_mim_2f0_m4m5_noshield c_width=5u c_length=5u
X696 z VSS cap_mim_2f0_m4m5_noshield c_width=5u c_length=5u
X697 z VSS cap_mim_2f0_m4m5_noshield c_width=5u c_length=5u
X698 z VSS cap_mim_2f0_m4m5_noshield c_width=5u c_length=5u
X699 z VSS cap_mim_2f0_m4m5_noshield c_width=5u c_length=5u
X700 z VSS cap_mim_2f0_m4m5_noshield c_width=5u c_length=5u
X701 z VSS cap_mim_2f0_m4m5_noshield c_width=5u c_length=5u
X702 z VSS cap_mim_2f0_m4m5_noshield c_width=5u c_length=5u
X703 z VSS cap_mim_2f0_m4m5_noshield c_width=5u c_length=5u
X704 z VSS cap_mim_2f0_m4m5_noshield c_width=5u c_length=5u
X705 z VSS cap_mim_2f0_m4m5_noshield c_width=5u c_length=5u
X706 z VSS cap_mim_2f0_m4m5_noshield c_width=5u c_length=5u
X707 z VSS cap_mim_2f0_m4m5_noshield c_width=5u c_length=5u
X708 z VSS cap_mim_2f0_m4m5_noshield c_width=5u c_length=5u
X709 z VSS cap_mim_2f0_m4m5_noshield c_width=5u c_length=5u
X710 z VSS cap_mim_2f0_m4m5_noshield c_width=5u c_length=5u
X711 z VSS cap_mim_2f0_m4m5_noshield c_width=5u c_length=5u
X712 z VSS cap_mim_2f0_m4m5_noshield c_width=5u c_length=5u
X713 z VSS cap_mim_2f0_m4m5_noshield c_width=5u c_length=5u
X714 z VSS cap_mim_2f0_m4m5_noshield c_width=5u c_length=5u
X715 z VSS cap_mim_2f0_m4m5_noshield c_width=5u c_length=5u
X716 z VSS cap_mim_2f0_m4m5_noshield c_width=5u c_length=5u
X717 z VSS cap_mim_2f0_m4m5_noshield c_width=5u c_length=5u
X718 z VSS cap_mim_2f0_m4m5_noshield c_width=5u c_length=5u
X719 z VSS cap_mim_2f0_m4m5_noshield c_width=5u c_length=5u
X720 z VSS cap_mim_2f0_m4m5_noshield c_width=5u c_length=5u
X721 z VSS cap_mim_2f0_m4m5_noshield c_width=5u c_length=5u
X722 z VSS cap_mim_2f0_m4m5_noshield c_width=5u c_length=5u
X723 z VSS cap_mim_2f0_m4m5_noshield c_width=5u c_length=5u
X724 z VSS cap_mim_2f0_m4m5_noshield c_width=5u c_length=5u
X725 z VSS cap_mim_2f0_m4m5_noshield c_width=5u c_length=5u
X726 z VSS cap_mim_2f0_m4m5_noshield c_width=5u c_length=5u
X727 z VSS cap_mim_2f0_m4m5_noshield c_width=5u c_length=5u
X728 z VSS cap_mim_2f0_m4m5_noshield c_width=5u c_length=5u
X729 z VSS cap_mim_2f0_m4m5_noshield c_width=5u c_length=5u
X730 z VSS cap_mim_2f0_m4m5_noshield c_width=5u c_length=5u
X731 z VSS cap_mim_2f0_m4m5_noshield c_width=5u c_length=5u
X732 z VSS cap_mim_2f0_m4m5_noshield c_width=5u c_length=5u
X733 z VSS cap_mim_2f0_m4m5_noshield c_width=5u c_length=5u
X734 z VSS cap_mim_2f0_m4m5_noshield c_width=5u c_length=5u
X735 z VSS cap_mim_2f0_m4m5_noshield c_width=5u c_length=5u
X736 z VSS cap_mim_2f0_m4m5_noshield c_width=5u c_length=5u
X737 z VSS cap_mim_2f0_m4m5_noshield c_width=5u c_length=5u
X738 z VSS cap_mim_2f0_m4m5_noshield c_width=5u c_length=5u
X739 z VSS cap_mim_2f0_m4m5_noshield c_width=5u c_length=5u
X740 z VSS cap_mim_2f0_m4m5_noshield c_width=5u c_length=5u
X741 z VSS cap_mim_2f0_m4m5_noshield c_width=5u c_length=5u
X742 z VSS cap_mim_2f0_m4m5_noshield c_width=5u c_length=5u
X743 z VSS cap_mim_2f0_m4m5_noshield c_width=5u c_length=5u
X744 z VSS cap_mim_2f0_m4m5_noshield c_width=5u c_length=5u
X745 z VSS cap_mim_2f0_m4m5_noshield c_width=5u c_length=5u
X746 z VSS cap_mim_2f0_m4m5_noshield c_width=5u c_length=5u
X747 z VSS cap_mim_2f0_m4m5_noshield c_width=5u c_length=5u
X748 z VSS cap_mim_2f0_m4m5_noshield c_width=5u c_length=5u
X749 z VSS cap_mim_2f0_m4m5_noshield c_width=5u c_length=5u
X750 z VSS cap_mim_2f0_m4m5_noshield c_width=5u c_length=5u
X751 z VSS cap_mim_2f0_m4m5_noshield c_width=5u c_length=5u
X752 z VSS cap_mim_2f0_m4m5_noshield c_width=5u c_length=5u
X753 z VSS cap_mim_2f0_m4m5_noshield c_width=5u c_length=5u
X754 z VSS cap_mim_2f0_m4m5_noshield c_width=5u c_length=5u
X755 z VSS cap_mim_2f0_m4m5_noshield c_width=5u c_length=5u
X756 z VSS cap_mim_2f0_m4m5_noshield c_width=5u c_length=5u
X757 z VSS cap_mim_2f0_m4m5_noshield c_width=5u c_length=5u
X758 z VSS cap_mim_2f0_m4m5_noshield c_width=5u c_length=5u
X759 z VSS cap_mim_2f0_m4m5_noshield c_width=5u c_length=5u
X760 z VSS cap_mim_2f0_m4m5_noshield c_width=5u c_length=5u
X761 z VSS cap_mim_2f0_m4m5_noshield c_width=5u c_length=5u
X762 z VSS cap_mim_2f0_m4m5_noshield c_width=5u c_length=5u
X763 z VSS cap_mim_2f0_m4m5_noshield c_width=5u c_length=5u
X764 z VSS cap_mim_2f0_m4m5_noshield c_width=5u c_length=5u
X765 z VSS cap_mim_2f0_m4m5_noshield c_width=5u c_length=5u
X766 z VSS cap_mim_2f0_m4m5_noshield c_width=5u c_length=5u
X767 z VSS cap_mim_2f0_m4m5_noshield c_width=5u c_length=5u
X768 z VSS cap_mim_2f0_m4m5_noshield c_width=5u c_length=5u
X769 z VSS cap_mim_2f0_m4m5_noshield c_width=5u c_length=5u
X770 z VSS cap_mim_2f0_m4m5_noshield c_width=5u c_length=5u
X771 z VSS cap_mim_2f0_m4m5_noshield c_width=5u c_length=5u
X772 z VSS cap_mim_2f0_m4m5_noshield c_width=5u c_length=5u
X773 z VSS cap_mim_2f0_m4m5_noshield c_width=5u c_length=5u
X774 z VSS cap_mim_2f0_m4m5_noshield c_width=5u c_length=5u
X775 z VSS cap_mim_2f0_m4m5_noshield c_width=5u c_length=5u
X776 z VSS cap_mim_2f0_m4m5_noshield c_width=5u c_length=5u
X777 z VSS cap_mim_2f0_m4m5_noshield c_width=5u c_length=5u
X778 z VSS cap_mim_2f0_m4m5_noshield c_width=5u c_length=5u
X779 z VSS cap_mim_2f0_m4m5_noshield c_width=5u c_length=5u
X780 z VSS cap_mim_2f0_m4m5_noshield c_width=5u c_length=5u
X781 z VSS cap_mim_2f0_m4m5_noshield c_width=5u c_length=5u
X782 z VSS cap_mim_2f0_m4m5_noshield c_width=5u c_length=5u
X783 z VSS cap_mim_2f0_m4m5_noshield c_width=5u c_length=5u
X784 z VSS cap_mim_2f0_m4m5_noshield c_width=5u c_length=5u
X785 z VSS cap_mim_2f0_m4m5_noshield c_width=5u c_length=5u
X786 z VSS cap_mim_2f0_m4m5_noshield c_width=5u c_length=5u
X787 z VSS cap_mim_2f0_m4m5_noshield c_width=5u c_length=5u
X788 z VSS cap_mim_2f0_m4m5_noshield c_width=5u c_length=5u
X789 z VSS cap_mim_2f0_m4m5_noshield c_width=5u c_length=5u
X790 z VSS cap_mim_2f0_m4m5_noshield c_width=5u c_length=5u
X791 z VSS cap_mim_2f0_m4m5_noshield c_width=5u c_length=5u
X792 z VSS cap_mim_2f0_m4m5_noshield c_width=5u c_length=5u
X793 z VSS cap_mim_2f0_m4m5_noshield c_width=5u c_length=5u
X794 z VSS cap_mim_2f0_m4m5_noshield c_width=5u c_length=5u
X795 z VSS cap_mim_2f0_m4m5_noshield c_width=5u c_length=5u
X796 z VSS cap_mim_2f0_m4m5_noshield c_width=5u c_length=5u
X797 z VSS cap_mim_2f0_m4m5_noshield c_width=5u c_length=5u
X798 z VSS cap_mim_2f0_m4m5_noshield c_width=5u c_length=5u
X799 z VSS cap_mim_2f0_m4m5_noshield c_width=5u c_length=5u
X800 z VSS cap_mim_2f0_m4m5_noshield c_width=5u c_length=5u
X801 z VSS cap_mim_2f0_m4m5_noshield c_width=5u c_length=5u
X802 z VSS cap_mim_2f0_m4m5_noshield c_width=5u c_length=5u
X803 z VSS cap_mim_2f0_m4m5_noshield c_width=5u c_length=5u
X804 z VSS cap_mim_2f0_m4m5_noshield c_width=5u c_length=5u
X805 z VSS cap_mim_2f0_m4m5_noshield c_width=5u c_length=5u
X806 z VSS cap_mim_2f0_m4m5_noshield c_width=5u c_length=5u
X807 z VSS cap_mim_2f0_m4m5_noshield c_width=5u c_length=5u
X808 z VSS cap_mim_2f0_m4m5_noshield c_width=5u c_length=5u
X809 z VSS cap_mim_2f0_m4m5_noshield c_width=5u c_length=5u
X810 z VSS cap_mim_2f0_m4m5_noshield c_width=5u c_length=5u
X811 z VSS cap_mim_2f0_m4m5_noshield c_width=5u c_length=5u
X812 z VSS cap_mim_2f0_m4m5_noshield c_width=5u c_length=5u
X813 z VSS cap_mim_2f0_m4m5_noshield c_width=5u c_length=5u
X814 z VSS cap_mim_2f0_m4m5_noshield c_width=5u c_length=5u
X815 z VSS cap_mim_2f0_m4m5_noshield c_width=5u c_length=5u
X816 z VSS cap_mim_2f0_m4m5_noshield c_width=5u c_length=5u
X817 z VSS cap_mim_2f0_m4m5_noshield c_width=5u c_length=5u
X818 z VSS cap_mim_2f0_m4m5_noshield c_width=5u c_length=5u
X819 z VSS cap_mim_2f0_m4m5_noshield c_width=5u c_length=5u
X820 z VSS cap_mim_2f0_m4m5_noshield c_width=5u c_length=5u
X821 z VSS cap_mim_2f0_m4m5_noshield c_width=5u c_length=5u
X822 z VSS cap_mim_2f0_m4m5_noshield c_width=5u c_length=5u
X823 z VSS cap_mim_2f0_m4m5_noshield c_width=5u c_length=5u
X824 z VSS cap_mim_2f0_m4m5_noshield c_width=5u c_length=5u
X825 z VSS cap_mim_2f0_m4m5_noshield c_width=5u c_length=5u
X826 z VSS cap_mim_2f0_m4m5_noshield c_width=5u c_length=5u
X827 z VSS cap_mim_2f0_m4m5_noshield c_width=5u c_length=5u
X828 z VSS cap_mim_2f0_m4m5_noshield c_width=5u c_length=5u
X829 z VSS cap_mim_2f0_m4m5_noshield c_width=5u c_length=5u
X830 z VSS cap_mim_2f0_m4m5_noshield c_width=5u c_length=5u
X831 z VSS cap_mim_2f0_m4m5_noshield c_width=5u c_length=5u
X832 z VSS cap_mim_2f0_m4m5_noshield c_width=5u c_length=5u
X833 z VSS cap_mim_2f0_m4m5_noshield c_width=5u c_length=5u
X834 z VSS cap_mim_2f0_m4m5_noshield c_width=5u c_length=5u
X835 z VSS cap_mim_2f0_m4m5_noshield c_width=5u c_length=5u
X836 z VSS cap_mim_2f0_m4m5_noshield c_width=5u c_length=5u
X837 z VSS cap_mim_2f0_m4m5_noshield c_width=5u c_length=5u
X838 z VSS cap_mim_2f0_m4m5_noshield c_width=5u c_length=5u
X839 z VSS cap_mim_2f0_m4m5_noshield c_width=5u c_length=5u
X840 z VSS cap_mim_2f0_m4m5_noshield c_width=5u c_length=5u
X841 z VSS cap_mim_2f0_m4m5_noshield c_width=5u c_length=5u
X842 z VSS cap_mim_2f0_m4m5_noshield c_width=5u c_length=5u
X843 z VSS cap_mim_2f0_m4m5_noshield c_width=5u c_length=5u
X844 z VSS cap_mim_2f0_m4m5_noshield c_width=5u c_length=5u
X845 z VSS cap_mim_2f0_m4m5_noshield c_width=5u c_length=5u
X846 z VSS cap_mim_2f0_m4m5_noshield c_width=5u c_length=5u
X847 z VSS cap_mim_2f0_m4m5_noshield c_width=5u c_length=5u
X848 z VSS cap_mim_2f0_m4m5_noshield c_width=5u c_length=5u
X849 z VSS cap_mim_2f0_m4m5_noshield c_width=5u c_length=5u
X850 z VSS cap_mim_2f0_m4m5_noshield c_width=5u c_length=5u
X851 z VSS cap_mim_2f0_m4m5_noshield c_width=5u c_length=5u
X852 z VSS cap_mim_2f0_m4m5_noshield c_width=5u c_length=5u
X853 z VSS cap_mim_2f0_m4m5_noshield c_width=5u c_length=5u
X854 z VSS cap_mim_2f0_m4m5_noshield c_width=5u c_length=5u
X855 z VSS cap_mim_2f0_m4m5_noshield c_width=5u c_length=5u
X856 z VSS cap_mim_2f0_m4m5_noshield c_width=5u c_length=5u
X857 z VSS cap_mim_2f0_m4m5_noshield c_width=5u c_length=5u
X858 z VSS cap_mim_2f0_m4m5_noshield c_width=5u c_length=5u
X859 z VSS cap_mim_2f0_m4m5_noshield c_width=5u c_length=5u
X860 z VSS cap_mim_2f0_m4m5_noshield c_width=5u c_length=5u
X861 z VSS cap_mim_2f0_m4m5_noshield c_width=5u c_length=5u
X862 z VSS cap_mim_2f0_m4m5_noshield c_width=5u c_length=5u
X863 z VSS cap_mim_2f0_m4m5_noshield c_width=5u c_length=5u
X864 z VSS cap_mim_2f0_m4m5_noshield c_width=5u c_length=5u
X865 z VSS cap_mim_2f0_m4m5_noshield c_width=5u c_length=5u
X866 z VSS cap_mim_2f0_m4m5_noshield c_width=5u c_length=5u
X867 z VSS cap_mim_2f0_m4m5_noshield c_width=5u c_length=5u
X868 z VSS cap_mim_2f0_m4m5_noshield c_width=5u c_length=5u
X869 z VSS cap_mim_2f0_m4m5_noshield c_width=5u c_length=5u
X870 z VSS cap_mim_2f0_m4m5_noshield c_width=5u c_length=5u
X871 z VSS cap_mim_2f0_m4m5_noshield c_width=5u c_length=5u
X872 z VSS cap_mim_2f0_m4m5_noshield c_width=5u c_length=5u
X873 z VSS cap_mim_2f0_m4m5_noshield c_width=5u c_length=5u
X874 z VSS cap_mim_2f0_m4m5_noshield c_width=5u c_length=5u
X875 z VSS cap_mim_2f0_m4m5_noshield c_width=5u c_length=5u
X876 z VSS cap_mim_2f0_m4m5_noshield c_width=5u c_length=5u
X877 z VSS cap_mim_2f0_m4m5_noshield c_width=5u c_length=5u
X878 z VSS cap_mim_2f0_m4m5_noshield c_width=5u c_length=5u
X879 z VSS cap_mim_2f0_m4m5_noshield c_width=5u c_length=5u
X880 z VSS cap_mim_2f0_m4m5_noshield c_width=5u c_length=5u
X881 z VSS cap_mim_2f0_m4m5_noshield c_width=5u c_length=5u
X882 z VSS cap_mim_2f0_m4m5_noshield c_width=5u c_length=5u
X883 z VSS cap_mim_2f0_m4m5_noshield c_width=5u c_length=5u
X884 z VSS cap_mim_2f0_m4m5_noshield c_width=5u c_length=5u
X885 z VSS cap_mim_2f0_m4m5_noshield c_width=5u c_length=5u
X886 z VSS cap_mim_2f0_m4m5_noshield c_width=5u c_length=5u
X887 z VSS cap_mim_2f0_m4m5_noshield c_width=5u c_length=5u
X888 z VSS cap_mim_2f0_m4m5_noshield c_width=5u c_length=5u
X889 z VSS cap_mim_2f0_m4m5_noshield c_width=5u c_length=5u
X890 z VSS cap_mim_2f0_m4m5_noshield c_width=5u c_length=5u
X891 z VSS cap_mim_2f0_m4m5_noshield c_width=5u c_length=5u
X892 z VSS cap_mim_2f0_m4m5_noshield c_width=5u c_length=5u
X893 z VSS cap_mim_2f0_m4m5_noshield c_width=5u c_length=5u
X894 z VSS cap_mim_2f0_m4m5_noshield c_width=5u c_length=5u
X895 z VSS cap_mim_2f0_m4m5_noshield c_width=5u c_length=5u
X896 z VSS cap_mim_2f0_m4m5_noshield c_width=5u c_length=5u
X897 z VSS cap_mim_2f0_m4m5_noshield c_width=5u c_length=5u
X898 z VSS cap_mim_2f0_m4m5_noshield c_width=5u c_length=5u
X899 z VSS cap_mim_2f0_m4m5_noshield c_width=5u c_length=5u
X900 z VSS cap_mim_2f0_m4m5_noshield c_width=5u c_length=5u
X901 z VSS cap_mim_2f0_m4m5_noshield c_width=5u c_length=5u
X902 z VSS cap_mim_2f0_m4m5_noshield c_width=5u c_length=5u
X903 z VSS cap_mim_2f0_m4m5_noshield c_width=5u c_length=5u
X904 z VSS cap_mim_2f0_m4m5_noshield c_width=5u c_length=5u
X905 z VSS cap_mim_2f0_m4m5_noshield c_width=5u c_length=5u
X906 z VSS cap_mim_2f0_m4m5_noshield c_width=5u c_length=5u
X907 z VSS cap_mim_2f0_m4m5_noshield c_width=5u c_length=5u
X908 z VSS cap_mim_2f0_m4m5_noshield c_width=5u c_length=5u
X909 z VSS cap_mim_2f0_m4m5_noshield c_width=5u c_length=5u
X910 z VSS cap_mim_2f0_m4m5_noshield c_width=5u c_length=5u
X911 z VSS cap_mim_2f0_m4m5_noshield c_width=5u c_length=5u
X912 z VSS cap_mim_2f0_m4m5_noshield c_width=5u c_length=5u
X913 z VSS cap_mim_2f0_m4m5_noshield c_width=5u c_length=5u
X914 z VSS cap_mim_2f0_m4m5_noshield c_width=5u c_length=5u
X915 z VSS cap_mim_2f0_m4m5_noshield c_width=5u c_length=5u
X916 z VSS cap_mim_2f0_m4m5_noshield c_width=5u c_length=5u
X917 z VSS cap_mim_2f0_m4m5_noshield c_width=5u c_length=5u
X918 z VSS cap_mim_2f0_m4m5_noshield c_width=5u c_length=5u
X919 z VSS cap_mim_2f0_m4m5_noshield c_width=5u c_length=5u
X920 z VSS cap_mim_2f0_m4m5_noshield c_width=5u c_length=5u
X921 z VSS cap_mim_2f0_m4m5_noshield c_width=5u c_length=5u
X922 z VSS cap_mim_2f0_m4m5_noshield c_width=5u c_length=5u
X923 z VSS cap_mim_2f0_m4m5_noshield c_width=5u c_length=5u
X924 z VSS cap_mim_2f0_m4m5_noshield c_width=5u c_length=5u
X925 z VSS cap_mim_2f0_m4m5_noshield c_width=5u c_length=5u
X926 z VSS cap_mim_2f0_m4m5_noshield c_width=5u c_length=5u
X927 z VSS cap_mim_2f0_m4m5_noshield c_width=5u c_length=5u
X928 z VSS cap_mim_2f0_m4m5_noshield c_width=5u c_length=5u
X929 z VSS cap_mim_2f0_m4m5_noshield c_width=5u c_length=5u
X930 z VSS cap_mim_2f0_m4m5_noshield c_width=5u c_length=5u
X931 z VSS cap_mim_2f0_m4m5_noshield c_width=5u c_length=5u
X932 z VSS cap_mim_2f0_m4m5_noshield c_width=5u c_length=5u
X933 z VSS cap_mim_2f0_m4m5_noshield c_width=5u c_length=5u
X934 z VSS cap_mim_2f0_m4m5_noshield c_width=5u c_length=5u
X935 z VSS cap_mim_2f0_m4m5_noshield c_width=5u c_length=5u
X936 z VSS cap_mim_2f0_m4m5_noshield c_width=5u c_length=5u
X937 z VSS cap_mim_2f0_m4m5_noshield c_width=5u c_length=5u
X938 z VSS cap_mim_2f0_m4m5_noshield c_width=5u c_length=5u
X939 z VSS cap_mim_2f0_m4m5_noshield c_width=5u c_length=5u
X940 z VSS cap_mim_2f0_m4m5_noshield c_width=5u c_length=5u
X941 z VSS cap_mim_2f0_m4m5_noshield c_width=5u c_length=5u
X942 z VSS cap_mim_2f0_m4m5_noshield c_width=5u c_length=5u
X943 z VSS cap_mim_2f0_m4m5_noshield c_width=5u c_length=5u
X944 z VSS cap_mim_2f0_m4m5_noshield c_width=5u c_length=5u
X945 z VSS cap_mim_2f0_m4m5_noshield c_width=5u c_length=5u
X946 z VSS cap_mim_2f0_m4m5_noshield c_width=5u c_length=5u
X947 z VSS cap_mim_2f0_m4m5_noshield c_width=5u c_length=5u
X948 z VSS cap_mim_2f0_m4m5_noshield c_width=5u c_length=5u
X949 z VSS cap_mim_2f0_m4m5_noshield c_width=5u c_length=5u
X950 z VSS cap_mim_2f0_m4m5_noshield c_width=5u c_length=5u
X951 z VSS cap_mim_2f0_m4m5_noshield c_width=5u c_length=5u
X952 z VSS cap_mim_2f0_m4m5_noshield c_width=5u c_length=5u
X953 z VSS cap_mim_2f0_m4m5_noshield c_width=5u c_length=5u
X954 z VSS cap_mim_2f0_m4m5_noshield c_width=5u c_length=5u
X955 z VSS cap_mim_2f0_m4m5_noshield c_width=5u c_length=5u
X956 z VSS cap_mim_2f0_m4m5_noshield c_width=5u c_length=5u
X957 z VSS cap_mim_2f0_m4m5_noshield c_width=5u c_length=5u
X958 z VSS cap_mim_2f0_m4m5_noshield c_width=5u c_length=5u
X959 z VSS cap_mim_2f0_m4m5_noshield c_width=5u c_length=5u
X960 z VSS cap_mim_2f0_m4m5_noshield c_width=5u c_length=5u
X961 z VSS cap_mim_2f0_m4m5_noshield c_width=5u c_length=5u
X962 z VSS cap_mim_2f0_m4m5_noshield c_width=5u c_length=5u
X963 z VSS cap_mim_2f0_m4m5_noshield c_width=5u c_length=5u
X964 z VSS cap_mim_2f0_m4m5_noshield c_width=5u c_length=5u
X965 z VSS cap_mim_2f0_m4m5_noshield c_width=5u c_length=5u
X966 z VSS cap_mim_2f0_m4m5_noshield c_width=5u c_length=5u
X967 z VSS cap_mim_2f0_m4m5_noshield c_width=5u c_length=5u
X968 z VSS cap_mim_2f0_m4m5_noshield c_width=5u c_length=5u
X969 z VSS cap_mim_2f0_m4m5_noshield c_width=5u c_length=5u
X970 z VSS cap_mim_2f0_m4m5_noshield c_width=5u c_length=5u
X971 z VSS cap_mim_2f0_m4m5_noshield c_width=5u c_length=5u
X972 z VSS cap_mim_2f0_m4m5_noshield c_width=5u c_length=5u
X973 z VSS cap_mim_2f0_m4m5_noshield c_width=5u c_length=5u
X974 z VSS cap_mim_2f0_m4m5_noshield c_width=5u c_length=5u
X975 z VSS cap_mim_2f0_m4m5_noshield c_width=5u c_length=5u
X976 z VSS cap_mim_2f0_m4m5_noshield c_width=5u c_length=5u
X977 z VSS cap_mim_2f0_m4m5_noshield c_width=5u c_length=5u
X978 z VSS cap_mim_2f0_m4m5_noshield c_width=5u c_length=5u
X979 z VSS cap_mim_2f0_m4m5_noshield c_width=5u c_length=5u
X980 z VSS cap_mim_2f0_m4m5_noshield c_width=5u c_length=5u
X981 z VSS cap_mim_2f0_m4m5_noshield c_width=5u c_length=5u
X982 z VSS cap_mim_2f0_m4m5_noshield c_width=5u c_length=5u
X983 z VSS cap_mim_2f0_m4m5_noshield c_width=5u c_length=5u
X984 z VSS cap_mim_2f0_m4m5_noshield c_width=5u c_length=5u
X985 z VSS cap_mim_2f0_m4m5_noshield c_width=5u c_length=5u
X986 z VSS cap_mim_2f0_m4m5_noshield c_width=5u c_length=5u
X987 z VSS cap_mim_2f0_m4m5_noshield c_width=5u c_length=5u
X988 z VSS cap_mim_2f0_m4m5_noshield c_width=5u c_length=5u
X989 z VSS cap_mim_2f0_m4m5_noshield c_width=5u c_length=5u
X990 z VSS cap_mim_2f0_m4m5_noshield c_width=5u c_length=5u
X991 z VSS cap_mim_2f0_m4m5_noshield c_width=5u c_length=5u
X992 z VSS cap_mim_2f0_m4m5_noshield c_width=5u c_length=5u
X993 z VSS cap_mim_2f0_m4m5_noshield c_width=5u c_length=5u
X994 z VSS cap_mim_2f0_m4m5_noshield c_width=5u c_length=5u
X995 z VSS cap_mim_2f0_m4m5_noshield c_width=5u c_length=5u
X996 z VSS cap_mim_2f0_m4m5_noshield c_width=5u c_length=5u
X997 z VSS cap_mim_2f0_m4m5_noshield c_width=5u c_length=5u
X998 z VSS cap_mim_2f0_m4m5_noshield c_width=5u c_length=5u
X999 z VSS cap_mim_2f0_m4m5_noshield c_width=5u c_length=5u
X1000 z VSS cap_mim_2f0_m4m5_noshield c_width=5u c_length=5u
X1001 z VSS cap_mim_2f0_m4m5_noshield c_width=5u c_length=5u
X1002 z VSS cap_mim_2f0_m4m5_noshield c_width=5u c_length=5u
X1003 z VSS cap_mim_2f0_m4m5_noshield c_width=5u c_length=5u
X1004 z VSS cap_mim_2f0_m4m5_noshield c_width=5u c_length=5u
X1005 z VSS cap_mim_2f0_m4m5_noshield c_width=5u c_length=5u
X1006 z VSS cap_mim_2f0_m4m5_noshield c_width=5u c_length=5u
X1007 z VSS cap_mim_2f0_m4m5_noshield c_width=5u c_length=5u
X1008 z VSS cap_mim_2f0_m4m5_noshield c_width=5u c_length=5u
X1009 z VSS cap_mim_2f0_m4m5_noshield c_width=5u c_length=5u
X1010 z VSS cap_mim_2f0_m4m5_noshield c_width=5u c_length=5u
X1011 z VSS cap_mim_2f0_m4m5_noshield c_width=5u c_length=5u
X1012 z VSS cap_mim_2f0_m4m5_noshield c_width=5u c_length=5u
X1013 z VSS cap_mim_2f0_m4m5_noshield c_width=5u c_length=5u
X1014 z VSS cap_mim_2f0_m4m5_noshield c_width=5u c_length=5u
X1015 z VSS cap_mim_2f0_m4m5_noshield c_width=5u c_length=5u
X1016 z VSS cap_mim_2f0_m4m5_noshield c_width=5u c_length=5u
X1017 z VSS cap_mim_2f0_m4m5_noshield c_width=5u c_length=5u
X1018 z VSS cap_mim_2f0_m4m5_noshield c_width=5u c_length=5u
X1019 z VSS cap_mim_2f0_m4m5_noshield c_width=5u c_length=5u
X1020 z VSS cap_mim_2f0_m4m5_noshield c_width=5u c_length=5u
X1021 z VSS cap_mim_2f0_m4m5_noshield c_width=5u c_length=5u
X1022 z VSS cap_mim_2f0_m4m5_noshield c_width=5u c_length=5u
X1023 z VSS cap_mim_2f0_m4m5_noshield c_width=5u c_length=5u
X1024 z VSS cap_mim_2f0_m4m5_noshield c_width=5u c_length=5u
X1025 z VSS cap_mim_2f0_m4m5_noshield c_width=5u c_length=5u
X1026 z VSS cap_mim_2f0_m4m5_noshield c_width=5u c_length=5u
X1027 z VSS cap_mim_2f0_m4m5_noshield c_width=5u c_length=5u
X1028 z VSS cap_mim_2f0_m4m5_noshield c_width=5u c_length=5u
X1029 z VSS cap_mim_2f0_m4m5_noshield c_width=5u c_length=5u
X1030 z VSS cap_mim_2f0_m4m5_noshield c_width=5u c_length=5u
X1031 z VSS cap_mim_2f0_m4m5_noshield c_width=5u c_length=5u
X1032 z VSS cap_mim_2f0_m4m5_noshield c_width=5u c_length=5u
X1033 z VSS cap_mim_2f0_m4m5_noshield c_width=5u c_length=5u
X1034 z VSS cap_mim_2f0_m4m5_noshield c_width=5u c_length=5u
X1035 z VSS cap_mim_2f0_m4m5_noshield c_width=5u c_length=5u
X1036 z VSS cap_mim_2f0_m4m5_noshield c_width=5u c_length=5u
X1037 z VSS cap_mim_2f0_m4m5_noshield c_width=5u c_length=5u
X1038 z VSS cap_mim_2f0_m4m5_noshield c_width=5u c_length=5u
X1039 z VSS cap_mim_2f0_m4m5_noshield c_width=5u c_length=5u
X1040 z VSS cap_mim_2f0_m4m5_noshield c_width=5u c_length=5u
X1041 z VSS cap_mim_2f0_m4m5_noshield c_width=5u c_length=5u
X1042 z VSS cap_mim_2f0_m4m5_noshield c_width=5u c_length=5u
X1043 z VSS cap_mim_2f0_m4m5_noshield c_width=5u c_length=5u
X1044 z VSS cap_mim_2f0_m4m5_noshield c_width=5u c_length=5u
X1045 z VSS cap_mim_2f0_m4m5_noshield c_width=5u c_length=5u
X1046 z VSS cap_mim_2f0_m4m5_noshield c_width=5u c_length=5u
X1047 z VSS cap_mim_2f0_m4m5_noshield c_width=5u c_length=5u
X1048 z VSS cap_mim_2f0_m4m5_noshield c_width=5u c_length=5u
X1049 z VSS cap_mim_2f0_m4m5_noshield c_width=5u c_length=5u
X1050 z VSS cap_mim_2f0_m4m5_noshield c_width=5u c_length=5u
X1051 z VSS cap_mim_2f0_m4m5_noshield c_width=5u c_length=5u
X1052 z VSS cap_mim_2f0_m4m5_noshield c_width=5u c_length=5u
X1053 z VSS cap_mim_2f0_m4m5_noshield c_width=5u c_length=5u
X1054 z VSS cap_mim_2f0_m4m5_noshield c_width=5u c_length=5u
X1055 z VSS cap_mim_2f0_m4m5_noshield c_width=5u c_length=5u
X1056 z VSS cap_mim_2f0_m4m5_noshield c_width=5u c_length=5u
X1057 z VSS cap_mim_2f0_m4m5_noshield c_width=5u c_length=5u
X1058 z VSS cap_mim_2f0_m4m5_noshield c_width=5u c_length=5u
X1059 z VSS cap_mim_2f0_m4m5_noshield c_width=5u c_length=5u
X1060 z VSS cap_mim_2f0_m4m5_noshield c_width=5u c_length=5u
X1061 z VSS cap_mim_2f0_m4m5_noshield c_width=5u c_length=5u
X1062 z VSS cap_mim_2f0_m4m5_noshield c_width=5u c_length=5u
X1063 z VSS cap_mim_2f0_m4m5_noshield c_width=5u c_length=5u
X1064 z VSS cap_mim_2f0_m4m5_noshield c_width=5u c_length=5u
X1065 z VSS cap_mim_2f0_m4m5_noshield c_width=5u c_length=5u
X1066 z VSS cap_mim_2f0_m4m5_noshield c_width=5u c_length=5u
X1067 z VSS cap_mim_2f0_m4m5_noshield c_width=5u c_length=5u
X1068 z VSS cap_mim_2f0_m4m5_noshield c_width=5u c_length=5u
X1069 z VSS cap_mim_2f0_m4m5_noshield c_width=5u c_length=5u
X1070 z VSS cap_mim_2f0_m4m5_noshield c_width=5u c_length=5u
X1071 z VSS cap_mim_2f0_m4m5_noshield c_width=5u c_length=5u
X1072 z VSS cap_mim_2f0_m4m5_noshield c_width=5u c_length=5u
X1073 z VSS cap_mim_2f0_m4m5_noshield c_width=5u c_length=5u
X1074 z VSS cap_mim_2f0_m4m5_noshield c_width=5u c_length=5u
X1075 z VSS cap_mim_2f0_m4m5_noshield c_width=5u c_length=5u
X1076 z VSS cap_mim_2f0_m4m5_noshield c_width=5u c_length=5u
X1077 z VSS cap_mim_2f0_m4m5_noshield c_width=5u c_length=5u
X1078 z VSS cap_mim_2f0_m4m5_noshield c_width=5u c_length=5u
X1079 z VSS cap_mim_2f0_m4m5_noshield c_width=5u c_length=5u
X1080 z VSS cap_mim_2f0_m4m5_noshield c_width=5u c_length=5u
X1081 z VSS cap_mim_2f0_m4m5_noshield c_width=5u c_length=5u
X1082 z VSS cap_mim_2f0_m4m5_noshield c_width=5u c_length=5u
X1083 z VSS cap_mim_2f0_m4m5_noshield c_width=5u c_length=5u
X1084 z VSS cap_mim_2f0_m4m5_noshield c_width=5u c_length=5u
X1085 z VSS cap_mim_2f0_m4m5_noshield c_width=5u c_length=5u
X1086 z VSS cap_mim_2f0_m4m5_noshield c_width=5u c_length=5u
X1087 z VSS cap_mim_2f0_m4m5_noshield c_width=5u c_length=5u
X1088 z VSS cap_mim_2f0_m4m5_noshield c_width=5u c_length=5u
X1089 z VSS cap_mim_2f0_m4m5_noshield c_width=5u c_length=5u
X1090 z VSS cap_mim_2f0_m4m5_noshield c_width=5u c_length=5u
X1091 z VSS cap_mim_2f0_m4m5_noshield c_width=5u c_length=5u
X1092 z VSS cap_mim_2f0_m4m5_noshield c_width=5u c_length=5u
X1093 z VSS cap_mim_2f0_m4m5_noshield c_width=5u c_length=5u
X1094 z VSS cap_mim_2f0_m4m5_noshield c_width=5u c_length=5u
X1095 z VSS cap_mim_2f0_m4m5_noshield c_width=5u c_length=5u
X1096 z VSS cap_mim_2f0_m4m5_noshield c_width=5u c_length=5u
X1097 z VSS cap_mim_2f0_m4m5_noshield c_width=5u c_length=5u
X1098 z VSS cap_mim_2f0_m4m5_noshield c_width=5u c_length=5u
X1099 z VSS cap_mim_2f0_m4m5_noshield c_width=5u c_length=5u
X1100 z VSS cap_mim_2f0_m4m5_noshield c_width=5u c_length=5u
X1101 z VSS cap_mim_2f0_m4m5_noshield c_width=5u c_length=5u
X1102 z VSS cap_mim_2f0_m4m5_noshield c_width=5u c_length=5u
X1103 z VSS cap_mim_2f0_m4m5_noshield c_width=5u c_length=5u
X1104 z VSS cap_mim_2f0_m4m5_noshield c_width=5u c_length=5u
X1105 z VSS cap_mim_2f0_m4m5_noshield c_width=5u c_length=5u
X1106 z VSS cap_mim_2f0_m4m5_noshield c_width=5u c_length=5u
X1107 z VSS cap_mim_2f0_m4m5_noshield c_width=5u c_length=5u
X1108 z VSS cap_mim_2f0_m4m5_noshield c_width=5u c_length=5u
X1109 z VSS cap_mim_2f0_m4m5_noshield c_width=5u c_length=5u
X1110 z VSS cap_mim_2f0_m4m5_noshield c_width=5u c_length=5u
X1111 z VSS cap_mim_2f0_m4m5_noshield c_width=5u c_length=5u
X1112 z VSS cap_mim_2f0_m4m5_noshield c_width=5u c_length=5u
X1113 z VSS cap_mim_2f0_m4m5_noshield c_width=5u c_length=5u
X1114 z VSS cap_mim_2f0_m4m5_noshield c_width=5u c_length=5u
X1115 z VSS cap_mim_2f0_m4m5_noshield c_width=5u c_length=5u
X1116 z VSS cap_mim_2f0_m4m5_noshield c_width=5u c_length=5u
X1117 z VSS cap_mim_2f0_m4m5_noshield c_width=5u c_length=5u
X1118 z VSS cap_mim_2f0_m4m5_noshield c_width=5u c_length=5u
X1119 z VSS cap_mim_2f0_m4m5_noshield c_width=5u c_length=5u
X1120 z VSS cap_mim_2f0_m4m5_noshield c_width=5u c_length=5u
X1121 z VSS cap_mim_2f0_m4m5_noshield c_width=5u c_length=5u
X1122 z VSS cap_mim_2f0_m4m5_noshield c_width=5u c_length=5u
X1123 z VSS cap_mim_2f0_m4m5_noshield c_width=5u c_length=5u
X1124 z VSS cap_mim_2f0_m4m5_noshield c_width=5u c_length=5u
X1125 z VSS cap_mim_2f0_m4m5_noshield c_width=5u c_length=5u
X1126 z VSS cap_mim_2f0_m4m5_noshield c_width=5u c_length=5u
X1127 z VSS cap_mim_2f0_m4m5_noshield c_width=5u c_length=5u
X1128 z VSS cap_mim_2f0_m4m5_noshield c_width=5u c_length=5u
X1129 z VSS cap_mim_2f0_m4m5_noshield c_width=5u c_length=5u
X1130 z VSS cap_mim_2f0_m4m5_noshield c_width=5u c_length=5u
X1131 z VSS cap_mim_2f0_m4m5_noshield c_width=5u c_length=5u
X1132 z VSS cap_mim_2f0_m4m5_noshield c_width=5u c_length=5u
X1133 z VSS cap_mim_2f0_m4m5_noshield c_width=5u c_length=5u
X1134 z VSS cap_mim_2f0_m4m5_noshield c_width=5u c_length=5u
X1135 z VSS cap_mim_2f0_m4m5_noshield c_width=5u c_length=5u
X1136 z VSS cap_mim_2f0_m4m5_noshield c_width=5u c_length=5u
X1137 z VSS cap_mim_2f0_m4m5_noshield c_width=5u c_length=5u
X1138 z VSS cap_mim_2f0_m4m5_noshield c_width=5u c_length=5u
X1139 z VSS cap_mim_2f0_m4m5_noshield c_width=5u c_length=5u
X1140 z VSS cap_mim_2f0_m4m5_noshield c_width=5u c_length=5u
X1141 z VSS cap_mim_2f0_m4m5_noshield c_width=5u c_length=5u
X1142 z VSS cap_mim_2f0_m4m5_noshield c_width=5u c_length=5u
X1143 z VSS cap_mim_2f0_m4m5_noshield c_width=5u c_length=5u
X1144 z VSS cap_mim_2f0_m4m5_noshield c_width=5u c_length=5u
X1145 z VSS cap_mim_2f0_m4m5_noshield c_width=5u c_length=5u
X1146 z VSS cap_mim_2f0_m4m5_noshield c_width=5u c_length=5u
X1147 z VSS cap_mim_2f0_m4m5_noshield c_width=5u c_length=5u
X1148 z VSS cap_mim_2f0_m4m5_noshield c_width=5u c_length=5u
X1149 z VSS cap_mim_2f0_m4m5_noshield c_width=5u c_length=5u
X1150 z VSS cap_mim_2f0_m4m5_noshield c_width=5u c_length=5u
X1151 z VSS cap_mim_2f0_m4m5_noshield c_width=5u c_length=5u
X1152 z VSS cap_mim_2f0_m4m5_noshield c_width=5u c_length=5u
X1153 z VSS cap_mim_2f0_m4m5_noshield c_width=5u c_length=5u
X1154 z VSS cap_mim_2f0_m4m5_noshield c_width=5u c_length=5u
X1155 z VSS cap_mim_2f0_m4m5_noshield c_width=5u c_length=5u
X1156 z VSS cap_mim_2f0_m4m5_noshield c_width=5u c_length=5u
X1157 z VSS cap_mim_2f0_m4m5_noshield c_width=5u c_length=5u
X1158 z VSS cap_mim_2f0_m4m5_noshield c_width=5u c_length=5u
X1159 z VSS cap_mim_2f0_m4m5_noshield c_width=5u c_length=5u
X1160 z VSS cap_mim_2f0_m4m5_noshield c_width=5u c_length=5u
X1161 z VSS cap_mim_2f0_m4m5_noshield c_width=5u c_length=5u
X1162 z VSS cap_mim_2f0_m4m5_noshield c_width=5u c_length=5u
X1163 z VSS cap_mim_2f0_m4m5_noshield c_width=5u c_length=5u
X1164 z VSS cap_mim_2f0_m4m5_noshield c_width=5u c_length=5u
X1165 z VSS cap_mim_2f0_m4m5_noshield c_width=5u c_length=5u
X1166 z VSS cap_mim_2f0_m4m5_noshield c_width=5u c_length=5u
X1167 z VSS cap_mim_2f0_m4m5_noshield c_width=5u c_length=5u
X1168 z VSS cap_mim_2f0_m4m5_noshield c_width=5u c_length=5u
X1169 z VSS cap_mim_2f0_m4m5_noshield c_width=5u c_length=5u
X1170 z VSS cap_mim_2f0_m4m5_noshield c_width=5u c_length=5u
X1171 z VSS cap_mim_2f0_m4m5_noshield c_width=5u c_length=5u
X1172 z VSS cap_mim_2f0_m4m5_noshield c_width=5u c_length=5u
X1173 z VSS cap_mim_2f0_m4m5_noshield c_width=5u c_length=5u
X1174 z VSS cap_mim_2f0_m4m5_noshield c_width=5u c_length=5u
X1175 z VSS cap_mim_2f0_m4m5_noshield c_width=5u c_length=5u
X1176 z VSS cap_mim_2f0_m4m5_noshield c_width=5u c_length=5u
X1177 z VSS cap_mim_2f0_m4m5_noshield c_width=5u c_length=5u
X1178 z VSS cap_mim_2f0_m4m5_noshield c_width=5u c_length=5u
X1179 z VSS cap_mim_2f0_m4m5_noshield c_width=5u c_length=5u
X1180 z VSS cap_mim_2f0_m4m5_noshield c_width=5u c_length=5u
X1181 z VSS cap_mim_2f0_m4m5_noshield c_width=5u c_length=5u
X1182 z VSS cap_mim_2f0_m4m5_noshield c_width=5u c_length=5u
X1183 z VSS cap_mim_2f0_m4m5_noshield c_width=5u c_length=5u
X1184 z VSS cap_mim_2f0_m4m5_noshield c_width=5u c_length=5u
X1185 z VSS cap_mim_2f0_m4m5_noshield c_width=5u c_length=5u
X1186 z VSS cap_mim_2f0_m4m5_noshield c_width=5u c_length=5u
X1187 z VSS cap_mim_2f0_m4m5_noshield c_width=5u c_length=5u
X1188 z VSS cap_mim_2f0_m4m5_noshield c_width=5u c_length=5u
X1189 z VSS cap_mim_2f0_m4m5_noshield c_width=5u c_length=5u
X1190 z VSS cap_mim_2f0_m4m5_noshield c_width=5u c_length=5u
X1191 z VSS cap_mim_2f0_m4m5_noshield c_width=5u c_length=5u
X1192 z VSS cap_mim_2f0_m4m5_noshield c_width=5u c_length=5u
X1193 z VSS cap_mim_2f0_m4m5_noshield c_width=5u c_length=5u
X1194 z VSS cap_mim_2f0_m4m5_noshield c_width=5u c_length=5u
X1195 z VSS cap_mim_2f0_m4m5_noshield c_width=5u c_length=5u
X1196 z VSS cap_mim_2f0_m4m5_noshield c_width=5u c_length=5u
X1197 z VSS cap_mim_2f0_m4m5_noshield c_width=5u c_length=5u
X1198 z VSS cap_mim_2f0_m4m5_noshield c_width=5u c_length=5u
X1199 z VSS cap_mim_2f0_m4m5_noshield c_width=5u c_length=5u
X1200 z VSS cap_mim_2f0_m4m5_noshield c_width=5u c_length=5u
X1201 z VSS cap_mim_2f0_m4m5_noshield c_width=5u c_length=5u
X1202 z VSS cap_mim_2f0_m4m5_noshield c_width=5u c_length=5u
X1203 z VSS cap_mim_2f0_m4m5_noshield c_width=5u c_length=5u
X1204 z VSS cap_mim_2f0_m4m5_noshield c_width=5u c_length=5u
X1205 z VSS cap_mim_2f0_m4m5_noshield c_width=5u c_length=5u
X1206 z VSS cap_mim_2f0_m4m5_noshield c_width=5u c_length=5u
X1207 z VSS cap_mim_2f0_m4m5_noshield c_width=5u c_length=5u
X1208 z VSS cap_mim_2f0_m4m5_noshield c_width=5u c_length=5u
X1209 z VSS cap_mim_2f0_m4m5_noshield c_width=5u c_length=5u
X1210 z VSS cap_mim_2f0_m4m5_noshield c_width=5u c_length=5u
X1211 z VSS cap_mim_2f0_m4m5_noshield c_width=5u c_length=5u
X1212 z VSS cap_mim_2f0_m4m5_noshield c_width=5u c_length=5u
X1213 z VSS cap_mim_2f0_m4m5_noshield c_width=5u c_length=5u
X1214 z VSS cap_mim_2f0_m4m5_noshield c_width=5u c_length=5u
X1215 z VSS cap_mim_2f0_m4m5_noshield c_width=5u c_length=5u
X1216 z VSS cap_mim_2f0_m4m5_noshield c_width=5u c_length=5u
X1217 z VSS cap_mim_2f0_m4m5_noshield c_width=5u c_length=5u
X1218 z VSS cap_mim_2f0_m4m5_noshield c_width=5u c_length=5u
X1219 z VSS cap_mim_2f0_m4m5_noshield c_width=5u c_length=5u
X1220 z VSS cap_mim_2f0_m4m5_noshield c_width=5u c_length=5u
X1221 z VSS cap_mim_2f0_m4m5_noshield c_width=5u c_length=5u
X1222 z VSS cap_mim_2f0_m4m5_noshield c_width=5u c_length=5u
X1223 z VSS cap_mim_2f0_m4m5_noshield c_width=5u c_length=5u
X1224 z VSS cap_mim_2f0_m4m5_noshield c_width=5u c_length=5u
X1225 z VSS cap_mim_2f0_m4m5_noshield c_width=5u c_length=5u
X1226 z VSS cap_mim_2f0_m4m5_noshield c_width=5u c_length=5u
X1227 z VSS cap_mim_2f0_m4m5_noshield c_width=5u c_length=5u
X1228 z VSS cap_mim_2f0_m4m5_noshield c_width=5u c_length=5u
X1229 z VSS cap_mim_2f0_m4m5_noshield c_width=5u c_length=5u
X1230 z VSS cap_mim_2f0_m4m5_noshield c_width=5u c_length=5u
X1231 z VSS cap_mim_2f0_m4m5_noshield c_width=5u c_length=5u
X1232 z VSS cap_mim_2f0_m4m5_noshield c_width=5u c_length=5u
X1233 z VSS cap_mim_2f0_m4m5_noshield c_width=5u c_length=5u
X1234 z VSS cap_mim_2f0_m4m5_noshield c_width=5u c_length=5u
X1235 z VSS cap_mim_2f0_m4m5_noshield c_width=5u c_length=5u
X1236 z VSS cap_mim_2f0_m4m5_noshield c_width=5u c_length=5u
X1237 z VSS cap_mim_2f0_m4m5_noshield c_width=5u c_length=5u
X1238 z VSS cap_mim_2f0_m4m5_noshield c_width=5u c_length=5u
X1239 z VSS cap_mim_2f0_m4m5_noshield c_width=5u c_length=5u
X1240 z VSS cap_mim_2f0_m4m5_noshield c_width=5u c_length=5u
X1241 z VSS cap_mim_2f0_m4m5_noshield c_width=5u c_length=5u
X1242 z VSS cap_mim_2f0_m4m5_noshield c_width=5u c_length=5u
X1243 z VSS cap_mim_2f0_m4m5_noshield c_width=5u c_length=5u
X1244 z VSS cap_mim_2f0_m4m5_noshield c_width=5u c_length=5u
X1245 z VSS cap_mim_2f0_m4m5_noshield c_width=5u c_length=5u
X1246 z VSS cap_mim_2f0_m4m5_noshield c_width=5u c_length=5u
X1247 z VSS cap_mim_2f0_m4m5_noshield c_width=5u c_length=5u
X1248 z VSS cap_mim_2f0_m4m5_noshield c_width=5u c_length=5u
X1249 z VSS cap_mim_2f0_m4m5_noshield c_width=5u c_length=5u
X1250 z VSS cap_mim_2f0_m4m5_noshield c_width=5u c_length=5u
X1251 z VSS cap_mim_2f0_m4m5_noshield c_width=5u c_length=5u
X1252 z VSS cap_mim_2f0_m4m5_noshield c_width=5u c_length=5u
X1253 z VSS cap_mim_2f0_m4m5_noshield c_width=5u c_length=5u
X1254 z VSS cap_mim_2f0_m4m5_noshield c_width=5u c_length=5u
X1255 z VSS cap_mim_2f0_m4m5_noshield c_width=5u c_length=5u
X1256 z VSS cap_mim_2f0_m4m5_noshield c_width=5u c_length=5u
X1257 z VSS cap_mim_2f0_m4m5_noshield c_width=5u c_length=5u
X1258 z VSS cap_mim_2f0_m4m5_noshield c_width=5u c_length=5u
X1259 z VSS cap_mim_2f0_m4m5_noshield c_width=5u c_length=5u
X1260 z VSS cap_mim_2f0_m4m5_noshield c_width=5u c_length=5u
X1261 z VSS cap_mim_2f0_m4m5_noshield c_width=5u c_length=5u
X1262 z VSS cap_mim_2f0_m4m5_noshield c_width=5u c_length=5u
X1263 z VSS cap_mim_2f0_m4m5_noshield c_width=5u c_length=5u
X1264 z VSS cap_mim_2f0_m4m5_noshield c_width=5u c_length=5u
X1265 z VSS cap_mim_2f0_m4m5_noshield c_width=5u c_length=5u
X1266 z VSS cap_mim_2f0_m4m5_noshield c_width=5u c_length=5u
X1267 z VSS cap_mim_2f0_m4m5_noshield c_width=5u c_length=5u
X1268 z VSS cap_mim_2f0_m4m5_noshield c_width=5u c_length=5u
X1269 z VSS cap_mim_2f0_m4m5_noshield c_width=5u c_length=5u
X1270 z VSS cap_mim_2f0_m4m5_noshield c_width=5u c_length=5u
X1271 z VSS cap_mim_2f0_m4m5_noshield c_width=5u c_length=5u
X1272 z VSS cap_mim_2f0_m4m5_noshield c_width=5u c_length=5u
X1273 z VSS cap_mim_2f0_m4m5_noshield c_width=5u c_length=5u
X1274 z VSS cap_mim_2f0_m4m5_noshield c_width=5u c_length=5u
X1275 z VSS cap_mim_2f0_m4m5_noshield c_width=5u c_length=5u
X1276 z VSS cap_mim_2f0_m4m5_noshield c_width=5u c_length=5u
X1277 z VSS cap_mim_2f0_m4m5_noshield c_width=5u c_length=5u
X1278 z VSS cap_mim_2f0_m4m5_noshield c_width=5u c_length=5u
X1279 z VSS cap_mim_2f0_m4m5_noshield c_width=5u c_length=5u
X1280 z VSS cap_mim_2f0_m4m5_noshield c_width=5u c_length=5u
X1281 z VSS cap_mim_2f0_m4m5_noshield c_width=5u c_length=5u
X1282 z VSS cap_mim_2f0_m4m5_noshield c_width=5u c_length=5u
X1283 z VSS cap_mim_2f0_m4m5_noshield c_width=5u c_length=5u
X1284 z VSS cap_mim_2f0_m4m5_noshield c_width=5u c_length=5u
X1285 z VSS cap_mim_2f0_m4m5_noshield c_width=5u c_length=5u
X1286 z VSS cap_mim_2f0_m4m5_noshield c_width=5u c_length=5u
X1287 z VSS cap_mim_2f0_m4m5_noshield c_width=5u c_length=5u
X1288 z VSS cap_mim_2f0_m4m5_noshield c_width=5u c_length=5u
X1289 z VSS cap_mim_2f0_m4m5_noshield c_width=5u c_length=5u
X1290 z VSS cap_mim_2f0_m4m5_noshield c_width=5u c_length=5u
X1291 z VSS cap_mim_2f0_m4m5_noshield c_width=5u c_length=5u
X1292 z VSS cap_mim_2f0_m4m5_noshield c_width=5u c_length=5u
X1293 z VSS cap_mim_2f0_m4m5_noshield c_width=5u c_length=5u
X1294 z VSS cap_mim_2f0_m4m5_noshield c_width=5u c_length=5u
X1295 z VSS cap_mim_2f0_m4m5_noshield c_width=5u c_length=5u
X1296 z VSS cap_mim_2f0_m4m5_noshield c_width=5u c_length=5u
X1297 z VSS cap_mim_2f0_m4m5_noshield c_width=5u c_length=5u
X1298 z VSS cap_mim_2f0_m4m5_noshield c_width=5u c_length=5u
X1299 z VSS cap_mim_2f0_m4m5_noshield c_width=5u c_length=5u
X1300 z VSS cap_mim_2f0_m4m5_noshield c_width=5u c_length=5u
X1301 z VSS cap_mim_2f0_m4m5_noshield c_width=5u c_length=5u
X1302 z VSS cap_mim_2f0_m4m5_noshield c_width=5u c_length=5u
X1303 z VSS cap_mim_2f0_m4m5_noshield c_width=5u c_length=5u
X1304 z VSS cap_mim_2f0_m4m5_noshield c_width=5u c_length=5u
X1305 z VSS cap_mim_2f0_m4m5_noshield c_width=5u c_length=5u
X1306 z VSS cap_mim_2f0_m4m5_noshield c_width=5u c_length=5u
X1307 z VSS cap_mim_2f0_m4m5_noshield c_width=5u c_length=5u
X1308 z VSS cap_mim_2f0_m4m5_noshield c_width=5u c_length=5u
X1309 z VSS cap_mim_2f0_m4m5_noshield c_width=5u c_length=5u
X1310 z VSS cap_mim_2f0_m4m5_noshield c_width=5u c_length=5u
X1311 z VSS cap_mim_2f0_m4m5_noshield c_width=5u c_length=5u
X1312 z VSS cap_mim_2f0_m4m5_noshield c_width=5u c_length=5u
X1313 z VSS cap_mim_2f0_m4m5_noshield c_width=5u c_length=5u
X1314 z VSS cap_mim_2f0_m4m5_noshield c_width=5u c_length=5u
X1315 z VSS cap_mim_2f0_m4m5_noshield c_width=5u c_length=5u
X1316 z VSS cap_mim_2f0_m4m5_noshield c_width=5u c_length=5u
X1317 z VSS cap_mim_2f0_m4m5_noshield c_width=5u c_length=5u
X1318 z VSS cap_mim_2f0_m4m5_noshield c_width=5u c_length=5u
X1319 z VSS cap_mim_2f0_m4m5_noshield c_width=5u c_length=5u
X1320 z VSS cap_mim_2f0_m4m5_noshield c_width=5u c_length=5u
X1321 z VSS cap_mim_2f0_m4m5_noshield c_width=5u c_length=5u
X1322 z VSS cap_mim_2f0_m4m5_noshield c_width=5u c_length=5u
X1323 z VSS cap_mim_2f0_m4m5_noshield c_width=5u c_length=5u
X1324 z VSS cap_mim_2f0_m4m5_noshield c_width=5u c_length=5u
X1325 z VSS cap_mim_2f0_m4m5_noshield c_width=5u c_length=5u
X1326 z VSS cap_mim_2f0_m4m5_noshield c_width=5u c_length=5u
X1327 z VSS cap_mim_2f0_m4m5_noshield c_width=5u c_length=5u
X1328 z VSS cap_mim_2f0_m4m5_noshield c_width=5u c_length=5u
X1329 z VSS cap_mim_2f0_m4m5_noshield c_width=5u c_length=5u
X1330 z VSS cap_mim_2f0_m4m5_noshield c_width=5u c_length=5u
X1331 z VSS cap_mim_2f0_m4m5_noshield c_width=5u c_length=5u
X1332 z VSS cap_mim_2f0_m4m5_noshield c_width=5u c_length=5u
X1333 z VSS cap_mim_2f0_m4m5_noshield c_width=5u c_length=5u
X1334 z VSS cap_mim_2f0_m4m5_noshield c_width=5u c_length=5u
X1335 z VSS cap_mim_2f0_m4m5_noshield c_width=5u c_length=5u
X1336 z VSS cap_mim_2f0_m4m5_noshield c_width=5u c_length=5u
X1337 z VSS cap_mim_2f0_m4m5_noshield c_width=5u c_length=5u
X1338 z VSS cap_mim_2f0_m4m5_noshield c_width=5u c_length=5u
X1339 z VSS cap_mim_2f0_m4m5_noshield c_width=5u c_length=5u
X1340 z VSS cap_mim_2f0_m4m5_noshield c_width=5u c_length=5u
X1341 z VSS cap_mim_2f0_m4m5_noshield c_width=5u c_length=5u
X1342 z VSS cap_mim_2f0_m4m5_noshield c_width=5u c_length=5u
X1343 z VSS cap_mim_2f0_m4m5_noshield c_width=5u c_length=5u
X1344 z VSS cap_mim_2f0_m4m5_noshield c_width=5u c_length=5u
X1345 z VSS cap_mim_2f0_m4m5_noshield c_width=5u c_length=5u
X1346 z VSS cap_mim_2f0_m4m5_noshield c_width=5u c_length=5u
X1347 z VSS cap_mim_2f0_m4m5_noshield c_width=5u c_length=5u
X1348 z VSS cap_mim_2f0_m4m5_noshield c_width=5u c_length=5u
X1349 z VSS cap_mim_2f0_m4m5_noshield c_width=5u c_length=5u
X1350 z VSS cap_mim_2f0_m4m5_noshield c_width=5u c_length=5u
X1351 z VSS cap_mim_2f0_m4m5_noshield c_width=5u c_length=5u
X1352 z VSS cap_mim_2f0_m4m5_noshield c_width=5u c_length=5u
X1353 z VSS cap_mim_2f0_m4m5_noshield c_width=5u c_length=5u
X1354 z VSS cap_mim_2f0_m4m5_noshield c_width=5u c_length=5u
X1355 z VSS cap_mim_2f0_m4m5_noshield c_width=5u c_length=5u
X1356 z VSS cap_mim_2f0_m4m5_noshield c_width=5u c_length=5u
X1357 z VSS cap_mim_2f0_m4m5_noshield c_width=5u c_length=5u
X1358 z VSS cap_mim_2f0_m4m5_noshield c_width=5u c_length=5u
X1359 z VSS cap_mim_2f0_m4m5_noshield c_width=5u c_length=5u
X1360 z VSS cap_mim_2f0_m4m5_noshield c_width=5u c_length=5u
X1361 z VSS cap_mim_2f0_m4m5_noshield c_width=5u c_length=5u
X1362 z VSS cap_mim_2f0_m4m5_noshield c_width=5u c_length=5u
X1363 z VSS cap_mim_2f0_m4m5_noshield c_width=5u c_length=5u
X1364 z VSS cap_mim_2f0_m4m5_noshield c_width=5u c_length=5u
X1365 z VSS cap_mim_2f0_m4m5_noshield c_width=5u c_length=5u
X1366 z VSS cap_mim_2f0_m4m5_noshield c_width=5u c_length=5u
X1367 z VSS cap_mim_2f0_m4m5_noshield c_width=5u c_length=5u
X1368 z VSS cap_mim_2f0_m4m5_noshield c_width=5u c_length=5u
X1369 z VSS cap_mim_2f0_m4m5_noshield c_width=5u c_length=5u
X1370 z VSS cap_mim_2f0_m4m5_noshield c_width=5u c_length=5u
X1371 z VSS cap_mim_2f0_m4m5_noshield c_width=5u c_length=5u
X1372 z VSS cap_mim_2f0_m4m5_noshield c_width=5u c_length=5u
X1373 z VSS cap_mim_2f0_m4m5_noshield c_width=5u c_length=5u
X1374 z VSS cap_mim_2f0_m4m5_noshield c_width=5u c_length=5u
X1375 z VSS cap_mim_2f0_m4m5_noshield c_width=5u c_length=5u
X1376 z VSS cap_mim_2f0_m4m5_noshield c_width=5u c_length=5u
X1377 z VSS cap_mim_2f0_m4m5_noshield c_width=5u c_length=5u
X1378 z VSS cap_mim_2f0_m4m5_noshield c_width=5u c_length=5u
X1379 z VSS cap_mim_2f0_m4m5_noshield c_width=5u c_length=5u
X1380 z VSS cap_mim_2f0_m4m5_noshield c_width=5u c_length=5u
X1381 z VSS cap_mim_2f0_m4m5_noshield c_width=5u c_length=5u
X1382 z VSS cap_mim_2f0_m4m5_noshield c_width=5u c_length=5u
X1383 z VSS cap_mim_2f0_m4m5_noshield c_width=5u c_length=5u
X1384 z VSS cap_mim_2f0_m4m5_noshield c_width=5u c_length=5u
X1385 z VSS cap_mim_2f0_m4m5_noshield c_width=5u c_length=5u
X1386 z VSS cap_mim_2f0_m4m5_noshield c_width=5u c_length=5u
X1387 z VSS cap_mim_2f0_m4m5_noshield c_width=5u c_length=5u
X1388 z VSS cap_mim_2f0_m4m5_noshield c_width=5u c_length=5u
X1389 z VSS cap_mim_2f0_m4m5_noshield c_width=5u c_length=5u
X1390 z VSS cap_mim_2f0_m4m5_noshield c_width=5u c_length=5u
X1391 z VSS cap_mim_2f0_m4m5_noshield c_width=5u c_length=5u
X1392 z VSS cap_mim_2f0_m4m5_noshield c_width=5u c_length=5u
X1393 z VSS cap_mim_2f0_m4m5_noshield c_width=5u c_length=5u
X1394 z VSS cap_mim_2f0_m4m5_noshield c_width=5u c_length=5u
X1395 z VSS cap_mim_2f0_m4m5_noshield c_width=5u c_length=5u
X1396 z VSS cap_mim_2f0_m4m5_noshield c_width=5u c_length=5u
X1397 z VSS cap_mim_2f0_m4m5_noshield c_width=5u c_length=5u
X1398 z VSS cap_mim_2f0_m4m5_noshield c_width=5u c_length=5u
X1399 z VSS cap_mim_2f0_m4m5_noshield c_width=5u c_length=5u
X1400 z VSS cap_mim_2f0_m4m5_noshield c_width=5u c_length=5u
X1401 z VSS cap_mim_2f0_m4m5_noshield c_width=5u c_length=5u
X1402 z VSS cap_mim_2f0_m4m5_noshield c_width=5u c_length=5u
X1403 z VSS cap_mim_2f0_m4m5_noshield c_width=5u c_length=5u
X1404 z VSS cap_mim_2f0_m4m5_noshield c_width=5u c_length=5u
X1405 z VSS cap_mim_2f0_m4m5_noshield c_width=5u c_length=5u
X1406 z VSS cap_mim_2f0_m4m5_noshield c_width=5u c_length=5u
X1407 z VSS cap_mim_2f0_m4m5_noshield c_width=5u c_length=5u
X1408 z VSS cap_mim_2f0_m4m5_noshield c_width=5u c_length=5u
X1409 z VSS cap_mim_2f0_m4m5_noshield c_width=5u c_length=5u
X1410 z VSS cap_mim_2f0_m4m5_noshield c_width=5u c_length=5u
X1411 z VSS cap_mim_2f0_m4m5_noshield c_width=5u c_length=5u
X1412 z VSS cap_mim_2f0_m4m5_noshield c_width=5u c_length=5u
X1413 z VSS cap_mim_2f0_m4m5_noshield c_width=5u c_length=5u
X1414 z VSS cap_mim_2f0_m4m5_noshield c_width=5u c_length=5u
X1415 z VSS cap_mim_2f0_m4m5_noshield c_width=5u c_length=5u
X1416 z VSS cap_mim_2f0_m4m5_noshield c_width=5u c_length=5u
X1417 z VSS cap_mim_2f0_m4m5_noshield c_width=5u c_length=5u
X1418 z VSS cap_mim_2f0_m4m5_noshield c_width=5u c_length=5u
X1419 z VSS cap_mim_2f0_m4m5_noshield c_width=5u c_length=5u
X1420 z VSS cap_mim_2f0_m4m5_noshield c_width=5u c_length=5u
X1421 z VSS cap_mim_2f0_m4m5_noshield c_width=5u c_length=5u
X1422 z VSS cap_mim_2f0_m4m5_noshield c_width=5u c_length=5u
X1423 z VSS cap_mim_2f0_m4m5_noshield c_width=5u c_length=5u
X1424 z VSS cap_mim_2f0_m4m5_noshield c_width=5u c_length=5u
X1425 z VSS cap_mim_2f0_m4m5_noshield c_width=5u c_length=5u
X1426 z VSS cap_mim_2f0_m4m5_noshield c_width=5u c_length=5u
X1427 z VSS cap_mim_2f0_m4m5_noshield c_width=5u c_length=5u
X1428 z VSS cap_mim_2f0_m4m5_noshield c_width=5u c_length=5u
X1429 z VSS cap_mim_2f0_m4m5_noshield c_width=5u c_length=5u
X1430 z VSS cap_mim_2f0_m4m5_noshield c_width=5u c_length=5u
X1431 z VSS cap_mim_2f0_m4m5_noshield c_width=5u c_length=5u
X1432 z VSS cap_mim_2f0_m4m5_noshield c_width=5u c_length=5u
X1433 z VSS cap_mim_2f0_m4m5_noshield c_width=5u c_length=5u
X1434 z VSS cap_mim_2f0_m4m5_noshield c_width=5u c_length=5u
X1435 z VSS cap_mim_2f0_m4m5_noshield c_width=5u c_length=5u
X1436 z VSS cap_mim_2f0_m4m5_noshield c_width=5u c_length=5u
X1437 z VSS cap_mim_2f0_m4m5_noshield c_width=5u c_length=5u
X1438 z VSS cap_mim_2f0_m4m5_noshield c_width=5u c_length=5u
X1439 z VSS cap_mim_2f0_m4m5_noshield c_width=5u c_length=5u
X1440 z VSS cap_mim_2f0_m4m5_noshield c_width=5u c_length=5u
X1441 z VSS cap_mim_2f0_m4m5_noshield c_width=5u c_length=5u
X1442 z VSS cap_mim_2f0_m4m5_noshield c_width=5u c_length=5u
X1443 z VSS cap_mim_2f0_m4m5_noshield c_width=5u c_length=5u
X1444 z VSS cap_mim_2f0_m4m5_noshield c_width=5u c_length=5u
X1445 z VSS cap_mim_2f0_m4m5_noshield c_width=5u c_length=5u
X1446 z VSS cap_mim_2f0_m4m5_noshield c_width=5u c_length=5u
X1447 z VSS cap_mim_2f0_m4m5_noshield c_width=5u c_length=5u
X1448 z VSS cap_mim_2f0_m4m5_noshield c_width=5u c_length=5u
X1449 z VSS cap_mim_2f0_m4m5_noshield c_width=5u c_length=5u
X1450 z VSS cap_mim_2f0_m4m5_noshield c_width=5u c_length=5u
X1451 z VSS cap_mim_2f0_m4m5_noshield c_width=5u c_length=5u
X1452 z VSS cap_mim_2f0_m4m5_noshield c_width=5u c_length=5u
X1453 z VSS cap_mim_2f0_m4m5_noshield c_width=5u c_length=5u
X1454 z VSS cap_mim_2f0_m4m5_noshield c_width=5u c_length=5u
X1455 z VSS cap_mim_2f0_m4m5_noshield c_width=5u c_length=5u
X1456 z VSS cap_mim_2f0_m4m5_noshield c_width=5u c_length=5u
X1457 z VSS cap_mim_2f0_m4m5_noshield c_width=5u c_length=5u
X1458 z VSS cap_mim_2f0_m4m5_noshield c_width=5u c_length=5u
X1459 z VSS cap_mim_2f0_m4m5_noshield c_width=5u c_length=5u
X1460 z VSS cap_mim_2f0_m4m5_noshield c_width=5u c_length=5u
X1461 z VSS cap_mim_2f0_m4m5_noshield c_width=5u c_length=5u
X1462 z VSS cap_mim_2f0_m4m5_noshield c_width=5u c_length=5u
X1463 z VSS cap_mim_2f0_m4m5_noshield c_width=5u c_length=5u
X1464 z VSS cap_mim_2f0_m4m5_noshield c_width=5u c_length=5u
X1465 z VSS cap_mim_2f0_m4m5_noshield c_width=5u c_length=5u
X1466 z VSS cap_mim_2f0_m4m5_noshield c_width=5u c_length=5u
X1467 z VSS cap_mim_2f0_m4m5_noshield c_width=5u c_length=5u
X1468 z VSS cap_mim_2f0_m4m5_noshield c_width=5u c_length=5u
X1469 z VSS cap_mim_2f0_m4m5_noshield c_width=5u c_length=5u
X1470 z VSS cap_mim_2f0_m4m5_noshield c_width=5u c_length=5u
X1471 z VSS cap_mim_2f0_m4m5_noshield c_width=5u c_length=5u
X1472 z VSS cap_mim_2f0_m4m5_noshield c_width=5u c_length=5u
X1473 z VSS cap_mim_2f0_m4m5_noshield c_width=5u c_length=5u
X1474 z VSS cap_mim_2f0_m4m5_noshield c_width=5u c_length=5u
X1475 z VSS cap_mim_2f0_m4m5_noshield c_width=5u c_length=5u
X1476 z VSS cap_mim_2f0_m4m5_noshield c_width=5u c_length=5u
X1477 z VSS cap_mim_2f0_m4m5_noshield c_width=5u c_length=5u
X1478 z VSS cap_mim_2f0_m4m5_noshield c_width=5u c_length=5u
X1479 z VSS cap_mim_2f0_m4m5_noshield c_width=5u c_length=5u
X1480 z VSS cap_mim_2f0_m4m5_noshield c_width=5u c_length=5u
X1481 z VSS cap_mim_2f0_m4m5_noshield c_width=5u c_length=5u
X1482 z VSS cap_mim_2f0_m4m5_noshield c_width=5u c_length=5u
X1483 z VSS cap_mim_2f0_m4m5_noshield c_width=5u c_length=5u
X1484 z VSS cap_mim_2f0_m4m5_noshield c_width=5u c_length=5u
X1485 z VSS cap_mim_2f0_m4m5_noshield c_width=5u c_length=5u
X1486 z VSS cap_mim_2f0_m4m5_noshield c_width=5u c_length=5u
X1487 z VSS cap_mim_2f0_m4m5_noshield c_width=5u c_length=5u
X1488 z VSS cap_mim_2f0_m4m5_noshield c_width=5u c_length=5u
X1489 z VSS cap_mim_2f0_m4m5_noshield c_width=5u c_length=5u
X1490 z VSS cap_mim_2f0_m4m5_noshield c_width=5u c_length=5u
X1491 z VSS cap_mim_2f0_m4m5_noshield c_width=5u c_length=5u
X1492 z VSS cap_mim_2f0_m4m5_noshield c_width=5u c_length=5u
X1493 z VSS cap_mim_2f0_m4m5_noshield c_width=5u c_length=5u
X1494 z VSS cap_mim_2f0_m4m5_noshield c_width=5u c_length=5u
X1495 z VSS cap_mim_2f0_m4m5_noshield c_width=5u c_length=5u
X1496 z VSS cap_mim_2f0_m4m5_noshield c_width=5u c_length=5u
X1497 z VSS cap_mim_2f0_m4m5_noshield c_width=5u c_length=5u
X1498 z VSS cap_mim_2f0_m4m5_noshield c_width=5u c_length=5u
X1499 z VSS cap_mim_2f0_m4m5_noshield c_width=5u c_length=5u
X1500 z VSS cap_mim_2f0_m4m5_noshield c_width=5u c_length=5u
X1501 z VSS cap_mim_2f0_m4m5_noshield c_width=5u c_length=5u
X1502 z VSS cap_mim_2f0_m4m5_noshield c_width=5u c_length=5u
X1503 z VSS cap_mim_2f0_m4m5_noshield c_width=5u c_length=5u
X1504 z VSS cap_mim_2f0_m4m5_noshield c_width=5u c_length=5u
X1505 z VSS cap_mim_2f0_m4m5_noshield c_width=5u c_length=5u
X1506 z VSS cap_mim_2f0_m4m5_noshield c_width=5u c_length=5u
X1507 z VSS cap_mim_2f0_m4m5_noshield c_width=5u c_length=5u
X1508 z VSS cap_mim_2f0_m4m5_noshield c_width=5u c_length=5u
X1509 z VSS cap_mim_2f0_m4m5_noshield c_width=5u c_length=5u
X1510 z VSS cap_mim_2f0_m4m5_noshield c_width=5u c_length=5u
X1511 z VSS cap_mim_2f0_m4m5_noshield c_width=5u c_length=5u
X1512 z VSS cap_mim_2f0_m4m5_noshield c_width=5u c_length=5u
X1513 z VSS cap_mim_2f0_m4m5_noshield c_width=5u c_length=5u
X1514 z VSS cap_mim_2f0_m4m5_noshield c_width=5u c_length=5u
X1515 z VSS cap_mim_2f0_m4m5_noshield c_width=5u c_length=5u
X1516 z VSS cap_mim_2f0_m4m5_noshield c_width=5u c_length=5u
X1517 z VSS cap_mim_2f0_m4m5_noshield c_width=5u c_length=5u
X1518 z VSS cap_mim_2f0_m4m5_noshield c_width=5u c_length=5u
X1519 z VSS cap_mim_2f0_m4m5_noshield c_width=5u c_length=5u
X1520 z VSS cap_mim_2f0_m4m5_noshield c_width=5u c_length=5u
X1521 z VSS cap_mim_2f0_m4m5_noshield c_width=5u c_length=5u
X1522 z VSS cap_mim_2f0_m4m5_noshield c_width=5u c_length=5u
X1523 z VSS cap_mim_2f0_m4m5_noshield c_width=5u c_length=5u
X1524 z VSS cap_mim_2f0_m4m5_noshield c_width=5u c_length=5u
X1525 z VSS cap_mim_2f0_m4m5_noshield c_width=5u c_length=5u
X1526 z VSS cap_mim_2f0_m4m5_noshield c_width=5u c_length=5u
X1527 z VSS cap_mim_2f0_m4m5_noshield c_width=5u c_length=5u
X1528 z VSS cap_mim_2f0_m4m5_noshield c_width=5u c_length=5u
X1529 z VSS cap_mim_2f0_m4m5_noshield c_width=5u c_length=5u
X1530 z VSS cap_mim_2f0_m4m5_noshield c_width=5u c_length=5u
X1531 z VSS cap_mim_2f0_m4m5_noshield c_width=5u c_length=5u
X1532 z VSS cap_mim_2f0_m4m5_noshield c_width=5u c_length=5u
X1533 z VSS cap_mim_2f0_m4m5_noshield c_width=5u c_length=5u
X1534 z VSS cap_mim_2f0_m4m5_noshield c_width=5u c_length=5u
X1535 z VSS cap_mim_2f0_m4m5_noshield c_width=5u c_length=5u
X1536 z VSS cap_mim_2f0_m4m5_noshield c_width=5u c_length=5u
X1537 z VSS cap_mim_2f0_m4m5_noshield c_width=5u c_length=5u
X1538 z VSS cap_mim_2f0_m4m5_noshield c_width=5u c_length=5u
X1539 z VSS cap_mim_2f0_m4m5_noshield c_width=5u c_length=5u
X1540 z VSS cap_mim_2f0_m4m5_noshield c_width=5u c_length=5u
X1541 z VSS cap_mim_2f0_m4m5_noshield c_width=5u c_length=5u
X1542 z VSS cap_mim_2f0_m4m5_noshield c_width=5u c_length=5u
X1543 z VSS cap_mim_2f0_m4m5_noshield c_width=5u c_length=5u
X1544 z VSS cap_mim_2f0_m4m5_noshield c_width=5u c_length=5u
X1545 z VSS cap_mim_2f0_m4m5_noshield c_width=5u c_length=5u
X1546 z VSS cap_mim_2f0_m4m5_noshield c_width=5u c_length=5u
X1547 z VSS cap_mim_2f0_m4m5_noshield c_width=5u c_length=5u
X1548 z VSS cap_mim_2f0_m4m5_noshield c_width=5u c_length=5u
X1549 z VSS cap_mim_2f0_m4m5_noshield c_width=5u c_length=5u
X1550 z VSS cap_mim_2f0_m4m5_noshield c_width=5u c_length=5u
X1551 z VSS cap_mim_2f0_m4m5_noshield c_width=5u c_length=5u
X1552 z VSS cap_mim_2f0_m4m5_noshield c_width=5u c_length=5u
X1553 z VSS cap_mim_2f0_m4m5_noshield c_width=5u c_length=5u
X1554 z VSS cap_mim_2f0_m4m5_noshield c_width=5u c_length=5u
X1555 z VSS cap_mim_2f0_m4m5_noshield c_width=5u c_length=5u
X1556 z VSS cap_mim_2f0_m4m5_noshield c_width=5u c_length=5u
X1557 z VSS cap_mim_2f0_m4m5_noshield c_width=5u c_length=5u
X1558 z VSS cap_mim_2f0_m4m5_noshield c_width=5u c_length=5u
X1559 z VSS cap_mim_2f0_m4m5_noshield c_width=5u c_length=5u
X1560 z VSS cap_mim_2f0_m4m5_noshield c_width=5u c_length=5u
X1561 z VSS cap_mim_2f0_m4m5_noshield c_width=5u c_length=5u
X1562 z VSS cap_mim_2f0_m4m5_noshield c_width=5u c_length=5u
X1563 z VSS cap_mim_2f0_m4m5_noshield c_width=5u c_length=5u
X1564 z VSS cap_mim_2f0_m4m5_noshield c_width=5u c_length=5u
X1565 z VSS cap_mim_2f0_m4m5_noshield c_width=5u c_length=5u
X1566 z VSS cap_mim_2f0_m4m5_noshield c_width=5u c_length=5u
X1567 z VSS cap_mim_2f0_m4m5_noshield c_width=5u c_length=5u
X1568 z VSS cap_mim_2f0_m4m5_noshield c_width=5u c_length=5u
X1569 z VSS cap_mim_2f0_m4m5_noshield c_width=5u c_length=5u
X1570 z VSS cap_mim_2f0_m4m5_noshield c_width=5u c_length=5u
X1571 z VSS cap_mim_2f0_m4m5_noshield c_width=5u c_length=5u
X1572 z VSS cap_mim_2f0_m4m5_noshield c_width=5u c_length=5u
X1573 z VSS cap_mim_2f0_m4m5_noshield c_width=5u c_length=5u
X1574 z VSS cap_mim_2f0_m4m5_noshield c_width=5u c_length=5u
X1575 z VSS cap_mim_2f0_m4m5_noshield c_width=5u c_length=5u
X1576 z VSS cap_mim_2f0_m4m5_noshield c_width=5u c_length=5u
X1577 z VSS cap_mim_2f0_m4m5_noshield c_width=5u c_length=5u
X1578 z VSS cap_mim_2f0_m4m5_noshield c_width=5u c_length=5u
X1579 z VSS cap_mim_2f0_m4m5_noshield c_width=5u c_length=5u
X1580 z VSS cap_mim_2f0_m4m5_noshield c_width=5u c_length=5u
X1581 z VSS cap_mim_2f0_m4m5_noshield c_width=5u c_length=5u
X1582 z VSS cap_mim_2f0_m4m5_noshield c_width=5u c_length=5u
X1583 z VSS cap_mim_2f0_m4m5_noshield c_width=5u c_length=5u
X1584 z VSS cap_mim_2f0_m4m5_noshield c_width=5u c_length=5u
X1585 z VSS cap_mim_2f0_m4m5_noshield c_width=5u c_length=5u
X1586 z VSS cap_mim_2f0_m4m5_noshield c_width=5u c_length=5u
X1587 z VSS cap_mim_2f0_m4m5_noshield c_width=5u c_length=5u
X1588 z VSS cap_mim_2f0_m4m5_noshield c_width=5u c_length=5u
X1589 z VSS cap_mim_2f0_m4m5_noshield c_width=5u c_length=5u
X1590 z VSS cap_mim_2f0_m4m5_noshield c_width=5u c_length=5u
X1591 z VSS cap_mim_2f0_m4m5_noshield c_width=5u c_length=5u
X1592 z VSS cap_mim_2f0_m4m5_noshield c_width=5u c_length=5u
X1593 z VSS cap_mim_2f0_m4m5_noshield c_width=5u c_length=5u
X1594 z VSS cap_mim_2f0_m4m5_noshield c_width=5u c_length=5u
X1595 z VSS cap_mim_2f0_m4m5_noshield c_width=5u c_length=5u
X1596 z VSS cap_mim_2f0_m4m5_noshield c_width=5u c_length=5u
X1597 z VSS cap_mim_2f0_m4m5_noshield c_width=5u c_length=5u
X1598 z VSS cap_mim_2f0_m4m5_noshield c_width=5u c_length=5u
X1599 z VSS cap_mim_2f0_m4m5_noshield c_width=5u c_length=5u
X1600 z VSS cap_mim_2f0_m4m5_noshield c_width=5u c_length=5u
X1601 z VSS cap_mim_2f0_m4m5_noshield c_width=5u c_length=5u
X1602 z VSS cap_mim_2f0_m4m5_noshield c_width=5u c_length=5u
X1603 z VSS cap_mim_2f0_m4m5_noshield c_width=5u c_length=5u
X1604 z VSS cap_mim_2f0_m4m5_noshield c_width=5u c_length=5u
X1605 z VSS cap_mim_2f0_m4m5_noshield c_width=5u c_length=5u
X1606 z VSS cap_mim_2f0_m4m5_noshield c_width=5u c_length=5u
X1607 z VSS cap_mim_2f0_m4m5_noshield c_width=5u c_length=5u
X1608 z VSS cap_mim_2f0_m4m5_noshield c_width=5u c_length=5u
X1609 z VSS cap_mim_2f0_m4m5_noshield c_width=5u c_length=5u
X1610 z VSS cap_mim_2f0_m4m5_noshield c_width=5u c_length=5u
X1611 z VSS cap_mim_2f0_m4m5_noshield c_width=5u c_length=5u
X1612 z VSS cap_mim_2f0_m4m5_noshield c_width=5u c_length=5u
X1613 z VSS cap_mim_2f0_m4m5_noshield c_width=5u c_length=5u
X1614 z VSS cap_mim_2f0_m4m5_noshield c_width=5u c_length=5u
X1615 z VSS cap_mim_2f0_m4m5_noshield c_width=5u c_length=5u
X1616 z VSS cap_mim_2f0_m4m5_noshield c_width=5u c_length=5u
X1617 z VSS cap_mim_2f0_m4m5_noshield c_width=5u c_length=5u
X1618 z VSS cap_mim_2f0_m4m5_noshield c_width=5u c_length=5u
X1619 z VSS cap_mim_2f0_m4m5_noshield c_width=5u c_length=5u
X1620 z VSS cap_mim_2f0_m4m5_noshield c_width=5u c_length=5u
X1621 z VSS cap_mim_2f0_m4m5_noshield c_width=5u c_length=5u
X1622 z VSS cap_mim_2f0_m4m5_noshield c_width=5u c_length=5u
X1623 z VSS cap_mim_2f0_m4m5_noshield c_width=5u c_length=5u
X1624 z VSS cap_mim_2f0_m4m5_noshield c_width=5u c_length=5u
X1625 z VSS cap_mim_2f0_m4m5_noshield c_width=5u c_length=5u
X1626 z VSS cap_mim_2f0_m4m5_noshield c_width=5u c_length=5u
X1627 z VSS cap_mim_2f0_m4m5_noshield c_width=5u c_length=5u
X1628 z VSS cap_mim_2f0_m4m5_noshield c_width=5u c_length=5u
X1629 z VSS cap_mim_2f0_m4m5_noshield c_width=5u c_length=5u
X1630 z VSS cap_mim_2f0_m4m5_noshield c_width=5u c_length=5u
X1631 z VSS cap_mim_2f0_m4m5_noshield c_width=5u c_length=5u
X1632 z VSS cap_mim_2f0_m4m5_noshield c_width=5u c_length=5u
X1633 z VSS cap_mim_2f0_m4m5_noshield c_width=5u c_length=5u
X1634 z VSS cap_mim_2f0_m4m5_noshield c_width=5u c_length=5u
X1635 z VSS cap_mim_2f0_m4m5_noshield c_width=5u c_length=5u
X1636 z VSS cap_mim_2f0_m4m5_noshield c_width=5u c_length=5u
X1637 z VSS cap_mim_2f0_m4m5_noshield c_width=5u c_length=5u
X1638 z VSS cap_mim_2f0_m4m5_noshield c_width=5u c_length=5u
X1639 z VSS cap_mim_2f0_m4m5_noshield c_width=5u c_length=5u
X1640 z VSS cap_mim_2f0_m4m5_noshield c_width=5u c_length=5u
X1641 z VSS cap_mim_2f0_m4m5_noshield c_width=5u c_length=5u
X1642 z VSS cap_mim_2f0_m4m5_noshield c_width=5u c_length=5u
X1643 z VSS cap_mim_2f0_m4m5_noshield c_width=5u c_length=5u
X1644 z VSS cap_mim_2f0_m4m5_noshield c_width=5u c_length=5u
X1645 z VSS cap_mim_2f0_m4m5_noshield c_width=5u c_length=5u
X1646 z VSS cap_mim_2f0_m4m5_noshield c_width=5u c_length=5u
X1647 z VSS cap_mim_2f0_m4m5_noshield c_width=5u c_length=5u
X1648 z VSS cap_mim_2f0_m4m5_noshield c_width=5u c_length=5u
X1649 z VSS cap_mim_2f0_m4m5_noshield c_width=5u c_length=5u
X1650 z VSS cap_mim_2f0_m4m5_noshield c_width=5u c_length=5u
X1651 z VSS cap_mim_2f0_m4m5_noshield c_width=5u c_length=5u
X1652 z VSS cap_mim_2f0_m4m5_noshield c_width=5u c_length=5u
X1653 z VSS cap_mim_2f0_m4m5_noshield c_width=5u c_length=5u
X1654 z VSS cap_mim_2f0_m4m5_noshield c_width=5u c_length=5u
X1655 z VSS cap_mim_2f0_m4m5_noshield c_width=5u c_length=5u
X1656 z VSS cap_mim_2f0_m4m5_noshield c_width=5u c_length=5u
X1657 z VSS cap_mim_2f0_m4m5_noshield c_width=5u c_length=5u
X1658 z VSS cap_mim_2f0_m4m5_noshield c_width=5u c_length=5u
X1659 z VSS cap_mim_2f0_m4m5_noshield c_width=5u c_length=5u
X1660 z VSS cap_mim_2f0_m4m5_noshield c_width=5u c_length=5u
X1661 z VSS cap_mim_2f0_m4m5_noshield c_width=5u c_length=5u
X1662 z VSS cap_mim_2f0_m4m5_noshield c_width=5u c_length=5u
X1663 z VSS cap_mim_2f0_m4m5_noshield c_width=5u c_length=5u
X1664 z VSS cap_mim_2f0_m4m5_noshield c_width=5u c_length=5u
X1665 z VSS cap_mim_2f0_m4m5_noshield c_width=5u c_length=5u
X1666 z VSS cap_mim_2f0_m4m5_noshield c_width=5u c_length=5u
X1667 z VSS cap_mim_2f0_m4m5_noshield c_width=5u c_length=5u
X1668 z VSS cap_mim_2f0_m4m5_noshield c_width=5u c_length=5u
X1669 z VSS cap_mim_2f0_m4m5_noshield c_width=5u c_length=5u
X1670 z VSS cap_mim_2f0_m4m5_noshield c_width=5u c_length=5u
X1671 z VSS cap_mim_2f0_m4m5_noshield c_width=5u c_length=5u
X1672 z VSS cap_mim_2f0_m4m5_noshield c_width=5u c_length=5u
X1673 z VSS cap_mim_2f0_m4m5_noshield c_width=5u c_length=5u
X1674 z VSS cap_mim_2f0_m4m5_noshield c_width=5u c_length=5u
X1675 z VSS cap_mim_2f0_m4m5_noshield c_width=5u c_length=5u
X1676 z VSS cap_mim_2f0_m4m5_noshield c_width=5u c_length=5u
X1677 z VSS cap_mim_2f0_m4m5_noshield c_width=5u c_length=5u
X1678 z VSS cap_mim_2f0_m4m5_noshield c_width=5u c_length=5u
X1679 z VSS cap_mim_2f0_m4m5_noshield c_width=5u c_length=5u
X1680 z VSS cap_mim_2f0_m4m5_noshield c_width=5u c_length=5u
X1681 z VSS cap_mim_2f0_m4m5_noshield c_width=5u c_length=5u
X1682 z VSS cap_mim_2f0_m4m5_noshield c_width=5u c_length=5u
X1683 z VSS cap_mim_2f0_m4m5_noshield c_width=5u c_length=5u
X1684 z VSS cap_mim_2f0_m4m5_noshield c_width=5u c_length=5u
X1685 z VSS cap_mim_2f0_m4m5_noshield c_width=5u c_length=5u
X1686 z VSS cap_mim_2f0_m4m5_noshield c_width=5u c_length=5u
X1687 z VSS cap_mim_2f0_m4m5_noshield c_width=5u c_length=5u
X1688 z VSS cap_mim_2f0_m4m5_noshield c_width=5u c_length=5u
X1689 z VSS cap_mim_2f0_m4m5_noshield c_width=5u c_length=5u
X1690 z VSS cap_mim_2f0_m4m5_noshield c_width=5u c_length=5u
X1691 z VSS cap_mim_2f0_m4m5_noshield c_width=5u c_length=5u
X1692 z VSS cap_mim_2f0_m4m5_noshield c_width=5u c_length=5u
X1693 z VSS cap_mim_2f0_m4m5_noshield c_width=5u c_length=5u
X1694 z VSS cap_mim_2f0_m4m5_noshield c_width=5u c_length=5u
X1695 z VSS cap_mim_2f0_m4m5_noshield c_width=5u c_length=5u
X1696 z VSS cap_mim_2f0_m4m5_noshield c_width=5u c_length=5u
X1697 z VSS cap_mim_2f0_m4m5_noshield c_width=5u c_length=5u
X1698 z VSS cap_mim_2f0_m4m5_noshield c_width=5u c_length=5u
X1699 z VSS cap_mim_2f0_m4m5_noshield c_width=5u c_length=5u
X1700 z VSS cap_mim_2f0_m4m5_noshield c_width=5u c_length=5u
X1701 z VSS cap_mim_2f0_m4m5_noshield c_width=5u c_length=5u
X1702 z VSS cap_mim_2f0_m4m5_noshield c_width=5u c_length=5u
X1703 z VSS cap_mim_2f0_m4m5_noshield c_width=5u c_length=5u
X1704 z VSS cap_mim_2f0_m4m5_noshield c_width=5u c_length=5u
X1705 z VSS cap_mim_2f0_m4m5_noshield c_width=5u c_length=5u
X1706 z VSS cap_mim_2f0_m4m5_noshield c_width=5u c_length=5u
X1707 z VSS cap_mim_2f0_m4m5_noshield c_width=5u c_length=5u
X1708 z VSS cap_mim_2f0_m4m5_noshield c_width=5u c_length=5u
X1709 z VSS cap_mim_2f0_m4m5_noshield c_width=5u c_length=5u
X1710 z VSS cap_mim_2f0_m4m5_noshield c_width=5u c_length=5u
X1711 z VSS cap_mim_2f0_m4m5_noshield c_width=5u c_length=5u
X1712 z VSS cap_mim_2f0_m4m5_noshield c_width=5u c_length=5u
X1713 z VSS cap_mim_2f0_m4m5_noshield c_width=5u c_length=5u
X1714 z VSS cap_mim_2f0_m4m5_noshield c_width=5u c_length=5u
X1715 z VSS cap_mim_2f0_m4m5_noshield c_width=5u c_length=5u
X1716 z VSS cap_mim_2f0_m4m5_noshield c_width=5u c_length=5u
X1717 z VSS cap_mim_2f0_m4m5_noshield c_width=5u c_length=5u
X1718 z VSS cap_mim_2f0_m4m5_noshield c_width=5u c_length=5u
X1719 z VSS cap_mim_2f0_m4m5_noshield c_width=5u c_length=5u
X1720 z VSS cap_mim_2f0_m4m5_noshield c_width=5u c_length=5u
X1721 z VSS cap_mim_2f0_m4m5_noshield c_width=5u c_length=5u
X1722 z VSS cap_mim_2f0_m4m5_noshield c_width=5u c_length=5u
X1723 z VSS cap_mim_2f0_m4m5_noshield c_width=5u c_length=5u
X1724 z VSS cap_mim_2f0_m4m5_noshield c_width=5u c_length=5u
X1725 z VSS cap_mim_2f0_m4m5_noshield c_width=5u c_length=5u
X1726 z VSS cap_mim_2f0_m4m5_noshield c_width=5u c_length=5u
X1727 z VSS cap_mim_2f0_m4m5_noshield c_width=5u c_length=5u
X1728 z VSS cap_mim_2f0_m4m5_noshield c_width=5u c_length=5u
X1729 z VSS cap_mim_2f0_m4m5_noshield c_width=5u c_length=5u
X1730 z VSS cap_mim_2f0_m4m5_noshield c_width=5u c_length=5u
X1731 z VSS cap_mim_2f0_m4m5_noshield c_width=5u c_length=5u
X1732 z VSS cap_mim_2f0_m4m5_noshield c_width=5u c_length=5u
X1733 z VSS cap_mim_2f0_m4m5_noshield c_width=5u c_length=5u
X1734 z VSS cap_mim_2f0_m4m5_noshield c_width=5u c_length=5u
X1735 z VSS cap_mim_2f0_m4m5_noshield c_width=5u c_length=5u
X1736 z VSS cap_mim_2f0_m4m5_noshield c_width=5u c_length=5u
X1737 z VSS cap_mim_2f0_m4m5_noshield c_width=5u c_length=5u
X1738 z VSS cap_mim_2f0_m4m5_noshield c_width=5u c_length=5u
X1739 z VSS cap_mim_2f0_m4m5_noshield c_width=5u c_length=5u
X1740 z VSS cap_mim_2f0_m4m5_noshield c_width=5u c_length=5u
X1741 z VSS cap_mim_2f0_m4m5_noshield c_width=5u c_length=5u
X1742 z VSS cap_mim_2f0_m4m5_noshield c_width=5u c_length=5u
X1743 z VSS cap_mim_2f0_m4m5_noshield c_width=5u c_length=5u
X1744 z VSS cap_mim_2f0_m4m5_noshield c_width=5u c_length=5u
X1745 z VSS cap_mim_2f0_m4m5_noshield c_width=5u c_length=5u
X1746 z VSS cap_mim_2f0_m4m5_noshield c_width=5u c_length=5u
X1747 z VSS cap_mim_2f0_m4m5_noshield c_width=5u c_length=5u
X1748 z VSS cap_mim_2f0_m4m5_noshield c_width=5u c_length=5u
X1749 z VSS cap_mim_2f0_m4m5_noshield c_width=5u c_length=5u
X1750 z VSS cap_mim_2f0_m4m5_noshield c_width=5u c_length=5u
X1751 z VSS cap_mim_2f0_m4m5_noshield c_width=5u c_length=5u
X1752 z VSS cap_mim_2f0_m4m5_noshield c_width=5u c_length=5u
X1753 z VSS cap_mim_2f0_m4m5_noshield c_width=5u c_length=5u
X1754 z VSS cap_mim_2f0_m4m5_noshield c_width=5u c_length=5u
X1755 z VSS cap_mim_2f0_m4m5_noshield c_width=5u c_length=5u
X1756 z VSS cap_mim_2f0_m4m5_noshield c_width=5u c_length=5u
X1757 z VSS cap_mim_2f0_m4m5_noshield c_width=5u c_length=5u
X1758 z VSS cap_mim_2f0_m4m5_noshield c_width=5u c_length=5u
X1759 z VSS cap_mim_2f0_m4m5_noshield c_width=5u c_length=5u
X1760 z VSS cap_mim_2f0_m4m5_noshield c_width=5u c_length=5u
X1761 z VSS cap_mim_2f0_m4m5_noshield c_width=5u c_length=5u
X1762 z VSS cap_mim_2f0_m4m5_noshield c_width=5u c_length=5u
X1763 z VSS cap_mim_2f0_m4m5_noshield c_width=5u c_length=5u
X1764 z VSS cap_mim_2f0_m4m5_noshield c_width=5u c_length=5u
X1765 z VSS cap_mim_2f0_m4m5_noshield c_width=5u c_length=5u
X1766 z VSS cap_mim_2f0_m4m5_noshield c_width=5u c_length=5u
X1767 z VSS cap_mim_2f0_m4m5_noshield c_width=5u c_length=5u
X1768 z VSS cap_mim_2f0_m4m5_noshield c_width=5u c_length=5u
X1769 z VSS cap_mim_2f0_m4m5_noshield c_width=5u c_length=5u
X1770 z VSS cap_mim_2f0_m4m5_noshield c_width=5u c_length=5u
X1771 z VSS cap_mim_2f0_m4m5_noshield c_width=5u c_length=5u
X1772 z VSS cap_mim_2f0_m4m5_noshield c_width=5u c_length=5u
X1773 z VSS cap_mim_2f0_m4m5_noshield c_width=5u c_length=5u
X1774 z VSS cap_mim_2f0_m4m5_noshield c_width=5u c_length=5u
X1775 z VSS cap_mim_2f0_m4m5_noshield c_width=5u c_length=5u
X1776 z VSS cap_mim_2f0_m4m5_noshield c_width=5u c_length=5u
X1777 z VSS cap_mim_2f0_m4m5_noshield c_width=5u c_length=5u
X1778 z VSS cap_mim_2f0_m4m5_noshield c_width=5u c_length=5u
X1779 z VSS cap_mim_2f0_m4m5_noshield c_width=5u c_length=5u
X1780 z VSS cap_mim_2f0_m4m5_noshield c_width=5u c_length=5u
X1781 z VSS cap_mim_2f0_m4m5_noshield c_width=5u c_length=5u
X1782 z VSS cap_mim_2f0_m4m5_noshield c_width=5u c_length=5u
X1783 z VSS cap_mim_2f0_m4m5_noshield c_width=5u c_length=5u
X1784 z VSS cap_mim_2f0_m4m5_noshield c_width=5u c_length=5u
X1785 z VSS cap_mim_2f0_m4m5_noshield c_width=5u c_length=5u
X1786 z VSS cap_mim_2f0_m4m5_noshield c_width=5u c_length=5u
X1787 z VSS cap_mim_2f0_m4m5_noshield c_width=5u c_length=5u
X1788 z VSS cap_mim_2f0_m4m5_noshield c_width=5u c_length=5u
X1789 z VSS cap_mim_2f0_m4m5_noshield c_width=5u c_length=5u
X1790 z VSS cap_mim_2f0_m4m5_noshield c_width=5u c_length=5u
X1791 z VSS cap_mim_2f0_m4m5_noshield c_width=5u c_length=5u
X1792 z VSS cap_mim_2f0_m4m5_noshield c_width=5u c_length=5u
X1793 z VSS cap_mim_2f0_m4m5_noshield c_width=5u c_length=5u
X1794 z VSS cap_mim_2f0_m4m5_noshield c_width=5u c_length=5u
X1795 z VSS cap_mim_2f0_m4m5_noshield c_width=5u c_length=5u
X1796 z VSS cap_mim_2f0_m4m5_noshield c_width=5u c_length=5u
X1797 z VSS cap_mim_2f0_m4m5_noshield c_width=5u c_length=5u
X1798 z VSS cap_mim_2f0_m4m5_noshield c_width=5u c_length=5u
X1799 z VSS cap_mim_2f0_m4m5_noshield c_width=5u c_length=5u
X1800 z VSS cap_mim_2f0_m4m5_noshield c_width=5u c_length=5u
X1801 z VSS cap_mim_2f0_m4m5_noshield c_width=5u c_length=5u
X1802 z VSS cap_mim_2f0_m4m5_noshield c_width=5u c_length=5u
X1803 z VSS cap_mim_2f0_m4m5_noshield c_width=5u c_length=5u
X1804 z VSS cap_mim_2f0_m4m5_noshield c_width=5u c_length=5u
X1805 z VSS cap_mim_2f0_m4m5_noshield c_width=5u c_length=5u
X1806 z VSS cap_mim_2f0_m4m5_noshield c_width=5u c_length=5u
X1807 z VSS cap_mim_2f0_m4m5_noshield c_width=5u c_length=5u
X1808 z VSS cap_mim_2f0_m4m5_noshield c_width=5u c_length=5u
X1809 z VSS cap_mim_2f0_m4m5_noshield c_width=5u c_length=5u
X1810 z VSS cap_mim_2f0_m4m5_noshield c_width=5u c_length=5u
X1811 z VSS cap_mim_2f0_m4m5_noshield c_width=5u c_length=5u
X1812 z VSS cap_mim_2f0_m4m5_noshield c_width=5u c_length=5u
X1813 z VSS cap_mim_2f0_m4m5_noshield c_width=5u c_length=5u
X1814 z VSS cap_mim_2f0_m4m5_noshield c_width=5u c_length=5u
X1815 z VSS cap_mim_2f0_m4m5_noshield c_width=5u c_length=5u
X1816 z VSS cap_mim_2f0_m4m5_noshield c_width=5u c_length=5u
X1817 z VSS cap_mim_2f0_m4m5_noshield c_width=5u c_length=5u
X1818 z VSS cap_mim_2f0_m4m5_noshield c_width=5u c_length=5u
X1819 z VSS cap_mim_2f0_m4m5_noshield c_width=5u c_length=5u
X1820 z VSS cap_mim_2f0_m4m5_noshield c_width=5u c_length=5u
X1821 z VSS cap_mim_2f0_m4m5_noshield c_width=5u c_length=5u
X1822 z VSS cap_mim_2f0_m4m5_noshield c_width=5u c_length=5u
X1823 z VSS cap_mim_2f0_m4m5_noshield c_width=5u c_length=5u
X1824 z VSS cap_mim_2f0_m4m5_noshield c_width=5u c_length=5u
X1825 z VSS cap_mim_2f0_m4m5_noshield c_width=5u c_length=5u
X1826 z VSS cap_mim_2f0_m4m5_noshield c_width=5u c_length=5u
X1827 z VSS cap_mim_2f0_m4m5_noshield c_width=5u c_length=5u
X1828 z VSS cap_mim_2f0_m4m5_noshield c_width=5u c_length=5u
X1829 z VSS cap_mim_2f0_m4m5_noshield c_width=5u c_length=5u
X1830 z VSS cap_mim_2f0_m4m5_noshield c_width=5u c_length=5u
X1831 z VSS cap_mim_2f0_m4m5_noshield c_width=5u c_length=5u
X1832 z VSS cap_mim_2f0_m4m5_noshield c_width=5u c_length=5u
X1833 z VSS cap_mim_2f0_m4m5_noshield c_width=5u c_length=5u
X1834 z VSS cap_mim_2f0_m4m5_noshield c_width=5u c_length=5u
X1835 z VSS cap_mim_2f0_m4m5_noshield c_width=5u c_length=5u
X1836 z VSS cap_mim_2f0_m4m5_noshield c_width=5u c_length=5u
X1837 z VSS cap_mim_2f0_m4m5_noshield c_width=5u c_length=5u
X1838 z VSS cap_mim_2f0_m4m5_noshield c_width=5u c_length=5u
X1839 z VSS cap_mim_2f0_m4m5_noshield c_width=5u c_length=5u
X1840 z VSS cap_mim_2f0_m4m5_noshield c_width=5u c_length=5u
X1841 z VSS cap_mim_2f0_m4m5_noshield c_width=5u c_length=5u
X1842 z VSS cap_mim_2f0_m4m5_noshield c_width=5u c_length=5u
X1843 z VSS cap_mim_2f0_m4m5_noshield c_width=5u c_length=5u
X1844 z VSS cap_mim_2f0_m4m5_noshield c_width=5u c_length=5u
X1845 z VSS cap_mim_2f0_m4m5_noshield c_width=5u c_length=5u
X1846 z VSS cap_mim_2f0_m4m5_noshield c_width=5u c_length=5u
X1847 z VSS cap_mim_2f0_m4m5_noshield c_width=5u c_length=5u
X1848 z VSS cap_mim_2f0_m4m5_noshield c_width=5u c_length=5u
X1849 z VSS cap_mim_2f0_m4m5_noshield c_width=5u c_length=5u
X1850 z VSS cap_mim_2f0_m4m5_noshield c_width=5u c_length=5u
X1851 z VSS cap_mim_2f0_m4m5_noshield c_width=5u c_length=5u
X1852 z VSS cap_mim_2f0_m4m5_noshield c_width=5u c_length=5u
X1853 z VSS cap_mim_2f0_m4m5_noshield c_width=5u c_length=5u
X1854 z VSS cap_mim_2f0_m4m5_noshield c_width=5u c_length=5u
X1855 z VSS cap_mim_2f0_m4m5_noshield c_width=5u c_length=5u
X1856 z VSS cap_mim_2f0_m4m5_noshield c_width=5u c_length=5u
X1857 z VSS cap_mim_2f0_m4m5_noshield c_width=5u c_length=5u
X1858 z VSS cap_mim_2f0_m4m5_noshield c_width=5u c_length=5u
X1859 z VSS cap_mim_2f0_m4m5_noshield c_width=5u c_length=5u
X1860 z VSS cap_mim_2f0_m4m5_noshield c_width=5u c_length=5u
X1861 z VSS cap_mim_2f0_m4m5_noshield c_width=5u c_length=5u
X1862 z VSS cap_mim_2f0_m4m5_noshield c_width=5u c_length=5u
X1863 z VSS cap_mim_2f0_m4m5_noshield c_width=5u c_length=5u
X1864 z VSS cap_mim_2f0_m4m5_noshield c_width=5u c_length=5u
X1865 z VSS cap_mim_2f0_m4m5_noshield c_width=5u c_length=5u
X1866 z VSS cap_mim_2f0_m4m5_noshield c_width=5u c_length=5u
X1867 z VSS cap_mim_2f0_m4m5_noshield c_width=5u c_length=5u
X1868 z VSS cap_mim_2f0_m4m5_noshield c_width=5u c_length=5u
X1869 z VSS cap_mim_2f0_m4m5_noshield c_width=5u c_length=5u
X1870 z VSS cap_mim_2f0_m4m5_noshield c_width=5u c_length=5u
X1871 z VSS cap_mim_2f0_m4m5_noshield c_width=5u c_length=5u
X1872 z VSS cap_mim_2f0_m4m5_noshield c_width=5u c_length=5u
X1873 z VSS cap_mim_2f0_m4m5_noshield c_width=5u c_length=5u
X1874 z VSS cap_mim_2f0_m4m5_noshield c_width=5u c_length=5u
X1875 z VSS cap_mim_2f0_m4m5_noshield c_width=5u c_length=5u
X1876 z VSS cap_mim_2f0_m4m5_noshield c_width=5u c_length=5u
X1877 z VSS cap_mim_2f0_m4m5_noshield c_width=5u c_length=5u
X1878 z VSS cap_mim_2f0_m4m5_noshield c_width=5u c_length=5u
X1879 z VSS cap_mim_2f0_m4m5_noshield c_width=5u c_length=5u
X1880 z VSS cap_mim_2f0_m4m5_noshield c_width=5u c_length=5u
X1881 z VSS cap_mim_2f0_m4m5_noshield c_width=5u c_length=5u
X1882 z VSS cap_mim_2f0_m4m5_noshield c_width=5u c_length=5u
X1883 z VSS cap_mim_2f0_m4m5_noshield c_width=5u c_length=5u
X1884 z VSS cap_mim_2f0_m4m5_noshield c_width=5u c_length=5u
X1885 z VSS cap_mim_2f0_m4m5_noshield c_width=5u c_length=5u
X1886 z VSS cap_mim_2f0_m4m5_noshield c_width=5u c_length=5u
X1887 z VSS cap_mim_2f0_m4m5_noshield c_width=5u c_length=5u
X1888 z VSS cap_mim_2f0_m4m5_noshield c_width=5u c_length=5u
X1889 z VSS cap_mim_2f0_m4m5_noshield c_width=5u c_length=5u
X1890 z VSS cap_mim_2f0_m4m5_noshield c_width=5u c_length=5u
X1891 z VSS cap_mim_2f0_m4m5_noshield c_width=5u c_length=5u
X1892 z VSS cap_mim_2f0_m4m5_noshield c_width=5u c_length=5u
X1893 z VSS cap_mim_2f0_m4m5_noshield c_width=5u c_length=5u
X1894 z VSS cap_mim_2f0_m4m5_noshield c_width=5u c_length=5u
X1895 z VSS cap_mim_2f0_m4m5_noshield c_width=5u c_length=5u
X1896 z VSS cap_mim_2f0_m4m5_noshield c_width=5u c_length=5u
X1897 z VSS cap_mim_2f0_m4m5_noshield c_width=5u c_length=5u
X1898 z VSS cap_mim_2f0_m4m5_noshield c_width=5u c_length=5u
X1899 z VSS cap_mim_2f0_m4m5_noshield c_width=5u c_length=5u
X1900 z VSS cap_mim_2f0_m4m5_noshield c_width=5u c_length=5u
X1901 z VSS cap_mim_2f0_m4m5_noshield c_width=5u c_length=5u
X1902 z VSS cap_mim_2f0_m4m5_noshield c_width=5u c_length=5u
X1903 z VSS cap_mim_2f0_m4m5_noshield c_width=5u c_length=5u
X1904 z VSS cap_mim_2f0_m4m5_noshield c_width=5u c_length=5u
X1905 z VSS cap_mim_2f0_m4m5_noshield c_width=5u c_length=5u
X1906 z VSS cap_mim_2f0_m4m5_noshield c_width=5u c_length=5u
X1907 z VSS cap_mim_2f0_m4m5_noshield c_width=5u c_length=5u
X1908 z VSS cap_mim_2f0_m4m5_noshield c_width=5u c_length=5u
X1909 z VSS cap_mim_2f0_m4m5_noshield c_width=5u c_length=5u
X1910 z VSS cap_mim_2f0_m4m5_noshield c_width=5u c_length=5u
X1911 z VSS cap_mim_2f0_m4m5_noshield c_width=5u c_length=5u
X1912 z VSS cap_mim_2f0_m4m5_noshield c_width=5u c_length=5u
X1913 z VSS cap_mim_2f0_m4m5_noshield c_width=5u c_length=5u
X1914 z VSS cap_mim_2f0_m4m5_noshield c_width=5u c_length=5u
X1915 z VSS cap_mim_2f0_m4m5_noshield c_width=5u c_length=5u
X1916 z VSS cap_mim_2f0_m4m5_noshield c_width=5u c_length=5u
X1917 z VSS cap_mim_2f0_m4m5_noshield c_width=5u c_length=5u
X1918 z VSS cap_mim_2f0_m4m5_noshield c_width=5u c_length=5u
X1919 z VSS cap_mim_2f0_m4m5_noshield c_width=5u c_length=5u
X1920 z VSS cap_mim_2f0_m4m5_noshield c_width=5u c_length=5u
X1921 z VSS cap_mim_2f0_m4m5_noshield c_width=5u c_length=5u
X1922 z VSS cap_mim_2f0_m4m5_noshield c_width=5u c_length=5u
X1923 z VSS cap_mim_2f0_m4m5_noshield c_width=5u c_length=5u
X1924 z VSS cap_mim_2f0_m4m5_noshield c_width=5u c_length=5u
X1925 z VSS cap_mim_2f0_m4m5_noshield c_width=5u c_length=5u
X1926 z VSS cap_mim_2f0_m4m5_noshield c_width=5u c_length=5u
X1927 z VSS cap_mim_2f0_m4m5_noshield c_width=5u c_length=5u
X1928 z VSS cap_mim_2f0_m4m5_noshield c_width=5u c_length=5u
X1929 z VSS cap_mim_2f0_m4m5_noshield c_width=5u c_length=5u
X1930 z VSS cap_mim_2f0_m4m5_noshield c_width=5u c_length=5u
X1931 z VSS cap_mim_2f0_m4m5_noshield c_width=5u c_length=5u
X1932 z VSS cap_mim_2f0_m4m5_noshield c_width=5u c_length=5u
X1933 z VSS cap_mim_2f0_m4m5_noshield c_width=5u c_length=5u
X1934 z VSS cap_mim_2f0_m4m5_noshield c_width=5u c_length=5u
X1935 z VSS cap_mim_2f0_m4m5_noshield c_width=5u c_length=5u
X1936 z VSS cap_mim_2f0_m4m5_noshield c_width=5u c_length=5u
X1937 z VSS cap_mim_2f0_m4m5_noshield c_width=5u c_length=5u
X1938 z VSS cap_mim_2f0_m4m5_noshield c_width=5u c_length=5u
X1939 z VSS cap_mim_2f0_m4m5_noshield c_width=5u c_length=5u
X1940 z VSS cap_mim_2f0_m4m5_noshield c_width=5u c_length=5u
X1941 z VSS cap_mim_2f0_m4m5_noshield c_width=5u c_length=5u
X1942 z VSS cap_mim_2f0_m4m5_noshield c_width=5u c_length=5u
X1943 z VSS cap_mim_2f0_m4m5_noshield c_width=5u c_length=5u
X1944 z VSS cap_mim_2f0_m4m5_noshield c_width=5u c_length=5u
X1945 z VSS cap_mim_2f0_m4m5_noshield c_width=5u c_length=5u
X1946 z VSS cap_mim_2f0_m4m5_noshield c_width=5u c_length=5u
X1947 z VSS cap_mim_2f0_m4m5_noshield c_width=5u c_length=5u
X1948 z VSS cap_mim_2f0_m4m5_noshield c_width=5u c_length=5u
X1949 z VSS cap_mim_2f0_m4m5_noshield c_width=5u c_length=5u
X1950 z VSS cap_mim_2f0_m4m5_noshield c_width=5u c_length=5u
X1951 z VSS cap_mim_2f0_m4m5_noshield c_width=5u c_length=5u
X1952 z VSS cap_mim_2f0_m4m5_noshield c_width=5u c_length=5u
X1953 z VSS cap_mim_2f0_m4m5_noshield c_width=5u c_length=5u
X1954 z VSS cap_mim_2f0_m4m5_noshield c_width=5u c_length=5u
X1955 z VSS cap_mim_2f0_m4m5_noshield c_width=5u c_length=5u
X1956 z VSS cap_mim_2f0_m4m5_noshield c_width=5u c_length=5u
X1957 z VSS cap_mim_2f0_m4m5_noshield c_width=5u c_length=5u
X1958 z VSS cap_mim_2f0_m4m5_noshield c_width=5u c_length=5u
X1959 z VSS cap_mim_2f0_m4m5_noshield c_width=5u c_length=5u
X1960 z VSS cap_mim_2f0_m4m5_noshield c_width=5u c_length=5u
X1961 z VSS cap_mim_2f0_m4m5_noshield c_width=5u c_length=5u
X1962 z VSS cap_mim_2f0_m4m5_noshield c_width=5u c_length=5u
X1963 z VSS cap_mim_2f0_m4m5_noshield c_width=5u c_length=5u
X1964 z VSS cap_mim_2f0_m4m5_noshield c_width=5u c_length=5u
X1965 z VSS cap_mim_2f0_m4m5_noshield c_width=5u c_length=5u
X1966 z VSS cap_mim_2f0_m4m5_noshield c_width=5u c_length=5u
X1967 z VSS cap_mim_2f0_m4m5_noshield c_width=5u c_length=5u
X1968 z VSS cap_mim_2f0_m4m5_noshield c_width=5u c_length=5u
X1969 z VSS cap_mim_2f0_m4m5_noshield c_width=5u c_length=5u
X1970 z VSS cap_mim_2f0_m4m5_noshield c_width=5u c_length=5u
X1971 z VSS cap_mim_2f0_m4m5_noshield c_width=5u c_length=5u
X1972 z VSS cap_mim_2f0_m4m5_noshield c_width=5u c_length=5u
X1973 z VSS cap_mim_2f0_m4m5_noshield c_width=5u c_length=5u
X1974 z VSS cap_mim_2f0_m4m5_noshield c_width=5u c_length=5u
X1975 z VSS cap_mim_2f0_m4m5_noshield c_width=5u c_length=5u
X1976 z VSS cap_mim_2f0_m4m5_noshield c_width=5u c_length=5u
X1977 z VSS cap_mim_2f0_m4m5_noshield c_width=5u c_length=5u
X1978 z VSS cap_mim_2f0_m4m5_noshield c_width=5u c_length=5u
X1979 z VSS cap_mim_2f0_m4m5_noshield c_width=5u c_length=5u
X1980 z VSS cap_mim_2f0_m4m5_noshield c_width=5u c_length=5u
X1981 z VSS cap_mim_2f0_m4m5_noshield c_width=5u c_length=5u
X1982 z VSS cap_mim_2f0_m4m5_noshield c_width=5u c_length=5u
X1983 z VSS cap_mim_2f0_m4m5_noshield c_width=5u c_length=5u
X1984 z VSS cap_mim_2f0_m4m5_noshield c_width=5u c_length=5u
X1985 z VSS cap_mim_2f0_m4m5_noshield c_width=5u c_length=5u
X1986 z VSS cap_mim_2f0_m4m5_noshield c_width=5u c_length=5u
X1987 z VSS cap_mim_2f0_m4m5_noshield c_width=5u c_length=5u
X1988 z VSS cap_mim_2f0_m4m5_noshield c_width=5u c_length=5u
X1989 z VSS cap_mim_2f0_m4m5_noshield c_width=5u c_length=5u
X1990 z VSS cap_mim_2f0_m4m5_noshield c_width=5u c_length=5u
X1991 z VSS cap_mim_2f0_m4m5_noshield c_width=5u c_length=5u
X1992 z VSS cap_mim_2f0_m4m5_noshield c_width=5u c_length=5u
X1993 z VSS cap_mim_2f0_m4m5_noshield c_width=5u c_length=5u
X1994 z VSS cap_mim_2f0_m4m5_noshield c_width=5u c_length=5u
X1995 z VSS cap_mim_2f0_m4m5_noshield c_width=5u c_length=5u
X1996 z VSS cap_mim_2f0_m4m5_noshield c_width=5u c_length=5u
X1997 z VSS cap_mim_2f0_m4m5_noshield c_width=5u c_length=5u
X1998 z VSS cap_mim_2f0_m4m5_noshield c_width=5u c_length=5u
X1999 z VSS cap_mim_2f0_m4m5_noshield c_width=5u c_length=5u
X2000 z VSS cap_mim_2f0_m4m5_noshield c_width=5u c_length=5u
X2001 z VSS cap_mim_2f0_m4m5_noshield c_width=5u c_length=5u
X2002 z VSS cap_mim_2f0_m4m5_noshield c_width=5u c_length=5u
X2003 z VSS cap_mim_2f0_m4m5_noshield c_width=5u c_length=5u
X2004 z VSS cap_mim_2f0_m4m5_noshield c_width=5u c_length=5u
X2005 z VSS cap_mim_2f0_m4m5_noshield c_width=5u c_length=5u
X2006 z VSS cap_mim_2f0_m4m5_noshield c_width=5u c_length=5u
X2007 z VSS cap_mim_2f0_m4m5_noshield c_width=5u c_length=5u
X2008 z VSS cap_mim_2f0_m4m5_noshield c_width=5u c_length=5u
X2009 z VSS cap_mim_2f0_m4m5_noshield c_width=5u c_length=5u
X2010 z VSS cap_mim_2f0_m4m5_noshield c_width=5u c_length=5u
X2011 z VSS cap_mim_2f0_m4m5_noshield c_width=5u c_length=5u
X2012 z VSS cap_mim_2f0_m4m5_noshield c_width=5u c_length=5u
X2013 z VSS cap_mim_2f0_m4m5_noshield c_width=5u c_length=5u
X2014 z VSS cap_mim_2f0_m4m5_noshield c_width=5u c_length=5u
X2015 z VSS cap_mim_2f0_m4m5_noshield c_width=5u c_length=5u
X2016 z VSS cap_mim_2f0_m4m5_noshield c_width=5u c_length=5u
X2017 z VSS cap_mim_2f0_m4m5_noshield c_width=5u c_length=5u
X2018 z VSS cap_mim_2f0_m4m5_noshield c_width=5u c_length=5u
X2019 z VSS cap_mim_2f0_m4m5_noshield c_width=5u c_length=5u
X2020 z VSS cap_mim_2f0_m4m5_noshield c_width=5u c_length=5u
X2021 z VSS cap_mim_2f0_m4m5_noshield c_width=5u c_length=5u
X2022 z VSS cap_mim_2f0_m4m5_noshield c_width=5u c_length=5u
X2023 z VSS cap_mim_2f0_m4m5_noshield c_width=5u c_length=5u
X2024 z VSS cap_mim_2f0_m4m5_noshield c_width=5u c_length=5u
X2025 z VSS cap_mim_2f0_m4m5_noshield c_width=5u c_length=5u
X2026 z VSS cap_mim_2f0_m4m5_noshield c_width=5u c_length=5u
X2027 z VSS cap_mim_2f0_m4m5_noshield c_width=5u c_length=5u
X2028 z VSS cap_mim_2f0_m4m5_noshield c_width=5u c_length=5u
X2029 z VSS cap_mim_2f0_m4m5_noshield c_width=5u c_length=5u
X2030 z VSS cap_mim_2f0_m4m5_noshield c_width=5u c_length=5u
X2031 z VSS cap_mim_2f0_m4m5_noshield c_width=5u c_length=5u
X2032 z VSS cap_mim_2f0_m4m5_noshield c_width=5u c_length=5u
X2033 z VSS cap_mim_2f0_m4m5_noshield c_width=5u c_length=5u
X2034 z VSS cap_mim_2f0_m4m5_noshield c_width=5u c_length=5u
X2035 z VSS cap_mim_2f0_m4m5_noshield c_width=5u c_length=5u
X2036 z VSS cap_mim_2f0_m4m5_noshield c_width=5u c_length=5u
X2037 z VSS cap_mim_2f0_m4m5_noshield c_width=5u c_length=5u
X2038 z VSS cap_mim_2f0_m4m5_noshield c_width=5u c_length=5u
X2039 z VSS cap_mim_2f0_m4m5_noshield c_width=5u c_length=5u
X2040 z VSS cap_mim_2f0_m4m5_noshield c_width=5u c_length=5u
X2041 z VSS cap_mim_2f0_m4m5_noshield c_width=5u c_length=5u
X2042 z VSS cap_mim_2f0_m4m5_noshield c_width=5u c_length=5u
X2043 z VSS cap_mim_2f0_m4m5_noshield c_width=5u c_length=5u
X2044 z VSS cap_mim_2f0_m4m5_noshield c_width=5u c_length=5u
X2045 z VSS cap_mim_2f0_m4m5_noshield c_width=5u c_length=5u
X2046 z VSS cap_mim_2f0_m4m5_noshield c_width=5u c_length=5u
X2047 z VSS cap_mim_2f0_m4m5_noshield c_width=5u c_length=5u
X2048 z VSS cap_mim_2f0_m4m5_noshield c_width=5u c_length=5u
X2049 z VSS cap_mim_2f0_m4m5_noshield c_width=5u c_length=5u
X2050 z VSS cap_mim_2f0_m4m5_noshield c_width=5u c_length=5u
X2051 z VSS cap_mim_2f0_m4m5_noshield c_width=5u c_length=5u
X2052 z VSS cap_mim_2f0_m4m5_noshield c_width=5u c_length=5u
X2053 z VSS cap_mim_2f0_m4m5_noshield c_width=5u c_length=5u
X2054 z VSS cap_mim_2f0_m4m5_noshield c_width=5u c_length=5u
X2055 z VSS cap_mim_2f0_m4m5_noshield c_width=5u c_length=5u
X2056 z VSS cap_mim_2f0_m4m5_noshield c_width=5u c_length=5u
X2057 z VSS cap_mim_2f0_m4m5_noshield c_width=5u c_length=5u
X2058 z VSS cap_mim_2f0_m4m5_noshield c_width=5u c_length=5u
X2059 z VSS cap_mim_2f0_m4m5_noshield c_width=5u c_length=5u
X2060 z VSS cap_mim_2f0_m4m5_noshield c_width=5u c_length=5u
X2061 z VSS cap_mim_2f0_m4m5_noshield c_width=5u c_length=5u
X2062 z VSS cap_mim_2f0_m4m5_noshield c_width=5u c_length=5u
X2063 z VSS cap_mim_2f0_m4m5_noshield c_width=5u c_length=5u
X2064 z VSS cap_mim_2f0_m4m5_noshield c_width=5u c_length=5u
X2065 z VSS cap_mim_2f0_m4m5_noshield c_width=5u c_length=5u
X2066 z VSS cap_mim_2f0_m4m5_noshield c_width=5u c_length=5u
X2067 z VSS cap_mim_2f0_m4m5_noshield c_width=5u c_length=5u
X2068 z VSS cap_mim_2f0_m4m5_noshield c_width=5u c_length=5u
X2069 z VSS cap_mim_2f0_m4m5_noshield c_width=5u c_length=5u
X2070 z VSS cap_mim_2f0_m4m5_noshield c_width=5u c_length=5u
X2071 z VSS cap_mim_2f0_m4m5_noshield c_width=5u c_length=5u
X2072 z VSS cap_mim_2f0_m4m5_noshield c_width=5u c_length=5u
X2073 z VSS cap_mim_2f0_m4m5_noshield c_width=5u c_length=5u
X2074 z VSS cap_mim_2f0_m4m5_noshield c_width=5u c_length=5u
X2075 z VSS cap_mim_2f0_m4m5_noshield c_width=5u c_length=5u
X2076 z VSS cap_mim_2f0_m4m5_noshield c_width=5u c_length=5u
X2077 z VSS cap_mim_2f0_m4m5_noshield c_width=5u c_length=5u
X2078 z VSS cap_mim_2f0_m4m5_noshield c_width=5u c_length=5u
X2079 z VSS cap_mim_2f0_m4m5_noshield c_width=5u c_length=5u
X2080 z VSS cap_mim_2f0_m4m5_noshield c_width=5u c_length=5u
X2081 z VSS cap_mim_2f0_m4m5_noshield c_width=5u c_length=5u
X2082 z VSS cap_mim_2f0_m4m5_noshield c_width=5u c_length=5u
X2083 z VSS cap_mim_2f0_m4m5_noshield c_width=5u c_length=5u
X2084 z VSS cap_mim_2f0_m4m5_noshield c_width=5u c_length=5u
X2085 z VSS cap_mim_2f0_m4m5_noshield c_width=5u c_length=5u
X2086 z VSS cap_mim_2f0_m4m5_noshield c_width=5u c_length=5u
X2087 z VSS cap_mim_2f0_m4m5_noshield c_width=5u c_length=5u
X2088 z VSS cap_mim_2f0_m4m5_noshield c_width=5u c_length=5u
X2089 z VSS cap_mim_2f0_m4m5_noshield c_width=5u c_length=5u
X2090 z VSS cap_mim_2f0_m4m5_noshield c_width=5u c_length=5u
X2091 z VSS cap_mim_2f0_m4m5_noshield c_width=5u c_length=5u
X2092 z VSS cap_mim_2f0_m4m5_noshield c_width=5u c_length=5u
X2093 z VSS cap_mim_2f0_m4m5_noshield c_width=5u c_length=5u
X2094 z VSS cap_mim_2f0_m4m5_noshield c_width=5u c_length=5u
X2095 z VSS cap_mim_2f0_m4m5_noshield c_width=5u c_length=5u
X2096 z VSS cap_mim_2f0_m4m5_noshield c_width=5u c_length=5u
X2097 z VSS cap_mim_2f0_m4m5_noshield c_width=5u c_length=5u
X2098 z VSS cap_mim_2f0_m4m5_noshield c_width=5u c_length=5u
X2099 z VSS cap_mim_2f0_m4m5_noshield c_width=5u c_length=5u
X2100 z VSS cap_mim_2f0_m4m5_noshield c_width=5u c_length=5u
X2101 z VSS cap_mim_2f0_m4m5_noshield c_width=5u c_length=5u
X2102 z VSS cap_mim_2f0_m4m5_noshield c_width=5u c_length=5u
X2103 z VSS cap_mim_2f0_m4m5_noshield c_width=5u c_length=5u
X2104 z VSS cap_mim_2f0_m4m5_noshield c_width=5u c_length=5u
X2105 z VSS cap_mim_2f0_m4m5_noshield c_width=5u c_length=5u
X2106 z VSS cap_mim_2f0_m4m5_noshield c_width=5u c_length=5u
X2107 z VSS cap_mim_2f0_m4m5_noshield c_width=5u c_length=5u
X2108 z VSS cap_mim_2f0_m4m5_noshield c_width=5u c_length=5u
X2109 z VSS cap_mim_2f0_m4m5_noshield c_width=5u c_length=5u
X2110 z VSS cap_mim_2f0_m4m5_noshield c_width=5u c_length=5u
X2111 z VSS cap_mim_2f0_m4m5_noshield c_width=5u c_length=5u
X2112 z VSS cap_mim_2f0_m4m5_noshield c_width=5u c_length=5u
X2113 z VSS cap_mim_2f0_m4m5_noshield c_width=5u c_length=5u
X2114 z VSS cap_mim_2f0_m4m5_noshield c_width=5u c_length=5u
X2115 z VSS cap_mim_2f0_m4m5_noshield c_width=5u c_length=5u
X2116 z VSS cap_mim_2f0_m4m5_noshield c_width=5u c_length=5u
X2117 z VSS cap_mim_2f0_m4m5_noshield c_width=5u c_length=5u
X2118 z VSS cap_mim_2f0_m4m5_noshield c_width=5u c_length=5u
X2119 z VSS cap_mim_2f0_m4m5_noshield c_width=5u c_length=5u
X2120 z VSS cap_mim_2f0_m4m5_noshield c_width=5u c_length=5u
X2121 z VSS cap_mim_2f0_m4m5_noshield c_width=5u c_length=5u
X2122 z VSS cap_mim_2f0_m4m5_noshield c_width=5u c_length=5u
X2123 z VSS cap_mim_2f0_m4m5_noshield c_width=5u c_length=5u
X2124 z VSS cap_mim_2f0_m4m5_noshield c_width=5u c_length=5u
X2125 z VSS cap_mim_2f0_m4m5_noshield c_width=5u c_length=5u
X2126 z VSS cap_mim_2f0_m4m5_noshield c_width=5u c_length=5u
X2127 z VSS cap_mim_2f0_m4m5_noshield c_width=5u c_length=5u
X2128 z VSS cap_mim_2f0_m4m5_noshield c_width=5u c_length=5u
X2129 z VSS cap_mim_2f0_m4m5_noshield c_width=5u c_length=5u
X2130 z VSS cap_mim_2f0_m4m5_noshield c_width=5u c_length=5u
X2131 z VSS cap_mim_2f0_m4m5_noshield c_width=5u c_length=5u
X2132 z VSS cap_mim_2f0_m4m5_noshield c_width=5u c_length=5u
X2133 z VSS cap_mim_2f0_m4m5_noshield c_width=5u c_length=5u
X2134 z VSS cap_mim_2f0_m4m5_noshield c_width=5u c_length=5u
X2135 z VSS cap_mim_2f0_m4m5_noshield c_width=5u c_length=5u
X2136 z VSS cap_mim_2f0_m4m5_noshield c_width=5u c_length=5u
X2137 z VSS cap_mim_2f0_m4m5_noshield c_width=5u c_length=5u
X2138 z VSS cap_mim_2f0_m4m5_noshield c_width=5u c_length=5u
X2139 z VSS cap_mim_2f0_m4m5_noshield c_width=5u c_length=5u
X2140 z VSS cap_mim_2f0_m4m5_noshield c_width=5u c_length=5u
X2141 z VSS cap_mim_2f0_m4m5_noshield c_width=5u c_length=5u
X2142 z VSS cap_mim_2f0_m4m5_noshield c_width=5u c_length=5u
X2143 z VSS cap_mim_2f0_m4m5_noshield c_width=5u c_length=5u
X2144 z VSS cap_mim_2f0_m4m5_noshield c_width=5u c_length=5u
X2145 z VSS cap_mim_2f0_m4m5_noshield c_width=5u c_length=5u
X2146 z VSS cap_mim_2f0_m4m5_noshield c_width=5u c_length=5u
X2147 z VSS cap_mim_2f0_m4m5_noshield c_width=5u c_length=5u
X2148 z VSS cap_mim_2f0_m4m5_noshield c_width=5u c_length=5u
X2149 z VSS cap_mim_2f0_m4m5_noshield c_width=5u c_length=5u
X2150 z VSS cap_mim_2f0_m4m5_noshield c_width=5u c_length=5u
X2151 z VSS cap_mim_2f0_m4m5_noshield c_width=5u c_length=5u
X2152 z VSS cap_mim_2f0_m4m5_noshield c_width=5u c_length=5u
X2153 z VSS cap_mim_2f0_m4m5_noshield c_width=5u c_length=5u
X2154 z VSS cap_mim_2f0_m4m5_noshield c_width=5u c_length=5u
X2155 z VSS cap_mim_2f0_m4m5_noshield c_width=5u c_length=5u
X2156 z VSS cap_mim_2f0_m4m5_noshield c_width=5u c_length=5u
X2157 z VSS cap_mim_2f0_m4m5_noshield c_width=5u c_length=5u
X2158 z VSS cap_mim_2f0_m4m5_noshield c_width=5u c_length=5u
X2159 z VSS cap_mim_2f0_m4m5_noshield c_width=5u c_length=5u
X2160 z VSS cap_mim_2f0_m4m5_noshield c_width=5u c_length=5u
X2161 z VSS cap_mim_2f0_m4m5_noshield c_width=5u c_length=5u
X2162 z VSS cap_mim_2f0_m4m5_noshield c_width=5u c_length=5u
X2163 z VSS cap_mim_2f0_m4m5_noshield c_width=5u c_length=5u
X2164 z VSS cap_mim_2f0_m4m5_noshield c_width=5u c_length=5u
X2165 z VSS cap_mim_2f0_m4m5_noshield c_width=5u c_length=5u
X2166 z VSS cap_mim_2f0_m4m5_noshield c_width=5u c_length=5u
X2167 z VSS cap_mim_2f0_m4m5_noshield c_width=5u c_length=5u
X2168 z VSS cap_mim_2f0_m4m5_noshield c_width=5u c_length=5u
X2169 z VSS cap_mim_2f0_m4m5_noshield c_width=5u c_length=5u
X2170 z VSS cap_mim_2f0_m4m5_noshield c_width=5u c_length=5u
X2171 z VSS cap_mim_2f0_m4m5_noshield c_width=5u c_length=5u
X2172 z VSS cap_mim_2f0_m4m5_noshield c_width=5u c_length=5u
X2173 z VSS cap_mim_2f0_m4m5_noshield c_width=5u c_length=5u
X2174 z VSS cap_mim_2f0_m4m5_noshield c_width=5u c_length=5u
X2175 z VSS cap_mim_2f0_m4m5_noshield c_width=5u c_length=5u
X2176 z VSS cap_mim_2f0_m4m5_noshield c_width=5u c_length=5u
X2177 z VSS cap_mim_2f0_m4m5_noshield c_width=5u c_length=5u
X2178 z VSS cap_mim_2f0_m4m5_noshield c_width=5u c_length=5u
X2179 z VSS cap_mim_2f0_m4m5_noshield c_width=5u c_length=5u
X2180 z VSS cap_mim_2f0_m4m5_noshield c_width=5u c_length=5u
X2181 z VSS cap_mim_2f0_m4m5_noshield c_width=5u c_length=5u
X2182 z VSS cap_mim_2f0_m4m5_noshield c_width=5u c_length=5u
X2183 z VSS cap_mim_2f0_m4m5_noshield c_width=5u c_length=5u
X2184 z VSS cap_mim_2f0_m4m5_noshield c_width=5u c_length=5u
X2185 z VSS cap_mim_2f0_m4m5_noshield c_width=5u c_length=5u
X2186 z VSS cap_mim_2f0_m4m5_noshield c_width=5u c_length=5u
X2187 z VSS cap_mim_2f0_m4m5_noshield c_width=5u c_length=5u
X2188 z VSS cap_mim_2f0_m4m5_noshield c_width=5u c_length=5u
X2189 z VSS cap_mim_2f0_m4m5_noshield c_width=5u c_length=5u
X2190 z VSS cap_mim_2f0_m4m5_noshield c_width=5u c_length=5u
X2191 z VSS cap_mim_2f0_m4m5_noshield c_width=5u c_length=5u
X2192 z VSS cap_mim_2f0_m4m5_noshield c_width=5u c_length=5u
X2193 z VSS cap_mim_2f0_m4m5_noshield c_width=5u c_length=5u
X2194 z VSS cap_mim_2f0_m4m5_noshield c_width=5u c_length=5u
X2195 z VSS cap_mim_2f0_m4m5_noshield c_width=5u c_length=5u
X2196 z VSS cap_mim_2f0_m4m5_noshield c_width=5u c_length=5u
X2197 z VSS cap_mim_2f0_m4m5_noshield c_width=5u c_length=5u
X2198 z VSS cap_mim_2f0_m4m5_noshield c_width=5u c_length=5u
X2199 z VSS cap_mim_2f0_m4m5_noshield c_width=5u c_length=5u
X2200 z VSS cap_mim_2f0_m4m5_noshield c_width=5u c_length=5u
X2201 z VSS cap_mim_2f0_m4m5_noshield c_width=5u c_length=5u
X2202 z VSS cap_mim_2f0_m4m5_noshield c_width=5u c_length=5u
X2203 z VSS cap_mim_2f0_m4m5_noshield c_width=5u c_length=5u
X2204 z VSS cap_mim_2f0_m4m5_noshield c_width=5u c_length=5u
X2205 z VSS cap_mim_2f0_m4m5_noshield c_width=5u c_length=5u
X2206 z VSS cap_mim_2f0_m4m5_noshield c_width=5u c_length=5u
X2207 z VSS cap_mim_2f0_m4m5_noshield c_width=5u c_length=5u
X2208 z VSS cap_mim_2f0_m4m5_noshield c_width=5u c_length=5u
X2209 z VSS cap_mim_2f0_m4m5_noshield c_width=5u c_length=5u
X2210 z VSS cap_mim_2f0_m4m5_noshield c_width=5u c_length=5u
X2211 z VSS cap_mim_2f0_m4m5_noshield c_width=5u c_length=5u
X2212 z VSS cap_mim_2f0_m4m5_noshield c_width=5u c_length=5u
X2213 z VSS cap_mim_2f0_m4m5_noshield c_width=5u c_length=5u
X2214 z VSS cap_mim_2f0_m4m5_noshield c_width=5u c_length=5u
X2215 z VSS cap_mim_2f0_m4m5_noshield c_width=5u c_length=5u
X2216 z VSS cap_mim_2f0_m4m5_noshield c_width=5u c_length=5u
X2217 z VSS cap_mim_2f0_m4m5_noshield c_width=5u c_length=5u
X2218 z VSS cap_mim_2f0_m4m5_noshield c_width=5u c_length=5u
X2219 z VSS cap_mim_2f0_m4m5_noshield c_width=5u c_length=5u
X2220 z VSS cap_mim_2f0_m4m5_noshield c_width=5u c_length=5u
X2221 z VSS cap_mim_2f0_m4m5_noshield c_width=5u c_length=5u
X2222 z VSS cap_mim_2f0_m4m5_noshield c_width=5u c_length=5u
X2223 z VSS cap_mim_2f0_m4m5_noshield c_width=5u c_length=5u
X2224 z VSS cap_mim_2f0_m4m5_noshield c_width=5u c_length=5u
X2225 z VSS cap_mim_2f0_m4m5_noshield c_width=5u c_length=5u
X2226 z VSS cap_mim_2f0_m4m5_noshield c_width=5u c_length=5u
X2227 z VSS cap_mim_2f0_m4m5_noshield c_width=5u c_length=5u
X2228 z VSS cap_mim_2f0_m4m5_noshield c_width=5u c_length=5u
X2229 z VSS cap_mim_2f0_m4m5_noshield c_width=5u c_length=5u
X2230 z VSS cap_mim_2f0_m4m5_noshield c_width=5u c_length=5u
X2231 z VSS cap_mim_2f0_m4m5_noshield c_width=5u c_length=5u
X2232 z VSS cap_mim_2f0_m4m5_noshield c_width=5u c_length=5u
X2233 z VSS cap_mim_2f0_m4m5_noshield c_width=5u c_length=5u
X2234 z VSS cap_mim_2f0_m4m5_noshield c_width=5u c_length=5u
X2235 z VSS cap_mim_2f0_m4m5_noshield c_width=5u c_length=5u
X2236 z VSS cap_mim_2f0_m4m5_noshield c_width=5u c_length=5u
X2237 z VSS cap_mim_2f0_m4m5_noshield c_width=5u c_length=5u
X2238 z VSS cap_mim_2f0_m4m5_noshield c_width=5u c_length=5u
X2239 z VSS cap_mim_2f0_m4m5_noshield c_width=5u c_length=5u
X2240 z VSS cap_mim_2f0_m4m5_noshield c_width=5u c_length=5u
X2241 z VSS cap_mim_2f0_m4m5_noshield c_width=5u c_length=5u
X2242 z VSS cap_mim_2f0_m4m5_noshield c_width=5u c_length=5u
X2243 z VSS cap_mim_2f0_m4m5_noshield c_width=5u c_length=5u
X2244 z VSS cap_mim_2f0_m4m5_noshield c_width=5u c_length=5u
X2245 z VSS cap_mim_2f0_m4m5_noshield c_width=5u c_length=5u
X2246 z VSS cap_mim_2f0_m4m5_noshield c_width=5u c_length=5u
X2247 z VSS cap_mim_2f0_m4m5_noshield c_width=5u c_length=5u
X2248 z VSS cap_mim_2f0_m4m5_noshield c_width=5u c_length=5u
X2249 z VSS cap_mim_2f0_m4m5_noshield c_width=5u c_length=5u
X2250 z VSS cap_mim_2f0_m4m5_noshield c_width=5u c_length=5u
X2251 z VSS cap_mim_2f0_m4m5_noshield c_width=5u c_length=5u
X2252 z VSS cap_mim_2f0_m4m5_noshield c_width=5u c_length=5u
X2253 z VSS cap_mim_2f0_m4m5_noshield c_width=5u c_length=5u
X2254 z VSS cap_mim_2f0_m4m5_noshield c_width=5u c_length=5u
X2255 z VSS cap_mim_2f0_m4m5_noshield c_width=5u c_length=5u
X2256 z VSS cap_mim_2f0_m4m5_noshield c_width=5u c_length=5u
X2257 z VSS cap_mim_2f0_m4m5_noshield c_width=5u c_length=5u
X2258 z VSS cap_mim_2f0_m4m5_noshield c_width=5u c_length=5u
X2259 z VSS cap_mim_2f0_m4m5_noshield c_width=5u c_length=5u
X2260 z VSS cap_mim_2f0_m4m5_noshield c_width=5u c_length=5u
X2261 z VSS cap_mim_2f0_m4m5_noshield c_width=5u c_length=5u
X2262 z VSS cap_mim_2f0_m4m5_noshield c_width=5u c_length=5u
X2263 z VSS cap_mim_2f0_m4m5_noshield c_width=5u c_length=5u
X2264 z VSS cap_mim_2f0_m4m5_noshield c_width=5u c_length=5u
X2265 z VSS cap_mim_2f0_m4m5_noshield c_width=5u c_length=5u
X2266 z VSS cap_mim_2f0_m4m5_noshield c_width=5u c_length=5u
X2267 z VSS cap_mim_2f0_m4m5_noshield c_width=5u c_length=5u
X2268 z VSS cap_mim_2f0_m4m5_noshield c_width=5u c_length=5u
X2269 z VSS cap_mim_2f0_m4m5_noshield c_width=5u c_length=5u
X2270 z VSS cap_mim_2f0_m4m5_noshield c_width=5u c_length=5u
X2271 z VSS cap_mim_2f0_m4m5_noshield c_width=5u c_length=5u
X2272 z VSS cap_mim_2f0_m4m5_noshield c_width=5u c_length=5u
X2273 z VSS cap_mim_2f0_m4m5_noshield c_width=5u c_length=5u
X2274 z VSS cap_mim_2f0_m4m5_noshield c_width=5u c_length=5u
X2275 z VSS cap_mim_2f0_m4m5_noshield c_width=5u c_length=5u
X2276 z VSS cap_mim_2f0_m4m5_noshield c_width=5u c_length=5u
X2277 z VSS cap_mim_2f0_m4m5_noshield c_width=5u c_length=5u
X2278 z VSS cap_mim_2f0_m4m5_noshield c_width=5u c_length=5u
X2279 z VSS cap_mim_2f0_m4m5_noshield c_width=5u c_length=5u
X2280 z VSS cap_mim_2f0_m4m5_noshield c_width=5u c_length=5u
X2281 z VSS cap_mim_2f0_m4m5_noshield c_width=5u c_length=5u
X2282 z VSS cap_mim_2f0_m4m5_noshield c_width=5u c_length=5u
X2283 z VSS cap_mim_2f0_m4m5_noshield c_width=5u c_length=5u
X2284 z VSS cap_mim_2f0_m4m5_noshield c_width=5u c_length=5u
X2285 z VSS cap_mim_2f0_m4m5_noshield c_width=5u c_length=5u
X2286 z VSS cap_mim_2f0_m4m5_noshield c_width=5u c_length=5u
X2287 z VSS cap_mim_2f0_m4m5_noshield c_width=5u c_length=5u
X2288 z VSS cap_mim_2f0_m4m5_noshield c_width=5u c_length=5u
X2289 z VSS cap_mim_2f0_m4m5_noshield c_width=5u c_length=5u
X2290 z VSS cap_mim_2f0_m4m5_noshield c_width=5u c_length=5u
X2291 z VSS cap_mim_2f0_m4m5_noshield c_width=5u c_length=5u
X2292 z VSS cap_mim_2f0_m4m5_noshield c_width=5u c_length=5u
X2293 z VSS cap_mim_2f0_m4m5_noshield c_width=5u c_length=5u
X2294 z VSS cap_mim_2f0_m4m5_noshield c_width=5u c_length=5u
X2295 z VSS cap_mim_2f0_m4m5_noshield c_width=5u c_length=5u
X2296 z VSS cap_mim_2f0_m4m5_noshield c_width=5u c_length=5u
X2297 z VSS cap_mim_2f0_m4m5_noshield c_width=5u c_length=5u
X2298 z VSS cap_mim_2f0_m4m5_noshield c_width=5u c_length=5u
X2299 z VSS cap_mim_2f0_m4m5_noshield c_width=5u c_length=5u
X2300 z VSS cap_mim_2f0_m4m5_noshield c_width=5u c_length=5u
X2301 z VSS cap_mim_2f0_m4m5_noshield c_width=5u c_length=5u
X2302 z VSS cap_mim_2f0_m4m5_noshield c_width=5u c_length=5u
X2303 z VSS cap_mim_2f0_m4m5_noshield c_width=5u c_length=5u
X2304 z VSS cap_mim_2f0_m4m5_noshield c_width=5u c_length=5u
X2305 z VSS cap_mim_2f0_m4m5_noshield c_width=5u c_length=5u
X2306 z VSS cap_mim_2f0_m4m5_noshield c_width=5u c_length=5u
X2307 z VSS cap_mim_2f0_m4m5_noshield c_width=5u c_length=5u
X2308 z VSS cap_mim_2f0_m4m5_noshield c_width=5u c_length=5u
X2309 z VSS cap_mim_2f0_m4m5_noshield c_width=5u c_length=5u
X2310 z VSS cap_mim_2f0_m4m5_noshield c_width=5u c_length=5u
X2311 z VSS cap_mim_2f0_m4m5_noshield c_width=5u c_length=5u
X2312 z VSS cap_mim_2f0_m4m5_noshield c_width=5u c_length=5u
X2313 z VSS cap_mim_2f0_m4m5_noshield c_width=5u c_length=5u
X2314 z VSS cap_mim_2f0_m4m5_noshield c_width=5u c_length=5u
X2315 z VSS cap_mim_2f0_m4m5_noshield c_width=5u c_length=5u
X2316 z VSS cap_mim_2f0_m4m5_noshield c_width=5u c_length=5u
X2317 z VSS cap_mim_2f0_m4m5_noshield c_width=5u c_length=5u
X2318 z VSS cap_mim_2f0_m4m5_noshield c_width=5u c_length=5u
X2319 z VSS cap_mim_2f0_m4m5_noshield c_width=5u c_length=5u
X2320 z VSS cap_mim_2f0_m4m5_noshield c_width=5u c_length=5u
X2321 z VSS cap_mim_2f0_m4m5_noshield c_width=5u c_length=5u
X2322 z VSS cap_mim_2f0_m4m5_noshield c_width=5u c_length=5u
X2323 z VSS cap_mim_2f0_m4m5_noshield c_width=5u c_length=5u
X2324 z VSS cap_mim_2f0_m4m5_noshield c_width=5u c_length=5u
X2325 z VSS cap_mim_2f0_m4m5_noshield c_width=5u c_length=5u
X2326 z VSS cap_mim_2f0_m4m5_noshield c_width=5u c_length=5u
X2327 z VSS cap_mim_2f0_m4m5_noshield c_width=5u c_length=5u
X2328 z VSS cap_mim_2f0_m4m5_noshield c_width=5u c_length=5u
X2329 z VSS cap_mim_2f0_m4m5_noshield c_width=5u c_length=5u
X2330 z VSS cap_mim_2f0_m4m5_noshield c_width=5u c_length=5u
X2331 z VSS cap_mim_2f0_m4m5_noshield c_width=5u c_length=5u
X2332 z VSS cap_mim_2f0_m4m5_noshield c_width=5u c_length=5u
X2333 z VSS cap_mim_2f0_m4m5_noshield c_width=5u c_length=5u
X2334 z VSS cap_mim_2f0_m4m5_noshield c_width=5u c_length=5u
X2335 z VSS cap_mim_2f0_m4m5_noshield c_width=5u c_length=5u
X2336 z VSS cap_mim_2f0_m4m5_noshield c_width=5u c_length=5u
X2337 z VSS cap_mim_2f0_m4m5_noshield c_width=5u c_length=5u
X2338 z VSS cap_mim_2f0_m4m5_noshield c_width=5u c_length=5u
X2339 z VSS cap_mim_2f0_m4m5_noshield c_width=5u c_length=5u
X2340 z VSS cap_mim_2f0_m4m5_noshield c_width=5u c_length=5u
X2341 z VSS cap_mim_2f0_m4m5_noshield c_width=5u c_length=5u
X2342 z VSS cap_mim_2f0_m4m5_noshield c_width=5u c_length=5u
X2343 z VSS cap_mim_2f0_m4m5_noshield c_width=5u c_length=5u
X2344 z VSS cap_mim_2f0_m4m5_noshield c_width=5u c_length=5u
X2345 z VSS cap_mim_2f0_m4m5_noshield c_width=5u c_length=5u
X2346 z VSS cap_mim_2f0_m4m5_noshield c_width=5u c_length=5u
X2347 z VSS cap_mim_2f0_m4m5_noshield c_width=5u c_length=5u
X2348 z VSS cap_mim_2f0_m4m5_noshield c_width=5u c_length=5u
X2349 z VSS cap_mim_2f0_m4m5_noshield c_width=5u c_length=5u
X2350 z VSS cap_mim_2f0_m4m5_noshield c_width=5u c_length=5u
X2351 z VSS cap_mim_2f0_m4m5_noshield c_width=5u c_length=5u
X2352 z VSS cap_mim_2f0_m4m5_noshield c_width=5u c_length=5u
X2353 z VSS cap_mim_2f0_m4m5_noshield c_width=5u c_length=5u
X2354 z VSS cap_mim_2f0_m4m5_noshield c_width=5u c_length=5u
X2355 z VSS cap_mim_2f0_m4m5_noshield c_width=5u c_length=5u
X2356 z VSS cap_mim_2f0_m4m5_noshield c_width=5u c_length=5u
X2357 z VSS cap_mim_2f0_m4m5_noshield c_width=5u c_length=5u
X2358 z VSS cap_mim_2f0_m4m5_noshield c_width=5u c_length=5u
X2359 z VSS cap_mim_2f0_m4m5_noshield c_width=5u c_length=5u
X2360 z VSS cap_mim_2f0_m4m5_noshield c_width=5u c_length=5u
X2361 z VSS cap_mim_2f0_m4m5_noshield c_width=5u c_length=5u
X2362 z VSS cap_mim_2f0_m4m5_noshield c_width=5u c_length=5u
X2363 z VSS cap_mim_2f0_m4m5_noshield c_width=5u c_length=5u
X2364 z VSS cap_mim_2f0_m4m5_noshield c_width=5u c_length=5u
X2365 z VSS cap_mim_2f0_m4m5_noshield c_width=5u c_length=5u
X2366 z VSS cap_mim_2f0_m4m5_noshield c_width=5u c_length=5u
X2367 z VSS cap_mim_2f0_m4m5_noshield c_width=5u c_length=5u
X2368 z VSS cap_mim_2f0_m4m5_noshield c_width=5u c_length=5u
X2369 z VSS cap_mim_2f0_m4m5_noshield c_width=5u c_length=5u
X2370 z VSS cap_mim_2f0_m4m5_noshield c_width=5u c_length=5u
X2371 z VSS cap_mim_2f0_m4m5_noshield c_width=5u c_length=5u
.ends

.subckt loop_filter_C2 VC VSS
X0 VC VSS cap_mim_2f0_m4m5_noshield c_width=5u c_length=5u
X1 VC VSS cap_mim_2f0_m4m5_noshield c_width=5u c_length=5u
X2 VC VSS cap_mim_2f0_m4m5_noshield c_width=5u c_length=5u
X3 VC VSS cap_mim_2f0_m4m5_noshield c_width=5u c_length=5u
X4 VC VSS cap_mim_2f0_m4m5_noshield c_width=5u c_length=5u
X5 VC VSS cap_mim_2f0_m4m5_noshield c_width=5u c_length=5u
X6 VC VSS cap_mim_2f0_m4m5_noshield c_width=5u c_length=5u
X7 VC VSS cap_mim_2f0_m4m5_noshield c_width=5u c_length=5u
X8 VC VSS cap_mim_2f0_m4m5_noshield c_width=5u c_length=5u
X9 VC VSS cap_mim_2f0_m4m5_noshield c_width=5u c_length=5u
X10 VC VSS cap_mim_2f0_m4m5_noshield c_width=5u c_length=5u
X11 VC VSS cap_mim_2f0_m4m5_noshield c_width=5u c_length=5u
X12 VC VSS cap_mim_2f0_m4m5_noshield c_width=5u c_length=5u
X13 VC VSS cap_mim_2f0_m4m5_noshield c_width=5u c_length=5u
X14 VC VSS cap_mim_2f0_m4m5_noshield c_width=5u c_length=5u
X15 VC VSS cap_mim_2f0_m4m5_noshield c_width=5u c_length=5u
X16 VC VSS cap_mim_2f0_m4m5_noshield c_width=5u c_length=5u
X17 VC VSS cap_mim_2f0_m4m5_noshield c_width=5u c_length=5u
X18 VC VSS cap_mim_2f0_m4m5_noshield c_width=5u c_length=5u
X19 VC VSS cap_mim_2f0_m4m5_noshield c_width=5u c_length=5u
X20 VC VSS cap_mim_2f0_m4m5_noshield c_width=5u c_length=5u
X21 VC VSS cap_mim_2f0_m4m5_noshield c_width=5u c_length=5u
X22 VC VSS cap_mim_2f0_m4m5_noshield c_width=5u c_length=5u
X23 VC VSS cap_mim_2f0_m4m5_noshield c_width=5u c_length=5u
X24 VC VSS cap_mim_2f0_m4m5_noshield c_width=5u c_length=5u
X25 VC VSS cap_mim_2f0_m4m5_noshield c_width=5u c_length=5u
X26 VC VSS cap_mim_2f0_m4m5_noshield c_width=5u c_length=5u
X27 VC VSS cap_mim_2f0_m4m5_noshield c_width=5u c_length=5u
X28 VC VSS cap_mim_2f0_m4m5_noshield c_width=5u c_length=5u
X29 VC VSS cap_mim_2f0_m4m5_noshield c_width=5u c_length=5u
X30 VC VSS cap_mim_2f0_m4m5_noshield c_width=5u c_length=5u
X31 VC VSS cap_mim_2f0_m4m5_noshield c_width=5u c_length=5u
X32 VC VSS cap_mim_2f0_m4m5_noshield c_width=5u c_length=5u
X33 VC VSS cap_mim_2f0_m4m5_noshield c_width=5u c_length=5u
X34 VC VSS cap_mim_2f0_m4m5_noshield c_width=5u c_length=5u
X35 VC VSS cap_mim_2f0_m4m5_noshield c_width=5u c_length=5u
X36 VC VSS cap_mim_2f0_m4m5_noshield c_width=5u c_length=5u
X37 VC VSS cap_mim_2f0_m4m5_noshield c_width=5u c_length=5u
X38 VC VSS cap_mim_2f0_m4m5_noshield c_width=5u c_length=5u
X39 VC VSS cap_mim_2f0_m4m5_noshield c_width=5u c_length=5u
X40 VC VSS cap_mim_2f0_m4m5_noshield c_width=5u c_length=5u
X41 VC VSS cap_mim_2f0_m4m5_noshield c_width=5u c_length=5u
X42 VC VSS cap_mim_2f0_m4m5_noshield c_width=5u c_length=5u
X43 VC VSS cap_mim_2f0_m4m5_noshield c_width=5u c_length=5u
X44 VC VSS cap_mim_2f0_m4m5_noshield c_width=5u c_length=5u
X45 VC VSS cap_mim_2f0_m4m5_noshield c_width=5u c_length=5u
X46 VC VSS cap_mim_2f0_m4m5_noshield c_width=5u c_length=5u
X47 VC VSS cap_mim_2f0_m4m5_noshield c_width=5u c_length=5u
X48 VC VSS cap_mim_2f0_m4m5_noshield c_width=5u c_length=5u
X49 VC VSS cap_mim_2f0_m4m5_noshield c_width=5u c_length=5u
X50 VC VSS cap_mim_2f0_m4m5_noshield c_width=5u c_length=5u
X51 VC VSS cap_mim_2f0_m4m5_noshield c_width=5u c_length=5u
X52 VC VSS cap_mim_2f0_m4m5_noshield c_width=5u c_length=5u
X53 VC VSS cap_mim_2f0_m4m5_noshield c_width=5u c_length=5u
X54 VC VSS cap_mim_2f0_m4m5_noshield c_width=5u c_length=5u
X55 VC VSS cap_mim_2f0_m4m5_noshield c_width=5u c_length=5u
X56 VC VSS cap_mim_2f0_m4m5_noshield c_width=5u c_length=5u
X57 VC VSS cap_mim_2f0_m4m5_noshield c_width=5u c_length=5u
X58 VC VSS cap_mim_2f0_m4m5_noshield c_width=5u c_length=5u
X59 VC VSS cap_mim_2f0_m4m5_noshield c_width=5u c_length=5u
X60 VC VSS cap_mim_2f0_m4m5_noshield c_width=5u c_length=5u
X61 VC VSS cap_mim_2f0_m4m5_noshield c_width=5u c_length=5u
X62 VC VSS cap_mim_2f0_m4m5_noshield c_width=5u c_length=5u
X63 VC VSS cap_mim_2f0_m4m5_noshield c_width=5u c_length=5u
X64 VC VSS cap_mim_2f0_m4m5_noshield c_width=5u c_length=5u
X65 VC VSS cap_mim_2f0_m4m5_noshield c_width=5u c_length=5u
X66 VC VSS cap_mim_2f0_m4m5_noshield c_width=5u c_length=5u
X67 VC VSS cap_mim_2f0_m4m5_noshield c_width=5u c_length=5u
X68 VC VSS cap_mim_2f0_m4m5_noshield c_width=5u c_length=5u
X69 VC VSS cap_mim_2f0_m4m5_noshield c_width=5u c_length=5u
X70 VC VSS cap_mim_2f0_m4m5_noshield c_width=5u c_length=5u
X71 VC VSS cap_mim_2f0_m4m5_noshield c_width=5u c_length=5u
X72 VC VSS cap_mim_2f0_m4m5_noshield c_width=5u c_length=5u
X73 VC VSS cap_mim_2f0_m4m5_noshield c_width=5u c_length=5u
X74 VC VSS cap_mim_2f0_m4m5_noshield c_width=5u c_length=5u
X75 VC VSS cap_mim_2f0_m4m5_noshield c_width=5u c_length=5u
X76 VC VSS cap_mim_2f0_m4m5_noshield c_width=5u c_length=5u
X77 VC VSS cap_mim_2f0_m4m5_noshield c_width=5u c_length=5u
X78 VC VSS cap_mim_2f0_m4m5_noshield c_width=5u c_length=5u
X79 VC VSS cap_mim_2f0_m4m5_noshield c_width=5u c_length=5u
X80 VC VSS cap_mim_2f0_m4m5_noshield c_width=5u c_length=5u
X81 VC VSS cap_mim_2f0_m4m5_noshield c_width=5u c_length=5u
X82 VC VSS cap_mim_2f0_m4m5_noshield c_width=5u c_length=5u
X83 VC VSS cap_mim_2f0_m4m5_noshield c_width=5u c_length=5u
X84 VC VSS cap_mim_2f0_m4m5_noshield c_width=5u c_length=5u
X85 VC VSS cap_mim_2f0_m4m5_noshield c_width=5u c_length=5u
X86 VC VSS cap_mim_2f0_m4m5_noshield c_width=5u c_length=5u
X87 VC VSS cap_mim_2f0_m4m5_noshield c_width=5u c_length=5u
X88 VC VSS cap_mim_2f0_m4m5_noshield c_width=5u c_length=5u
X89 VC VSS cap_mim_2f0_m4m5_noshield c_width=5u c_length=5u
X90 VC VSS cap_mim_2f0_m4m5_noshield c_width=5u c_length=5u
X91 VC VSS cap_mim_2f0_m4m5_noshield c_width=5u c_length=5u
X92 VC VSS cap_mim_2f0_m4m5_noshield c_width=5u c_length=5u
X93 VC VSS cap_mim_2f0_m4m5_noshield c_width=5u c_length=5u
X94 VC VSS cap_mim_2f0_m4m5_noshield c_width=5u c_length=5u
X95 VC VSS cap_mim_2f0_m4m5_noshield c_width=5u c_length=5u
X96 VC VSS cap_mim_2f0_m4m5_noshield c_width=5u c_length=5u
X97 VC VSS cap_mim_2f0_m4m5_noshield c_width=5u c_length=5u
X98 VC VSS cap_mim_2f0_m4m5_noshield c_width=5u c_length=5u
X99 VC VSS cap_mim_2f0_m4m5_noshield c_width=5u c_length=5u
X100 VC VSS cap_mim_2f0_m4m5_noshield c_width=5u c_length=5u
X101 VC VSS cap_mim_2f0_m4m5_noshield c_width=5u c_length=5u
X102 VC VSS cap_mim_2f0_m4m5_noshield c_width=5u c_length=5u
X103 VC VSS cap_mim_2f0_m4m5_noshield c_width=5u c_length=5u
X104 VC VSS cap_mim_2f0_m4m5_noshield c_width=5u c_length=5u
X105 VC VSS cap_mim_2f0_m4m5_noshield c_width=5u c_length=5u
X106 VC VSS cap_mim_2f0_m4m5_noshield c_width=5u c_length=5u
X107 VC VSS cap_mim_2f0_m4m5_noshield c_width=5u c_length=5u
X108 VC VSS cap_mim_2f0_m4m5_noshield c_width=5u c_length=5u
X109 VC VSS cap_mim_2f0_m4m5_noshield c_width=5u c_length=5u
X110 VC VSS cap_mim_2f0_m4m5_noshield c_width=5u c_length=5u
X111 VC VSS cap_mim_2f0_m4m5_noshield c_width=5u c_length=5u
X112 VC VSS cap_mim_2f0_m4m5_noshield c_width=5u c_length=5u
X113 VC VSS cap_mim_2f0_m4m5_noshield c_width=5u c_length=5u
X114 VC VSS cap_mim_2f0_m4m5_noshield c_width=5u c_length=5u
X115 VC VSS cap_mim_2f0_m4m5_noshield c_width=5u c_length=5u
X116 VC VSS cap_mim_2f0_m4m5_noshield c_width=5u c_length=5u
X117 VC VSS cap_mim_2f0_m4m5_noshield c_width=5u c_length=5u
X118 VC VSS cap_mim_2f0_m4m5_noshield c_width=5u c_length=5u
X119 VC VSS cap_mim_2f0_m4m5_noshield c_width=5u c_length=5u
X120 VC VSS cap_mim_2f0_m4m5_noshield c_width=5u c_length=5u
X121 VC VSS cap_mim_2f0_m4m5_noshield c_width=5u c_length=5u
X122 VC VSS cap_mim_2f0_m4m5_noshield c_width=5u c_length=5u
X123 VC VSS cap_mim_2f0_m4m5_noshield c_width=5u c_length=5u
X124 VC VSS cap_mim_2f0_m4m5_noshield c_width=5u c_length=5u
X125 VC VSS cap_mim_2f0_m4m5_noshield c_width=5u c_length=5u
X126 VC VSS cap_mim_2f0_m4m5_noshield c_width=5u c_length=5u
X127 VC VSS cap_mim_2f0_m4m5_noshield c_width=5u c_length=5u
X128 VC VSS cap_mim_2f0_m4m5_noshield c_width=5u c_length=5u
X129 VC VSS cap_mim_2f0_m4m5_noshield c_width=5u c_length=5u
X130 VC VSS cap_mim_2f0_m4m5_noshield c_width=5u c_length=5u
X131 VC VSS cap_mim_2f0_m4m5_noshield c_width=5u c_length=5u
X132 VC VSS cap_mim_2f0_m4m5_noshield c_width=5u c_length=5u
X133 VC VSS cap_mim_2f0_m4m5_noshield c_width=5u c_length=5u
X134 VC VSS cap_mim_2f0_m4m5_noshield c_width=5u c_length=5u
X135 VC VSS cap_mim_2f0_m4m5_noshield c_width=5u c_length=5u
X136 VC VSS cap_mim_2f0_m4m5_noshield c_width=5u c_length=5u
X137 VC VSS cap_mim_2f0_m4m5_noshield c_width=5u c_length=5u
X138 VC VSS cap_mim_2f0_m4m5_noshield c_width=5u c_length=5u
X139 VC VSS cap_mim_2f0_m4m5_noshield c_width=5u c_length=5u
X140 VC VSS cap_mim_2f0_m4m5_noshield c_width=5u c_length=5u
X141 VC VSS cap_mim_2f0_m4m5_noshield c_width=5u c_length=5u
X142 VC VSS cap_mim_2f0_m4m5_noshield c_width=5u c_length=5u
X143 VC VSS cap_mim_2f0_m4m5_noshield c_width=5u c_length=5u
X144 VC VSS cap_mim_2f0_m4m5_noshield c_width=5u c_length=5u
X145 VC VSS cap_mim_2f0_m4m5_noshield c_width=5u c_length=5u
X146 VC VSS cap_mim_2f0_m4m5_noshield c_width=5u c_length=5u
X147 VC VSS cap_mim_2f0_m4m5_noshield c_width=5u c_length=5u
X148 VC VSS cap_mim_2f0_m4m5_noshield c_width=5u c_length=5u
X149 VC VSS cap_mim_2f0_m4m5_noshield c_width=5u c_length=5u
X150 VC VSS cap_mim_2f0_m4m5_noshield c_width=5u c_length=5u
X151 VC VSS cap_mim_2f0_m4m5_noshield c_width=5u c_length=5u
X152 VC VSS cap_mim_2f0_m4m5_noshield c_width=5u c_length=5u
X153 VC VSS cap_mim_2f0_m4m5_noshield c_width=5u c_length=5u
X154 VC VSS cap_mim_2f0_m4m5_noshield c_width=5u c_length=5u
X155 VC VSS cap_mim_2f0_m4m5_noshield c_width=5u c_length=5u
X156 VC VSS cap_mim_2f0_m4m5_noshield c_width=5u c_length=5u
X157 VC VSS cap_mim_2f0_m4m5_noshield c_width=5u c_length=5u
X158 VC VSS cap_mim_2f0_m4m5_noshield c_width=5u c_length=5u
X159 VC VSS cap_mim_2f0_m4m5_noshield c_width=5u c_length=5u
X160 VC VSS cap_mim_2f0_m4m5_noshield c_width=5u c_length=5u
X161 VC VSS cap_mim_2f0_m4m5_noshield c_width=5u c_length=5u
X162 VC VSS cap_mim_2f0_m4m5_noshield c_width=5u c_length=5u
X163 VC VSS cap_mim_2f0_m4m5_noshield c_width=5u c_length=5u
X164 VC VSS cap_mim_2f0_m4m5_noshield c_width=5u c_length=5u
X165 VC VSS cap_mim_2f0_m4m5_noshield c_width=5u c_length=5u
X166 VC VSS cap_mim_2f0_m4m5_noshield c_width=5u c_length=5u
X167 VC VSS cap_mim_2f0_m4m5_noshield c_width=5u c_length=5u
X168 VC VSS cap_mim_2f0_m4m5_noshield c_width=5u c_length=5u
X169 VC VSS cap_mim_2f0_m4m5_noshield c_width=5u c_length=5u
X170 VC VSS cap_mim_2f0_m4m5_noshield c_width=5u c_length=5u
X171 VC VSS cap_mim_2f0_m4m5_noshield c_width=5u c_length=5u
X172 VC VSS cap_mim_2f0_m4m5_noshield c_width=5u c_length=5u
X173 VC VSS cap_mim_2f0_m4m5_noshield c_width=5u c_length=5u
X174 VC VSS cap_mim_2f0_m4m5_noshield c_width=5u c_length=5u
X175 VC VSS cap_mim_2f0_m4m5_noshield c_width=5u c_length=5u
X176 VC VSS cap_mim_2f0_m4m5_noshield c_width=5u c_length=5u
X177 VC VSS cap_mim_2f0_m4m5_noshield c_width=5u c_length=5u
X178 VC VSS cap_mim_2f0_m4m5_noshield c_width=5u c_length=5u
X179 VC VSS cap_mim_2f0_m4m5_noshield c_width=5u c_length=5u
X180 VC VSS cap_mim_2f0_m4m5_noshield c_width=5u c_length=5u
X181 VC VSS cap_mim_2f0_m4m5_noshield c_width=5u c_length=5u
X182 VC VSS cap_mim_2f0_m4m5_noshield c_width=5u c_length=5u
X183 VC VSS cap_mim_2f0_m4m5_noshield c_width=5u c_length=5u
X184 VC VSS cap_mim_2f0_m4m5_noshield c_width=5u c_length=5u
X185 VC VSS cap_mim_2f0_m4m5_noshield c_width=5u c_length=5u
X186 VC VSS cap_mim_2f0_m4m5_noshield c_width=5u c_length=5u
X187 VC VSS cap_mim_2f0_m4m5_noshield c_width=5u c_length=5u
X188 VC VSS cap_mim_2f0_m4m5_noshield c_width=5u c_length=5u
X189 VC VSS cap_mim_2f0_m4m5_noshield c_width=5u c_length=5u
X190 VC VSS cap_mim_2f0_m4m5_noshield c_width=5u c_length=5u
X191 VC VSS cap_mim_2f0_m4m5_noshield c_width=5u c_length=5u
X192 VC VSS cap_mim_2f0_m4m5_noshield c_width=5u c_length=5u
X193 VC VSS cap_mim_2f0_m4m5_noshield c_width=5u c_length=5u
X194 VC VSS cap_mim_2f0_m4m5_noshield c_width=5u c_length=5u
X195 VC VSS cap_mim_2f0_m4m5_noshield c_width=5u c_length=5u
.ends

.subckt loop_filter_C3 VT VSS
X0 VT VSS cap_mim_2f0_m4m5_noshield c_width=5u c_length=5u
X1 VT VSS cap_mim_2f0_m4m5_noshield c_width=5u c_length=5u
X2 VT VSS cap_mim_2f0_m4m5_noshield c_width=5u c_length=5u
X3 VT VSS cap_mim_2f0_m4m5_noshield c_width=5u c_length=5u
X4 VT VSS cap_mim_2f0_m4m5_noshield c_width=5u c_length=5u
X5 VT VSS cap_mim_2f0_m4m5_noshield c_width=5u c_length=5u
X6 VT VSS cap_mim_2f0_m4m5_noshield c_width=5u c_length=5u
X7 VT VSS cap_mim_2f0_m4m5_noshield c_width=5u c_length=5u
X8 VT VSS cap_mim_2f0_m4m5_noshield c_width=5u c_length=5u
X9 VT VSS cap_mim_2f0_m4m5_noshield c_width=5u c_length=5u
X10 VT VSS cap_mim_2f0_m4m5_noshield c_width=5u c_length=5u
X11 VT VSS cap_mim_2f0_m4m5_noshield c_width=5u c_length=5u
X12 VT VSS cap_mim_2f0_m4m5_noshield c_width=5u c_length=5u
X13 VT VSS cap_mim_2f0_m4m5_noshield c_width=5u c_length=5u
X14 VT VSS cap_mim_2f0_m4m5_noshield c_width=5u c_length=5u
X15 VT VSS cap_mim_2f0_m4m5_noshield c_width=5u c_length=5u
X16 VT VSS cap_mim_2f0_m4m5_noshield c_width=5u c_length=5u
X17 VT VSS cap_mim_2f0_m4m5_noshield c_width=5u c_length=5u
X18 VT VSS cap_mim_2f0_m4m5_noshield c_width=5u c_length=5u
X19 VT VSS cap_mim_2f0_m4m5_noshield c_width=5u c_length=5u
X20 VT VSS cap_mim_2f0_m4m5_noshield c_width=5u c_length=5u
X21 VT VSS cap_mim_2f0_m4m5_noshield c_width=5u c_length=5u
X22 VT VSS cap_mim_2f0_m4m5_noshield c_width=5u c_length=5u
X23 VT VSS cap_mim_2f0_m4m5_noshield c_width=5u c_length=5u
X24 VT VSS cap_mim_2f0_m4m5_noshield c_width=5u c_length=5u
X25 VT VSS cap_mim_2f0_m4m5_noshield c_width=5u c_length=5u
X26 VT VSS cap_mim_2f0_m4m5_noshield c_width=5u c_length=5u
X27 VT VSS cap_mim_2f0_m4m5_noshield c_width=5u c_length=5u
X28 VT VSS cap_mim_2f0_m4m5_noshield c_width=5u c_length=5u
X29 VT VSS cap_mim_2f0_m4m5_noshield c_width=5u c_length=5u
.ends

.subckt loop_filter_R2u_0 VT VC VSS
X0 VC VT VSS ppolyf_u_1k r_width=2u r_length=2u
.ends

.subckt loop_filter VC VT VSS
XXR1u_0 XC1/z VC VSS loop_filter_R1u_0
XXC1 XC1/z VSS loop_filter_C1
XXC2 VC VSS loop_filter_C2
XXC3 VT VSS loop_filter_C3
XXR2u_0 VT VC VSS loop_filter_R2u_0
.ends

.subckt pll_core VSS VDD REFCK LO NB PB ICP2 VCTRL FS FB
XXDB VSS VDD LO XDIV/CK divbuf
XXMTX XMTX/tx VSS pll_core_MTX
XXDIV VDD XDIV/CK FS FB VSS div48
XXPFD VDD XPFD/REF FB XPFD/UP XCP/UPB XCP/DN XCP/DNB VSS pfd
XXMTHI XMTLO/thi XMTX/tx VDD pll_core_MTHI
XXCP VDD XCP/UPB XCP/DN XCP/DNB PB NB ICP2 XLF/VC VSS cp
XXMTLO XMTLO/tlo XMTLO/thi VSS pll_core_MTLO
XXR2u_0 XPFD/REF REFCK VSS pll_core_R2u_0
XXMCLN XPFD/REF XMTLO/tlo VSS pll_core_MCLN
XXMCLP XPFD/REF XMTLO/thi VDD pll_core_MCLP
XXLF XLF/VC VCTRL VSS loop_filter
.ends
