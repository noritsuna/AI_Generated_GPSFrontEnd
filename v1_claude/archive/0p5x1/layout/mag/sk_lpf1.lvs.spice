* NGSPICE file created from sk_lpf1.ext - technology: gf180mcuD

.subckt sk_lpf1_MFN VSS yN OUTN
X0 OUTN yN VSS OUTN pfet_03v3 ad=1.325p pd=5.53u as=1.325p ps=5.53u w=5u l=0.28u
X1 OUTN yN VSS OUTN pfet_03v3 ad=1.325p pd=5.53u as=1.325p ps=5.53u w=5u l=0.28u
X2 VSS yN OUTN OUTN pfet_03v3 ad=1.325p pd=5.53u as=1.325p ps=5.53u w=5u l=0.28u
X3 VSS yN OUTN OUTN pfet_03v3 ad=1.325p pd=5.53u as=2.225p ps=10.89u w=5u l=0.28u
X4 VSS yN OUTN OUTN pfet_03v3 ad=1.325p pd=5.53u as=1.325p ps=5.53u w=5u l=0.28u
X5 OUTN yN VSS OUTN pfet_03v3 ad=1.325p pd=5.53u as=1.325p ps=5.53u w=5u l=0.28u
X6 VSS yN OUTN OUTN pfet_03v3 ad=1.325p pd=5.53u as=1.325p ps=5.53u w=5u l=0.28u
X7 OUTN yN VSS OUTN pfet_03v3 ad=2.225p pd=10.89u as=1.325p ps=5.53u w=5u l=0.28u
.ends

.subckt sk_lpf1_C2N yN VSS
X0 yN VSS cap_mim_2f0_m4m5_noshield c_width=5u c_length=5u
X1 yN VSS cap_mim_2f0_m4m5_noshield c_width=5u c_length=5u
X2 yN VSS cap_mim_2f0_m4m5_noshield c_width=5u c_length=5u
X3 yN VSS cap_mim_2f0_m4m5_noshield c_width=5u c_length=5u
X4 yN VSS cap_mim_2f0_m4m5_noshield c_width=5u c_length=5u
X5 yN VSS cap_mim_2f0_m4m5_noshield c_width=5u c_length=5u
X6 yN VSS cap_mim_2f0_m4m5_noshield c_width=5u c_length=5u
X7 yN VSS cap_mim_2f0_m4m5_noshield c_width=5u c_length=5u
X8 yN VSS cap_mim_2f0_m4m5_noshield c_width=5u c_length=5u
X9 yN VSS cap_mim_2f0_m4m5_noshield c_width=5u c_length=5u
X10 yN VSS cap_mim_2f0_m4m5_noshield c_width=5u c_length=5u
X11 yN VSS cap_mim_2f0_m4m5_noshield c_width=5u c_length=5u
X12 yN VSS cap_mim_2f0_m4m5_noshield c_width=5u c_length=5u
X13 yN VSS cap_mim_2f0_m4m5_noshield c_width=5u c_length=5u
X14 yN VSS cap_mim_2f0_m4m5_noshield c_width=5u c_length=5u
X15 yN VSS cap_mim_2f0_m4m5_noshield c_width=5u c_length=5u
X16 yN VSS cap_mim_2f0_m4m5_noshield c_width=5u c_length=5u
X17 yN VSS cap_mim_2f0_m4m5_noshield c_width=5u c_length=5u
X18 yN VSS cap_mim_2f0_m4m5_noshield c_width=5u c_length=5u
X19 yN VSS cap_mim_2f0_m4m5_noshield c_width=5u c_length=5u
X20 yN VSS cap_mim_2f0_m4m5_noshield c_width=5u c_length=5u
X21 yN VSS cap_mim_2f0_m4m5_noshield c_width=5u c_length=5u
X22 yN VSS cap_mim_2f0_m4m5_noshield c_width=5u c_length=5u
X23 yN VSS cap_mim_2f0_m4m5_noshield c_width=5u c_length=5u
X24 yN VSS cap_mim_2f0_m4m5_noshield c_width=5u c_length=5u
X25 yN VSS cap_mim_2f0_m4m5_noshield c_width=5u c_length=5u
X26 yN VSS cap_mim_2f0_m4m5_noshield c_width=5u c_length=5u
X27 yN VSS cap_mim_2f0_m4m5_noshield c_width=5u c_length=5u
X28 yN VSS cap_mim_2f0_m4m5_noshield c_width=5u c_length=5u
X29 yN VSS cap_mim_2f0_m4m5_noshield c_width=5u c_length=5u
X30 yN VSS cap_mim_2f0_m4m5_noshield c_width=5u c_length=5u
X31 yN VSS cap_mim_2f0_m4m5_noshield c_width=5u c_length=5u
X32 yN VSS cap_mim_2f0_m4m5_noshield c_width=5u c_length=5u
X33 yN VSS cap_mim_2f0_m4m5_noshield c_width=5u c_length=5u
X34 yN VSS cap_mim_2f0_m4m5_noshield c_width=5u c_length=5u
X35 yN VSS cap_mim_2f0_m4m5_noshield c_width=5u c_length=5u
X36 yN VSS cap_mim_2f0_m4m5_noshield c_width=5u c_length=5u
X37 yN VSS cap_mim_2f0_m4m5_noshield c_width=5u c_length=5u
X38 yN VSS cap_mim_2f0_m4m5_noshield c_width=5u c_length=5u
X39 yN VSS cap_mim_2f0_m4m5_noshield c_width=5u c_length=5u
X40 yN VSS cap_mim_2f0_m4m5_noshield c_width=5u c_length=5u
X41 yN VSS cap_mim_2f0_m4m5_noshield c_width=5u c_length=5u
X42 yN VSS cap_mim_2f0_m4m5_noshield c_width=5u c_length=5u
X43 yN VSS cap_mim_2f0_m4m5_noshield c_width=5u c_length=5u
X44 yN VSS cap_mim_2f0_m4m5_noshield c_width=5u c_length=5u
X45 yN VSS cap_mim_2f0_m4m5_noshield c_width=5u c_length=5u
X46 yN VSS cap_mim_2f0_m4m5_noshield c_width=5u c_length=5u
X47 yN VSS cap_mim_2f0_m4m5_noshield c_width=5u c_length=5u
X48 yN VSS cap_mim_2f0_m4m5_noshield c_width=5u c_length=5u
X49 yN VSS cap_mim_2f0_m4m5_noshield c_width=5u c_length=5u
X50 yN VSS cap_mim_2f0_m4m5_noshield c_width=5u c_length=5u
X51 yN VSS cap_mim_2f0_m4m5_noshield c_width=5u c_length=5u
X52 yN VSS cap_mim_2f0_m4m5_noshield c_width=5u c_length=5u
X53 yN VSS cap_mim_2f0_m4m5_noshield c_width=5u c_length=5u
X54 yN VSS cap_mim_2f0_m4m5_noshield c_width=5u c_length=5u
X55 yN VSS cap_mim_2f0_m4m5_noshield c_width=5u c_length=5u
X56 yN VSS cap_mim_2f0_m4m5_noshield c_width=5u c_length=5u
X57 yN VSS cap_mim_2f0_m4m5_noshield c_width=5u c_length=5u
X58 yN VSS cap_mim_2f0_m4m5_noshield c_width=5u c_length=5u
X59 yN VSS cap_mim_2f0_m4m5_noshield c_width=5u c_length=5u
X60 yN VSS cap_mim_2f0_m4m5_noshield c_width=5u c_length=5u
X61 yN VSS cap_mim_2f0_m4m5_noshield c_width=5u c_length=5u
X62 yN VSS cap_mim_2f0_m4m5_noshield c_width=5u c_length=5u
X63 yN VSS cap_mim_2f0_m4m5_noshield c_width=5u c_length=5u
X64 yN VSS cap_mim_2f0_m4m5_noshield c_width=5u c_length=5u
X65 yN VSS cap_mim_2f0_m4m5_noshield c_width=5u c_length=5u
X66 yN VSS cap_mim_2f0_m4m5_noshield c_width=5u c_length=5u
X67 yN VSS cap_mim_2f0_m4m5_noshield c_width=5u c_length=5u
X68 yN VSS cap_mim_2f0_m4m5_noshield c_width=5u c_length=5u
X69 yN VSS cap_mim_2f0_m4m5_noshield c_width=5u c_length=5u
X70 yN VSS cap_mim_2f0_m4m5_noshield c_width=5u c_length=5u
X71 yN VSS cap_mim_2f0_m4m5_noshield c_width=5u c_length=5u
X72 yN VSS cap_mim_2f0_m4m5_noshield c_width=5u c_length=5u
X73 yN VSS cap_mim_2f0_m4m5_noshield c_width=5u c_length=5u
X74 yN VSS cap_mim_2f0_m4m5_noshield c_width=5u c_length=5u
X75 yN VSS cap_mim_2f0_m4m5_noshield c_width=5u c_length=5u
X76 yN VSS cap_mim_2f0_m4m5_noshield c_width=5u c_length=5u
X77 yN VSS cap_mim_2f0_m4m5_noshield c_width=5u c_length=5u
X78 yN VSS cap_mim_2f0_m4m5_noshield c_width=5u c_length=5u
X79 yN VSS cap_mim_2f0_m4m5_noshield c_width=5u c_length=5u
X80 yN VSS cap_mim_2f0_m4m5_noshield c_width=5u c_length=5u
X81 yN VSS cap_mim_2f0_m4m5_noshield c_width=5u c_length=5u
X82 yN VSS cap_mim_2f0_m4m5_noshield c_width=5u c_length=5u
X83 yN VSS cap_mim_2f0_m4m5_noshield c_width=5u c_length=5u
.ends

.subckt sk_lpf1_C1N xN OUTN
X0 xN OUTN cap_mim_2f0_m4m5_noshield c_width=5u c_length=5u
X1 xN OUTN cap_mim_2f0_m4m5_noshield c_width=5u c_length=5u
X2 xN OUTN cap_mim_2f0_m4m5_noshield c_width=5u c_length=5u
X3 xN OUTN cap_mim_2f0_m4m5_noshield c_width=5u c_length=5u
X4 xN OUTN cap_mim_2f0_m4m5_noshield c_width=5u c_length=5u
X5 xN OUTN cap_mim_2f0_m4m5_noshield c_width=5u c_length=5u
X6 xN OUTN cap_mim_2f0_m4m5_noshield c_width=5u c_length=5u
X7 xN OUTN cap_mim_2f0_m4m5_noshield c_width=5u c_length=5u
X8 xN OUTN cap_mim_2f0_m4m5_noshield c_width=5u c_length=5u
X9 xN OUTN cap_mim_2f0_m4m5_noshield c_width=5u c_length=5u
X10 xN OUTN cap_mim_2f0_m4m5_noshield c_width=5u c_length=5u
X11 xN OUTN cap_mim_2f0_m4m5_noshield c_width=5u c_length=5u
X12 xN OUTN cap_mim_2f0_m4m5_noshield c_width=5u c_length=5u
X13 xN OUTN cap_mim_2f0_m4m5_noshield c_width=5u c_length=5u
X14 xN OUTN cap_mim_2f0_m4m5_noshield c_width=5u c_length=5u
X15 xN OUTN cap_mim_2f0_m4m5_noshield c_width=5u c_length=5u
X16 xN OUTN cap_mim_2f0_m4m5_noshield c_width=5u c_length=5u
X17 xN OUTN cap_mim_2f0_m4m5_noshield c_width=5u c_length=5u
X18 xN OUTN cap_mim_2f0_m4m5_noshield c_width=5u c_length=5u
X19 xN OUTN cap_mim_2f0_m4m5_noshield c_width=5u c_length=5u
X20 xN OUTN cap_mim_2f0_m4m5_noshield c_width=5u c_length=5u
X21 xN OUTN cap_mim_2f0_m4m5_noshield c_width=5u c_length=5u
X22 xN OUTN cap_mim_2f0_m4m5_noshield c_width=5u c_length=5u
X23 xN OUTN cap_mim_2f0_m4m5_noshield c_width=5u c_length=5u
X24 xN OUTN cap_mim_2f0_m4m5_noshield c_width=5u c_length=5u
X25 xN OUTN cap_mim_2f0_m4m5_noshield c_width=5u c_length=5u
X26 xN OUTN cap_mim_2f0_m4m5_noshield c_width=5u c_length=5u
X27 xN OUTN cap_mim_2f0_m4m5_noshield c_width=5u c_length=5u
X28 xN OUTN cap_mim_2f0_m4m5_noshield c_width=5u c_length=5u
X29 xN OUTN cap_mim_2f0_m4m5_noshield c_width=5u c_length=5u
X30 xN OUTN cap_mim_2f0_m4m5_noshield c_width=5u c_length=5u
X31 xN OUTN cap_mim_2f0_m4m5_noshield c_width=5u c_length=5u
X32 xN OUTN cap_mim_2f0_m4m5_noshield c_width=5u c_length=5u
X33 xN OUTN cap_mim_2f0_m4m5_noshield c_width=5u c_length=5u
X34 xN OUTN cap_mim_2f0_m4m5_noshield c_width=5u c_length=5u
X35 xN OUTN cap_mim_2f0_m4m5_noshield c_width=5u c_length=5u
X36 xN OUTN cap_mim_2f0_m4m5_noshield c_width=5u c_length=5u
X37 xN OUTN cap_mim_2f0_m4m5_noshield c_width=5u c_length=5u
X38 xN OUTN cap_mim_2f0_m4m5_noshield c_width=5u c_length=5u
X39 xN OUTN cap_mim_2f0_m4m5_noshield c_width=5u c_length=5u
X40 xN OUTN cap_mim_2f0_m4m5_noshield c_width=5u c_length=5u
X41 xN OUTN cap_mim_2f0_m4m5_noshield c_width=5u c_length=5u
X42 xN OUTN cap_mim_2f0_m4m5_noshield c_width=5u c_length=5u
X43 xN OUTN cap_mim_2f0_m4m5_noshield c_width=5u c_length=5u
X44 xN OUTN cap_mim_2f0_m4m5_noshield c_width=5u c_length=5u
X45 xN OUTN cap_mim_2f0_m4m5_noshield c_width=5u c_length=5u
X46 xN OUTN cap_mim_2f0_m4m5_noshield c_width=5u c_length=5u
X47 xN OUTN cap_mim_2f0_m4m5_noshield c_width=5u c_length=5u
X48 xN OUTN cap_mim_2f0_m4m5_noshield c_width=5u c_length=5u
X49 xN OUTN cap_mim_2f0_m4m5_noshield c_width=5u c_length=5u
X50 xN OUTN cap_mim_2f0_m4m5_noshield c_width=5u c_length=5u
X51 xN OUTN cap_mim_2f0_m4m5_noshield c_width=5u c_length=5u
X52 xN OUTN cap_mim_2f0_m4m5_noshield c_width=5u c_length=5u
X53 xN OUTN cap_mim_2f0_m4m5_noshield c_width=5u c_length=5u
X54 xN OUTN cap_mim_2f0_m4m5_noshield c_width=5u c_length=5u
X55 xN OUTN cap_mim_2f0_m4m5_noshield c_width=5u c_length=5u
X56 xN OUTN cap_mim_2f0_m4m5_noshield c_width=5u c_length=5u
X57 xN OUTN cap_mim_2f0_m4m5_noshield c_width=5u c_length=5u
X58 xN OUTN cap_mim_2f0_m4m5_noshield c_width=5u c_length=5u
X59 xN OUTN cap_mim_2f0_m4m5_noshield c_width=5u c_length=5u
X60 xN OUTN cap_mim_2f0_m4m5_noshield c_width=5u c_length=5u
X61 xN OUTN cap_mim_2f0_m4m5_noshield c_width=5u c_length=5u
X62 xN OUTN cap_mim_2f0_m4m5_noshield c_width=5u c_length=5u
X63 xN OUTN cap_mim_2f0_m4m5_noshield c_width=5u c_length=5u
X64 xN OUTN cap_mim_2f0_m4m5_noshield c_width=5u c_length=5u
X65 xN OUTN cap_mim_2f0_m4m5_noshield c_width=5u c_length=5u
X66 xN OUTN cap_mim_2f0_m4m5_noshield c_width=5u c_length=5u
X67 xN OUTN cap_mim_2f0_m4m5_noshield c_width=5u c_length=5u
X68 xN OUTN cap_mim_2f0_m4m5_noshield c_width=5u c_length=5u
X69 xN OUTN cap_mim_2f0_m4m5_noshield c_width=5u c_length=5u
X70 xN OUTN cap_mim_2f0_m4m5_noshield c_width=5u c_length=5u
X71 xN OUTN cap_mim_2f0_m4m5_noshield c_width=5u c_length=5u
X72 xN OUTN cap_mim_2f0_m4m5_noshield c_width=5u c_length=5u
.ends

.subckt sk_lpf1_MFP VSS yP OUTP
X0 OUTP yP VSS OUTP pfet_03v3 ad=1.325p pd=5.53u as=1.325p ps=5.53u w=5u l=0.28u
X1 OUTP yP VSS OUTP pfet_03v3 ad=1.325p pd=5.53u as=1.325p ps=5.53u w=5u l=0.28u
X2 VSS yP OUTP OUTP pfet_03v3 ad=1.325p pd=5.53u as=1.325p ps=5.53u w=5u l=0.28u
X3 VSS yP OUTP OUTP pfet_03v3 ad=1.325p pd=5.53u as=2.225p ps=10.89u w=5u l=0.28u
X4 VSS yP OUTP OUTP pfet_03v3 ad=1.325p pd=5.53u as=1.325p ps=5.53u w=5u l=0.28u
X5 OUTP yP VSS OUTP pfet_03v3 ad=1.325p pd=5.53u as=1.325p ps=5.53u w=5u l=0.28u
X6 VSS yP OUTP OUTP pfet_03v3 ad=1.325p pd=5.53u as=1.325p ps=5.53u w=5u l=0.28u
X7 OUTP yP VSS OUTP pfet_03v3 ad=2.225p pd=10.89u as=1.325p ps=5.53u w=5u l=0.28u
.ends

.subckt sk_lpf1_C2P yP VSS
X0 yP VSS cap_mim_2f0_m4m5_noshield c_width=5u c_length=5u
X1 yP VSS cap_mim_2f0_m4m5_noshield c_width=5u c_length=5u
X2 yP VSS cap_mim_2f0_m4m5_noshield c_width=5u c_length=5u
X3 yP VSS cap_mim_2f0_m4m5_noshield c_width=5u c_length=5u
X4 yP VSS cap_mim_2f0_m4m5_noshield c_width=5u c_length=5u
X5 yP VSS cap_mim_2f0_m4m5_noshield c_width=5u c_length=5u
X6 yP VSS cap_mim_2f0_m4m5_noshield c_width=5u c_length=5u
X7 yP VSS cap_mim_2f0_m4m5_noshield c_width=5u c_length=5u
X8 yP VSS cap_mim_2f0_m4m5_noshield c_width=5u c_length=5u
X9 yP VSS cap_mim_2f0_m4m5_noshield c_width=5u c_length=5u
X10 yP VSS cap_mim_2f0_m4m5_noshield c_width=5u c_length=5u
X11 yP VSS cap_mim_2f0_m4m5_noshield c_width=5u c_length=5u
X12 yP VSS cap_mim_2f0_m4m5_noshield c_width=5u c_length=5u
X13 yP VSS cap_mim_2f0_m4m5_noshield c_width=5u c_length=5u
X14 yP VSS cap_mim_2f0_m4m5_noshield c_width=5u c_length=5u
X15 yP VSS cap_mim_2f0_m4m5_noshield c_width=5u c_length=5u
X16 yP VSS cap_mim_2f0_m4m5_noshield c_width=5u c_length=5u
X17 yP VSS cap_mim_2f0_m4m5_noshield c_width=5u c_length=5u
X18 yP VSS cap_mim_2f0_m4m5_noshield c_width=5u c_length=5u
X19 yP VSS cap_mim_2f0_m4m5_noshield c_width=5u c_length=5u
X20 yP VSS cap_mim_2f0_m4m5_noshield c_width=5u c_length=5u
X21 yP VSS cap_mim_2f0_m4m5_noshield c_width=5u c_length=5u
X22 yP VSS cap_mim_2f0_m4m5_noshield c_width=5u c_length=5u
X23 yP VSS cap_mim_2f0_m4m5_noshield c_width=5u c_length=5u
X24 yP VSS cap_mim_2f0_m4m5_noshield c_width=5u c_length=5u
X25 yP VSS cap_mim_2f0_m4m5_noshield c_width=5u c_length=5u
X26 yP VSS cap_mim_2f0_m4m5_noshield c_width=5u c_length=5u
X27 yP VSS cap_mim_2f0_m4m5_noshield c_width=5u c_length=5u
X28 yP VSS cap_mim_2f0_m4m5_noshield c_width=5u c_length=5u
X29 yP VSS cap_mim_2f0_m4m5_noshield c_width=5u c_length=5u
X30 yP VSS cap_mim_2f0_m4m5_noshield c_width=5u c_length=5u
X31 yP VSS cap_mim_2f0_m4m5_noshield c_width=5u c_length=5u
X32 yP VSS cap_mim_2f0_m4m5_noshield c_width=5u c_length=5u
X33 yP VSS cap_mim_2f0_m4m5_noshield c_width=5u c_length=5u
X34 yP VSS cap_mim_2f0_m4m5_noshield c_width=5u c_length=5u
X35 yP VSS cap_mim_2f0_m4m5_noshield c_width=5u c_length=5u
X36 yP VSS cap_mim_2f0_m4m5_noshield c_width=5u c_length=5u
X37 yP VSS cap_mim_2f0_m4m5_noshield c_width=5u c_length=5u
X38 yP VSS cap_mim_2f0_m4m5_noshield c_width=5u c_length=5u
X39 yP VSS cap_mim_2f0_m4m5_noshield c_width=5u c_length=5u
X40 yP VSS cap_mim_2f0_m4m5_noshield c_width=5u c_length=5u
X41 yP VSS cap_mim_2f0_m4m5_noshield c_width=5u c_length=5u
X42 yP VSS cap_mim_2f0_m4m5_noshield c_width=5u c_length=5u
X43 yP VSS cap_mim_2f0_m4m5_noshield c_width=5u c_length=5u
X44 yP VSS cap_mim_2f0_m4m5_noshield c_width=5u c_length=5u
X45 yP VSS cap_mim_2f0_m4m5_noshield c_width=5u c_length=5u
X46 yP VSS cap_mim_2f0_m4m5_noshield c_width=5u c_length=5u
X47 yP VSS cap_mim_2f0_m4m5_noshield c_width=5u c_length=5u
X48 yP VSS cap_mim_2f0_m4m5_noshield c_width=5u c_length=5u
X49 yP VSS cap_mim_2f0_m4m5_noshield c_width=5u c_length=5u
X50 yP VSS cap_mim_2f0_m4m5_noshield c_width=5u c_length=5u
X51 yP VSS cap_mim_2f0_m4m5_noshield c_width=5u c_length=5u
X52 yP VSS cap_mim_2f0_m4m5_noshield c_width=5u c_length=5u
X53 yP VSS cap_mim_2f0_m4m5_noshield c_width=5u c_length=5u
X54 yP VSS cap_mim_2f0_m4m5_noshield c_width=5u c_length=5u
X55 yP VSS cap_mim_2f0_m4m5_noshield c_width=5u c_length=5u
X56 yP VSS cap_mim_2f0_m4m5_noshield c_width=5u c_length=5u
X57 yP VSS cap_mim_2f0_m4m5_noshield c_width=5u c_length=5u
X58 yP VSS cap_mim_2f0_m4m5_noshield c_width=5u c_length=5u
X59 yP VSS cap_mim_2f0_m4m5_noshield c_width=5u c_length=5u
X60 yP VSS cap_mim_2f0_m4m5_noshield c_width=5u c_length=5u
X61 yP VSS cap_mim_2f0_m4m5_noshield c_width=5u c_length=5u
X62 yP VSS cap_mim_2f0_m4m5_noshield c_width=5u c_length=5u
X63 yP VSS cap_mim_2f0_m4m5_noshield c_width=5u c_length=5u
X64 yP VSS cap_mim_2f0_m4m5_noshield c_width=5u c_length=5u
X65 yP VSS cap_mim_2f0_m4m5_noshield c_width=5u c_length=5u
X66 yP VSS cap_mim_2f0_m4m5_noshield c_width=5u c_length=5u
X67 yP VSS cap_mim_2f0_m4m5_noshield c_width=5u c_length=5u
X68 yP VSS cap_mim_2f0_m4m5_noshield c_width=5u c_length=5u
X69 yP VSS cap_mim_2f0_m4m5_noshield c_width=5u c_length=5u
X70 yP VSS cap_mim_2f0_m4m5_noshield c_width=5u c_length=5u
X71 yP VSS cap_mim_2f0_m4m5_noshield c_width=5u c_length=5u
X72 yP VSS cap_mim_2f0_m4m5_noshield c_width=5u c_length=5u
X73 yP VSS cap_mim_2f0_m4m5_noshield c_width=5u c_length=5u
X74 yP VSS cap_mim_2f0_m4m5_noshield c_width=5u c_length=5u
X75 yP VSS cap_mim_2f0_m4m5_noshield c_width=5u c_length=5u
X76 yP VSS cap_mim_2f0_m4m5_noshield c_width=5u c_length=5u
X77 yP VSS cap_mim_2f0_m4m5_noshield c_width=5u c_length=5u
X78 yP VSS cap_mim_2f0_m4m5_noshield c_width=5u c_length=5u
X79 yP VSS cap_mim_2f0_m4m5_noshield c_width=5u c_length=5u
X80 yP VSS cap_mim_2f0_m4m5_noshield c_width=5u c_length=5u
X81 yP VSS cap_mim_2f0_m4m5_noshield c_width=5u c_length=5u
X82 yP VSS cap_mim_2f0_m4m5_noshield c_width=5u c_length=5u
X83 yP VSS cap_mim_2f0_m4m5_noshield c_width=5u c_length=5u
.ends

.subckt sk_lpf1_C1P xP OUTP
X0 xP OUTP cap_mim_2f0_m4m5_noshield c_width=5u c_length=5u
X1 xP OUTP cap_mim_2f0_m4m5_noshield c_width=5u c_length=5u
X2 xP OUTP cap_mim_2f0_m4m5_noshield c_width=5u c_length=5u
X3 xP OUTP cap_mim_2f0_m4m5_noshield c_width=5u c_length=5u
X4 xP OUTP cap_mim_2f0_m4m5_noshield c_width=5u c_length=5u
X5 xP OUTP cap_mim_2f0_m4m5_noshield c_width=5u c_length=5u
X6 xP OUTP cap_mim_2f0_m4m5_noshield c_width=5u c_length=5u
X7 xP OUTP cap_mim_2f0_m4m5_noshield c_width=5u c_length=5u
X8 xP OUTP cap_mim_2f0_m4m5_noshield c_width=5u c_length=5u
X9 xP OUTP cap_mim_2f0_m4m5_noshield c_width=5u c_length=5u
X10 xP OUTP cap_mim_2f0_m4m5_noshield c_width=5u c_length=5u
X11 xP OUTP cap_mim_2f0_m4m5_noshield c_width=5u c_length=5u
X12 xP OUTP cap_mim_2f0_m4m5_noshield c_width=5u c_length=5u
X13 xP OUTP cap_mim_2f0_m4m5_noshield c_width=5u c_length=5u
X14 xP OUTP cap_mim_2f0_m4m5_noshield c_width=5u c_length=5u
X15 xP OUTP cap_mim_2f0_m4m5_noshield c_width=5u c_length=5u
X16 xP OUTP cap_mim_2f0_m4m5_noshield c_width=5u c_length=5u
X17 xP OUTP cap_mim_2f0_m4m5_noshield c_width=5u c_length=5u
X18 xP OUTP cap_mim_2f0_m4m5_noshield c_width=5u c_length=5u
X19 xP OUTP cap_mim_2f0_m4m5_noshield c_width=5u c_length=5u
X20 xP OUTP cap_mim_2f0_m4m5_noshield c_width=5u c_length=5u
X21 xP OUTP cap_mim_2f0_m4m5_noshield c_width=5u c_length=5u
X22 xP OUTP cap_mim_2f0_m4m5_noshield c_width=5u c_length=5u
X23 xP OUTP cap_mim_2f0_m4m5_noshield c_width=5u c_length=5u
X24 xP OUTP cap_mim_2f0_m4m5_noshield c_width=5u c_length=5u
X25 xP OUTP cap_mim_2f0_m4m5_noshield c_width=5u c_length=5u
X26 xP OUTP cap_mim_2f0_m4m5_noshield c_width=5u c_length=5u
X27 xP OUTP cap_mim_2f0_m4m5_noshield c_width=5u c_length=5u
X28 xP OUTP cap_mim_2f0_m4m5_noshield c_width=5u c_length=5u
X29 xP OUTP cap_mim_2f0_m4m5_noshield c_width=5u c_length=5u
X30 xP OUTP cap_mim_2f0_m4m5_noshield c_width=5u c_length=5u
X31 xP OUTP cap_mim_2f0_m4m5_noshield c_width=5u c_length=5u
X32 xP OUTP cap_mim_2f0_m4m5_noshield c_width=5u c_length=5u
X33 xP OUTP cap_mim_2f0_m4m5_noshield c_width=5u c_length=5u
X34 xP OUTP cap_mim_2f0_m4m5_noshield c_width=5u c_length=5u
X35 xP OUTP cap_mim_2f0_m4m5_noshield c_width=5u c_length=5u
X36 xP OUTP cap_mim_2f0_m4m5_noshield c_width=5u c_length=5u
X37 xP OUTP cap_mim_2f0_m4m5_noshield c_width=5u c_length=5u
X38 xP OUTP cap_mim_2f0_m4m5_noshield c_width=5u c_length=5u
X39 xP OUTP cap_mim_2f0_m4m5_noshield c_width=5u c_length=5u
X40 xP OUTP cap_mim_2f0_m4m5_noshield c_width=5u c_length=5u
X41 xP OUTP cap_mim_2f0_m4m5_noshield c_width=5u c_length=5u
X42 xP OUTP cap_mim_2f0_m4m5_noshield c_width=5u c_length=5u
X43 xP OUTP cap_mim_2f0_m4m5_noshield c_width=5u c_length=5u
X44 xP OUTP cap_mim_2f0_m4m5_noshield c_width=5u c_length=5u
X45 xP OUTP cap_mim_2f0_m4m5_noshield c_width=5u c_length=5u
X46 xP OUTP cap_mim_2f0_m4m5_noshield c_width=5u c_length=5u
X47 xP OUTP cap_mim_2f0_m4m5_noshield c_width=5u c_length=5u
X48 xP OUTP cap_mim_2f0_m4m5_noshield c_width=5u c_length=5u
X49 xP OUTP cap_mim_2f0_m4m5_noshield c_width=5u c_length=5u
X50 xP OUTP cap_mim_2f0_m4m5_noshield c_width=5u c_length=5u
X51 xP OUTP cap_mim_2f0_m4m5_noshield c_width=5u c_length=5u
X52 xP OUTP cap_mim_2f0_m4m5_noshield c_width=5u c_length=5u
X53 xP OUTP cap_mim_2f0_m4m5_noshield c_width=5u c_length=5u
X54 xP OUTP cap_mim_2f0_m4m5_noshield c_width=5u c_length=5u
X55 xP OUTP cap_mim_2f0_m4m5_noshield c_width=5u c_length=5u
X56 xP OUTP cap_mim_2f0_m4m5_noshield c_width=5u c_length=5u
X57 xP OUTP cap_mim_2f0_m4m5_noshield c_width=5u c_length=5u
X58 xP OUTP cap_mim_2f0_m4m5_noshield c_width=5u c_length=5u
X59 xP OUTP cap_mim_2f0_m4m5_noshield c_width=5u c_length=5u
X60 xP OUTP cap_mim_2f0_m4m5_noshield c_width=5u c_length=5u
X61 xP OUTP cap_mim_2f0_m4m5_noshield c_width=5u c_length=5u
X62 xP OUTP cap_mim_2f0_m4m5_noshield c_width=5u c_length=5u
X63 xP OUTP cap_mim_2f0_m4m5_noshield c_width=5u c_length=5u
X64 xP OUTP cap_mim_2f0_m4m5_noshield c_width=5u c_length=5u
X65 xP OUTP cap_mim_2f0_m4m5_noshield c_width=5u c_length=5u
X66 xP OUTP cap_mim_2f0_m4m5_noshield c_width=5u c_length=5u
X67 xP OUTP cap_mim_2f0_m4m5_noshield c_width=5u c_length=5u
X68 xP OUTP cap_mim_2f0_m4m5_noshield c_width=5u c_length=5u
X69 xP OUTP cap_mim_2f0_m4m5_noshield c_width=5u c_length=5u
X70 xP OUTP cap_mim_2f0_m4m5_noshield c_width=5u c_length=5u
X71 xP OUTP cap_mim_2f0_m4m5_noshield c_width=5u c_length=5u
X72 xP OUTP cap_mim_2f0_m4m5_noshield c_width=5u c_length=5u
.ends

.subckt sk_lpf1_R1u_0 xP INP xN INN yP yN VSS
X0 xN yN VSS ppolyf_u_1k r_width=1u r_length=3u
X1 INN xN VSS ppolyf_u_1k r_width=1u r_length=1u
X2 xP yP VSS ppolyf_u_1k r_width=1u r_length=3u
X3 INP xP VSS ppolyf_u_1k r_width=1u r_length=1u
.ends

.subckt sk_lpf1_MIP_MIN OUTP OUTN PB VDD
X0 VDD PB OUTP VDD pfet_03v3 ad=4.45p pd=20.89u as=2.65p ps=10.53u w=10u l=2u
X1 VDD PB OUTP VDD pfet_03v3 ad=2.65p pd=10.53u as=2.65p ps=10.53u w=10u l=2u
X2 OUTN PB VDD VDD pfet_03v3 ad=2.65p pd=10.53u as=2.65p ps=10.53u w=10u l=2u
X3 OUTP PB VDD VDD pfet_03v3 ad=2.65p pd=10.53u as=2.65p ps=10.53u w=10u l=2u
X4 OUTP PB VDD VDD pfet_03v3 ad=2.65p pd=10.53u as=2.65p ps=10.53u w=10u l=2u
X5 OUTN PB VDD VDD pfet_03v3 ad=2.65p pd=10.53u as=2.65p ps=10.53u w=10u l=2u
X6 VDD PB OUTP VDD pfet_03v3 ad=2.65p pd=10.53u as=2.65p ps=10.53u w=10u l=2u
X7 OUTN PB VDD VDD pfet_03v3 ad=2.65p pd=10.53u as=2.65p ps=10.53u w=10u l=2u
X8 VDD PB OUTN VDD pfet_03v3 ad=2.65p pd=10.53u as=2.65p ps=10.53u w=10u l=2u
X9 VDD PB OUTN VDD pfet_03v3 ad=2.65p pd=10.53u as=2.65p ps=10.53u w=10u l=2u
X10 VDD PB OUTN VDD pfet_03v3 ad=2.65p pd=10.53u as=2.65p ps=10.53u w=10u l=2u
X11 OUTP PB VDD VDD pfet_03v3 ad=2.65p pd=10.53u as=2.65p ps=10.53u w=10u l=2u
X12 OUTN PB VDD VDD pfet_03v3 ad=2.65p pd=10.53u as=2.65p ps=10.53u w=10u l=2u
X13 OUTP PB VDD VDD pfet_03v3 ad=2.65p pd=10.53u as=2.65p ps=10.53u w=10u l=2u
X14 VDD PB OUTN VDD pfet_03v3 ad=2.65p pd=10.53u as=2.65p ps=10.53u w=10u l=2u
X15 VDD PB OUTP VDD pfet_03v3 ad=2.65p pd=10.53u as=2.65p ps=10.53u w=10u l=2u
X16 VDD PB OUTP VDD pfet_03v3 ad=2.65p pd=10.53u as=2.65p ps=10.53u w=10u l=2u
X17 OUTP PB VDD VDD pfet_03v3 ad=2.65p pd=10.53u as=4.45p ps=20.89u w=10u l=2u
X18 OUTP PB VDD VDD pfet_03v3 ad=2.65p pd=10.53u as=2.65p ps=10.53u w=10u l=2u
X19 OUTN PB VDD VDD pfet_03v3 ad=2.65p pd=10.53u as=2.65p ps=10.53u w=10u l=2u
X20 OUTN PB VDD VDD pfet_03v3 ad=2.65p pd=10.53u as=2.65p ps=10.53u w=10u l=2u
X21 VDD PB OUTN VDD pfet_03v3 ad=2.65p pd=10.53u as=2.65p ps=10.53u w=10u l=2u
X22 VDD PB OUTP VDD pfet_03v3 ad=2.65p pd=10.53u as=2.65p ps=10.53u w=10u l=2u
X23 VDD PB OUTN VDD pfet_03v3 ad=2.65p pd=10.53u as=2.65p ps=10.53u w=10u l=2u
X24 VDD PB OUTN VDD pfet_03v3 ad=2.65p pd=10.53u as=2.65p ps=10.53u w=10u l=2u
X25 OUTN PB VDD VDD pfet_03v3 ad=2.65p pd=10.53u as=2.65p ps=10.53u w=10u l=2u
X26 OUTP PB VDD VDD pfet_03v3 ad=2.65p pd=10.53u as=2.65p ps=10.53u w=10u l=2u
X27 OUTP PB VDD VDD pfet_03v3 ad=2.65p pd=10.53u as=2.65p ps=10.53u w=10u l=2u
X28 VDD PB OUTP VDD pfet_03v3 ad=2.65p pd=10.53u as=2.65p ps=10.53u w=10u l=2u
X29 OUTN PB VDD VDD pfet_03v3 ad=2.65p pd=10.53u as=2.65p ps=10.53u w=10u l=2u
X30 VDD PB OUTP VDD pfet_03v3 ad=4.45p pd=20.89u as=2.65p ps=10.53u w=10u l=2u
X31 OUTN PB VDD VDD pfet_03v3 ad=2.65p pd=10.53u as=2.65p ps=10.53u w=10u l=2u
X32 OUTP PB VDD VDD pfet_03v3 ad=2.65p pd=10.53u as=2.65p ps=10.53u w=10u l=2u
X33 OUTN PB VDD VDD pfet_03v3 ad=2.65p pd=10.53u as=2.65p ps=10.53u w=10u l=2u
X34 OUTN PB VDD VDD pfet_03v3 ad=2.65p pd=10.53u as=2.65p ps=10.53u w=10u l=2u
X35 OUTP PB VDD VDD pfet_03v3 ad=2.65p pd=10.53u as=2.65p ps=10.53u w=10u l=2u
X36 VDD PB OUTP VDD pfet_03v3 ad=2.65p pd=10.53u as=2.65p ps=10.53u w=10u l=2u
X37 VDD PB OUTN VDD pfet_03v3 ad=2.65p pd=10.53u as=2.65p ps=10.53u w=10u l=2u
X38 VDD PB OUTP VDD pfet_03v3 ad=2.65p pd=10.53u as=2.65p ps=10.53u w=10u l=2u
X39 OUTN PB VDD VDD pfet_03v3 ad=2.65p pd=10.53u as=2.65p ps=10.53u w=10u l=2u
X40 OUTN PB VDD VDD pfet_03v3 ad=2.65p pd=10.53u as=2.65p ps=10.53u w=10u l=2u
X41 VDD PB OUTN VDD pfet_03v3 ad=2.65p pd=10.53u as=2.65p ps=10.53u w=10u l=2u
X42 VDD PB OUTP VDD pfet_03v3 ad=2.65p pd=10.53u as=2.65p ps=10.53u w=10u l=2u
X43 VDD PB OUTP VDD pfet_03v3 ad=2.65p pd=10.53u as=2.65p ps=10.53u w=10u l=2u
X44 VDD PB OUTN VDD pfet_03v3 ad=2.65p pd=10.53u as=2.65p ps=10.53u w=10u l=2u
X45 OUTP PB VDD VDD pfet_03v3 ad=2.65p pd=10.53u as=2.65p ps=10.53u w=10u l=2u
X46 VDD PB OUTN VDD pfet_03v3 ad=2.65p pd=10.53u as=2.65p ps=10.53u w=10u l=2u
X47 OUTP PB VDD VDD pfet_03v3 ad=2.65p pd=10.53u as=4.45p ps=20.89u w=10u l=2u
X48 VDD PB OUTN VDD pfet_03v3 ad=2.65p pd=10.53u as=2.65p ps=10.53u w=10u l=2u
X49 OUTP PB VDD VDD pfet_03v3 ad=2.65p pd=10.53u as=2.65p ps=10.53u w=10u l=2u
X50 VDD PB OUTP VDD pfet_03v3 ad=2.65p pd=10.53u as=2.65p ps=10.53u w=10u l=2u
X51 VDD PB OUTN VDD pfet_03v3 ad=2.65p pd=10.53u as=2.65p ps=10.53u w=10u l=2u
X52 OUTN PB VDD VDD pfet_03v3 ad=2.65p pd=10.53u as=2.65p ps=10.53u w=10u l=2u
X53 OUTP PB VDD VDD pfet_03v3 ad=2.65p pd=10.53u as=2.65p ps=10.53u w=10u l=2u
X54 OUTP PB VDD VDD pfet_03v3 ad=2.65p pd=10.53u as=2.65p ps=10.53u w=10u l=2u
X55 OUTN PB VDD VDD pfet_03v3 ad=2.65p pd=10.53u as=2.65p ps=10.53u w=10u l=2u
X56 OUTN PB VDD VDD pfet_03v3 ad=2.65p pd=10.53u as=2.65p ps=10.53u w=10u l=2u
X57 OUTP PB VDD VDD pfet_03v3 ad=2.65p pd=10.53u as=2.65p ps=10.53u w=10u l=2u
X58 OUTN PB VDD VDD pfet_03v3 ad=2.65p pd=10.53u as=2.65p ps=10.53u w=10u l=2u
X59 VDD PB OUTP VDD pfet_03v3 ad=2.65p pd=10.53u as=2.65p ps=10.53u w=10u l=2u
X60 VDD PB OUTN VDD pfet_03v3 ad=2.65p pd=10.53u as=2.65p ps=10.53u w=10u l=2u
X61 VDD PB OUTN VDD pfet_03v3 ad=2.65p pd=10.53u as=2.65p ps=10.53u w=10u l=2u
X62 OUTN PB VDD VDD pfet_03v3 ad=2.65p pd=10.53u as=2.65p ps=10.53u w=10u l=2u
X63 OUTP PB VDD VDD pfet_03v3 ad=2.65p pd=10.53u as=2.65p ps=10.53u w=10u l=2u
X64 OUTN PB VDD VDD pfet_03v3 ad=2.65p pd=10.53u as=2.65p ps=10.53u w=10u l=2u
X65 VDD PB OUTP VDD pfet_03v3 ad=2.65p pd=10.53u as=2.65p ps=10.53u w=10u l=2u
X66 OUTN PB VDD VDD pfet_03v3 ad=2.65p pd=10.53u as=2.65p ps=10.53u w=10u l=2u
X67 VDD PB OUTP VDD pfet_03v3 ad=2.65p pd=10.53u as=2.65p ps=10.53u w=10u l=2u
X68 VDD PB OUTN VDD pfet_03v3 ad=2.65p pd=10.53u as=2.65p ps=10.53u w=10u l=2u
X69 VDD PB OUTN VDD pfet_03v3 ad=2.65p pd=10.53u as=2.65p ps=10.53u w=10u l=2u
X70 OUTP PB VDD VDD pfet_03v3 ad=2.65p pd=10.53u as=2.65p ps=10.53u w=10u l=2u
X71 OUTP PB VDD VDD pfet_03v3 ad=2.65p pd=10.53u as=2.65p ps=10.53u w=10u l=2u
X72 VDD PB OUTN VDD pfet_03v3 ad=2.65p pd=10.53u as=2.65p ps=10.53u w=10u l=2u
X73 VDD PB OUTN VDD pfet_03v3 ad=2.65p pd=10.53u as=2.65p ps=10.53u w=10u l=2u
X74 VDD PB OUTP VDD pfet_03v3 ad=2.65p pd=10.53u as=2.65p ps=10.53u w=10u l=2u
X75 VDD PB OUTP VDD pfet_03v3 ad=2.65p pd=10.53u as=2.65p ps=10.53u w=10u l=2u
X76 OUTN PB VDD VDD pfet_03v3 ad=2.65p pd=10.53u as=2.65p ps=10.53u w=10u l=2u
X77 VDD PB OUTN VDD pfet_03v3 ad=2.65p pd=10.53u as=2.65p ps=10.53u w=10u l=2u
X78 OUTP PB VDD VDD pfet_03v3 ad=2.65p pd=10.53u as=2.65p ps=10.53u w=10u l=2u
X79 VDD PB OUTP VDD pfet_03v3 ad=2.65p pd=10.53u as=2.65p ps=10.53u w=10u l=2u
X80 OUTN PB VDD VDD pfet_03v3 ad=2.65p pd=10.53u as=2.65p ps=10.53u w=10u l=2u
X81 OUTN PB VDD VDD pfet_03v3 ad=2.65p pd=10.53u as=2.65p ps=10.53u w=10u l=2u
X82 OUTP PB VDD VDD pfet_03v3 ad=2.65p pd=10.53u as=2.65p ps=10.53u w=10u l=2u
X83 OUTN PB VDD VDD pfet_03v3 ad=2.65p pd=10.53u as=2.65p ps=10.53u w=10u l=2u
X84 OUTP PB VDD VDD pfet_03v3 ad=2.65p pd=10.53u as=2.65p ps=10.53u w=10u l=2u
X85 VDD PB OUTP VDD pfet_03v3 ad=2.65p pd=10.53u as=2.65p ps=10.53u w=10u l=2u
X86 VDD PB OUTN VDD pfet_03v3 ad=2.65p pd=10.53u as=2.65p ps=10.53u w=10u l=2u
X87 OUTN PB VDD VDD pfet_03v3 ad=2.65p pd=10.53u as=2.65p ps=10.53u w=10u l=2u
X88 VDD PB OUTN VDD pfet_03v3 ad=2.65p pd=10.53u as=2.65p ps=10.53u w=10u l=2u
X89 OUTP PB VDD VDD pfet_03v3 ad=2.65p pd=10.53u as=2.65p ps=10.53u w=10u l=2u
X90 OUTN PB VDD VDD pfet_03v3 ad=2.65p pd=10.53u as=2.65p ps=10.53u w=10u l=2u
X91 VDD PB OUTN VDD pfet_03v3 ad=2.65p pd=10.53u as=2.65p ps=10.53u w=10u l=2u
X92 VDD PB OUTN VDD pfet_03v3 ad=2.65p pd=10.53u as=2.65p ps=10.53u w=10u l=2u
X93 OUTP PB VDD VDD pfet_03v3 ad=2.65p pd=10.53u as=2.65p ps=10.53u w=10u l=2u
X94 VDD PB OUTP VDD pfet_03v3 ad=2.65p pd=10.53u as=2.65p ps=10.53u w=10u l=2u
X95 OUTN PB VDD VDD pfet_03v3 ad=2.65p pd=10.53u as=2.65p ps=10.53u w=10u l=2u
X96 VDD PB OUTN VDD pfet_03v3 ad=2.65p pd=10.53u as=2.65p ps=10.53u w=10u l=2u
X97 VDD PB OUTP VDD pfet_03v3 ad=2.65p pd=10.53u as=2.65p ps=10.53u w=10u l=2u
X98 VDD PB OUTN VDD pfet_03v3 ad=2.65p pd=10.53u as=2.65p ps=10.53u w=10u l=2u
X99 OUTP PB VDD VDD pfet_03v3 ad=2.65p pd=10.53u as=2.65p ps=10.53u w=10u l=2u
X100 OUTP PB VDD VDD pfet_03v3 ad=2.65p pd=10.53u as=2.65p ps=10.53u w=10u l=2u
X101 VDD PB OUTP VDD pfet_03v3 ad=2.65p pd=10.53u as=2.65p ps=10.53u w=10u l=2u
X102 VDD PB OUTN VDD pfet_03v3 ad=2.65p pd=10.53u as=2.65p ps=10.53u w=10u l=2u
X103 OUTP PB VDD VDD pfet_03v3 ad=2.65p pd=10.53u as=2.65p ps=10.53u w=10u l=2u
X104 VDD PB OUTP VDD pfet_03v3 ad=2.65p pd=10.53u as=2.65p ps=10.53u w=10u l=2u
X105 OUTN PB VDD VDD pfet_03v3 ad=2.65p pd=10.53u as=2.65p ps=10.53u w=10u l=2u
X106 OUTN PB VDD VDD pfet_03v3 ad=2.65p pd=10.53u as=2.65p ps=10.53u w=10u l=2u
X107 OUTP PB VDD VDD pfet_03v3 ad=2.65p pd=10.53u as=2.65p ps=10.53u w=10u l=2u
X108 OUTP PB VDD VDD pfet_03v3 ad=2.65p pd=10.53u as=2.65p ps=10.53u w=10u l=2u
X109 VDD PB OUTN VDD pfet_03v3 ad=2.65p pd=10.53u as=2.65p ps=10.53u w=10u l=2u
X110 OUTN PB VDD VDD pfet_03v3 ad=2.65p pd=10.53u as=2.65p ps=10.53u w=10u l=2u
X111 VDD PB OUTN VDD pfet_03v3 ad=2.65p pd=10.53u as=2.65p ps=10.53u w=10u l=2u
X112 VDD PB OUTP VDD pfet_03v3 ad=2.65p pd=10.53u as=2.65p ps=10.53u w=10u l=2u
X113 OUTP PB VDD VDD pfet_03v3 ad=2.65p pd=10.53u as=2.65p ps=10.53u w=10u l=2u
X114 OUTN PB VDD VDD pfet_03v3 ad=2.65p pd=10.53u as=2.65p ps=10.53u w=10u l=2u
X115 VDD PB OUTP VDD pfet_03v3 ad=2.65p pd=10.53u as=2.65p ps=10.53u w=10u l=2u
X116 OUTP PB VDD VDD pfet_03v3 ad=2.65p pd=10.53u as=2.65p ps=10.53u w=10u l=2u
X117 VDD PB OUTP VDD pfet_03v3 ad=2.65p pd=10.53u as=2.65p ps=10.53u w=10u l=2u
X118 VDD PB OUTP VDD pfet_03v3 ad=2.65p pd=10.53u as=2.65p ps=10.53u w=10u l=2u
X119 VDD PB OUTP VDD pfet_03v3 ad=2.65p pd=10.53u as=2.65p ps=10.53u w=10u l=2u
X120 VDD PB OUTP VDD pfet_03v3 ad=2.65p pd=10.53u as=2.65p ps=10.53u w=10u l=2u
X121 VDD PB OUTN VDD pfet_03v3 ad=2.65p pd=10.53u as=2.65p ps=10.53u w=10u l=2u
X122 OUTN PB VDD VDD pfet_03v3 ad=2.65p pd=10.53u as=2.65p ps=10.53u w=10u l=2u
X123 VDD PB OUTN VDD pfet_03v3 ad=2.65p pd=10.53u as=2.65p ps=10.53u w=10u l=2u
X124 VDD PB OUTP VDD pfet_03v3 ad=2.65p pd=10.53u as=2.65p ps=10.53u w=10u l=2u
X125 VDD PB OUTP VDD pfet_03v3 ad=2.65p pd=10.53u as=2.65p ps=10.53u w=10u l=2u
X126 VDD PB OUTN VDD pfet_03v3 ad=2.65p pd=10.53u as=2.65p ps=10.53u w=10u l=2u
X127 OUTP PB VDD VDD pfet_03v3 ad=2.65p pd=10.53u as=2.65p ps=10.53u w=10u l=2u
.ends

.subckt sk_lpf1 VSS VDD INP INN PB OUTP OUTN
XXMFN VSS XMFN/yN OUTN sk_lpf1_MFN
XXC2N XMFN/yN VSS sk_lpf1_C2N
XXC1N XC1N/xN OUTN sk_lpf1_C1N
XXMFP VSS XMFP/yP OUTP sk_lpf1_MFP
XXC2P XMFP/yP VSS sk_lpf1_C2P
XXC1P XC1P/xP OUTP sk_lpf1_C1P
XXR1u_0 XC1P/xP INP XC1N/xN INN XMFP/yP XMFN/yN VSS sk_lpf1_R1u_0
XXMIP_MIN OUTP OUTN PB VDD sk_lpf1_MIP_MIN
.ends
