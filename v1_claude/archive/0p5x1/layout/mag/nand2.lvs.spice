* NGSPICE file created from nand2.ext - technology: gf180mcuD

.subckt nand2_MP1 Y A VDD
X0 Y A VDD VDD pfet_03v3 ad=0.89p pd=4.89u as=0.89p ps=4.89u w=2u l=0.28u
.ends

.subckt nand2_MP2 Y B VDD
X0 Y B VDD VDD pfet_03v3 ad=0.89p pd=4.89u as=0.89p ps=4.89u w=2u l=0.28u
.ends

.subckt nand2_MN1 n1 Y A VSS
X0 Y A n1 VSS nfet_03v3 ad=0.89p pd=4.89u as=0.89p ps=4.89u w=2u l=0.28u
.ends

.subckt nand2_MN2 n1 B VSS
X0 n1 B VSS VSS nfet_03v3 ad=0.89p pd=4.89u as=0.89p ps=4.89u w=2u l=0.28u
.ends

.subckt nand2 VSS VDD A B Y
XXMP1 Y A VDD nand2_MP1
XXMP2 Y B VDD nand2_MP2
XXMN1 XMN2/n1 Y A VSS nand2_MN1
XXMN2 XMN2/n1 B VSS nand2_MN2
.ends
