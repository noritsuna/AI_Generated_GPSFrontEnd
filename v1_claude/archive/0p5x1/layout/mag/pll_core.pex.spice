* NGSPICE file created from pll_core_flat.ext - technology: gf180mcuD

.subckt pll_core_flat VSS VDD REFIN LO NB PB ICP2 VCTRL FS FB REFCK
X0 a_87640_80239# PB.t9 VDD VDD pfet_03v3 ad=2.12p pd=8.53u as=2.12p ps=8.53u w=8u l=2u
X1 a_3540_180844# VSS cap_mim_2f0_m4m5_noshield c_width=5u c_length=5u
X2 a_9420_18186# a_9840_16064# VSS ppolyf_u_1k r_width=1u r_length=10u
X3 a_3540_180844# VSS cap_mim_2f0_m4m5_noshield c_width=5u c_length=5u
X4 a_3540_180844# VSS cap_mim_2f0_m4m5_noshield c_width=5u c_length=5u
X5 a_3540_180844# VSS cap_mim_2f0_m4m5_noshield c_width=5u c_length=5u
X6 a_3540_180844# VSS cap_mim_2f0_m4m5_noshield c_width=5u c_length=5u
X7 a_3540_180844# VSS cap_mim_2f0_m4m5_noshield c_width=5u c_length=5u
X8 a_3540_180844# VSS cap_mim_2f0_m4m5_noshield c_width=5u c_length=5u
X9 a_3540_180844# VSS cap_mim_2f0_m4m5_noshield c_width=5u c_length=5u
X10 a_3540_180844# VSS cap_mim_2f0_m4m5_noshield c_width=5u c_length=5u
X11 a_3540_180844# VSS cap_mim_2f0_m4m5_noshield c_width=5u c_length=5u
X12 a_3540_181966.t7 VSS cap_mim_2f0_m4m5_noshield c_width=5u c_length=5u
X13 a_3540_180844# VSS cap_mim_2f0_m4m5_noshield c_width=5u c_length=5u
X14 a_3540_180844# VSS cap_mim_2f0_m4m5_noshield c_width=5u c_length=5u
X15 a_3540_180844# VSS cap_mim_2f0_m4m5_noshield c_width=5u c_length=5u
X16 REFIN a_3667_12409# cap_mim_2f0_m4m5_noshield c_width=5u c_length=5u
X17 a_3540_180844# VSS cap_mim_2f0_m4m5_noshield c_width=5u c_length=5u
X18 a_3540_180844# VSS cap_mim_2f0_m4m5_noshield c_width=5u c_length=5u
X19 a_3540_180844# VSS cap_mim_2f0_m4m5_noshield c_width=5u c_length=5u
X20 a_3540_180844# VSS cap_mim_2f0_m4m5_noshield c_width=5u c_length=5u
X21 a_3540_180844# VSS cap_mim_2f0_m4m5_noshield c_width=5u c_length=5u
X22 a_3540_180844# VSS cap_mim_2f0_m4m5_noshield c_width=5u c_length=5u
X23 a_3540_180844# VSS cap_mim_2f0_m4m5_noshield c_width=5u c_length=5u
X24 a_3540_180844# VSS cap_mim_2f0_m4m5_noshield c_width=5u c_length=5u
X25 a_3540_180844# VSS cap_mim_2f0_m4m5_noshield c_width=5u c_length=5u
X26 a_3540_180844# VSS cap_mim_2f0_m4m5_noshield c_width=5u c_length=5u
X27 a_3540_180844# VSS cap_mim_2f0_m4m5_noshield c_width=5u c_length=5u
X28 a_3540_181966.t7 VSS cap_mim_2f0_m4m5_noshield c_width=5u c_length=5u
X29 a_88109_80239# VSS cap_mim_2f0_m4m5_noshield c_width=5u c_length=5u
X30 a_3540_180844# VSS cap_mim_2f0_m4m5_noshield c_width=5u c_length=5u
X31 a_3540_181966.t7 VSS cap_mim_2f0_m4m5_noshield c_width=5u c_length=5u
X32 a_3540_181966.t7 VSS cap_mim_2f0_m4m5_noshield c_width=5u c_length=5u
X33 a_3540_180844# VSS cap_mim_2f0_m4m5_noshield c_width=5u c_length=5u
X34 a_88109_80239# VSS cap_mim_2f0_m4m5_noshield c_width=5u c_length=5u
X35 a_3540_180844# VSS cap_mim_2f0_m4m5_noshield c_width=5u c_length=5u
X36 a_3540_180844# VSS cap_mim_2f0_m4m5_noshield c_width=5u c_length=5u
X37 a_3540_180844# VSS cap_mim_2f0_m4m5_noshield c_width=5u c_length=5u
X38 a_3540_180844# VSS cap_mim_2f0_m4m5_noshield c_width=5u c_length=5u
X39 a_3540_180844# VSS cap_mim_2f0_m4m5_noshield c_width=5u c_length=5u
X40 a_3540_180844# VSS cap_mim_2f0_m4m5_noshield c_width=5u c_length=5u
X41 a_3540_180844# VSS cap_mim_2f0_m4m5_noshield c_width=5u c_length=5u
X42 a_3540_180844# VSS cap_mim_2f0_m4m5_noshield c_width=5u c_length=5u
X43 a_3540_180844# VSS cap_mim_2f0_m4m5_noshield c_width=5u c_length=5u
X44 a_3540_180844# VSS cap_mim_2f0_m4m5_noshield c_width=5u c_length=5u
X45 a_3540_180844# VSS cap_mim_2f0_m4m5_noshield c_width=5u c_length=5u
X46 a_3540_180844# VSS cap_mim_2f0_m4m5_noshield c_width=5u c_length=5u
X47 a_89421_69640# ICP2.t0 a_105420_69640# VSS nfet_03v3 ad=0.89p pd=4.89u as=0.53p ps=2.53u w=2u l=0.28u
X48 a_31785_45000# a_30105_36740# VDD VDD pfet_03v3 ad=0.89p pd=4.89u as=0.89p ps=4.89u w=2u l=0.28u
X49 a_3540_180844# VSS cap_mim_2f0_m4m5_noshield c_width=5u c_length=5u
X50 a_3540_181966.t7 VSS cap_mim_2f0_m4m5_noshield c_width=5u c_length=5u
X51 a_3540_180844# VSS cap_mim_2f0_m4m5_noshield c_width=5u c_length=5u
X52 a_3540_180844# VSS cap_mim_2f0_m4m5_noshield c_width=5u c_length=5u
X53 a_3540_180844# VSS cap_mim_2f0_m4m5_noshield c_width=5u c_length=5u
X54 a_3540_180844# VSS cap_mim_2f0_m4m5_noshield c_width=5u c_length=5u
X55 a_3540_180844# VSS cap_mim_2f0_m4m5_noshield c_width=5u c_length=5u
X56 a_3540_180844# VSS cap_mim_2f0_m4m5_noshield c_width=5u c_length=5u
X57 a_8147_62389# a_17667_83249# a_31640_61800# VSS nfet_03v3 ad=0.89p pd=4.89u as=0.89p ps=4.89u w=2u l=0.28u
X58 a_3540_180844# VSS cap_mim_2f0_m4m5_noshield c_width=5u c_length=5u
X59 a_3540_180844# VSS cap_mim_2f0_m4m5_noshield c_width=5u c_length=5u
X60 a_3540_180844# VSS cap_mim_2f0_m4m5_noshield c_width=5u c_length=5u
X61 a_3540_180844# VSS cap_mim_2f0_m4m5_noshield c_width=5u c_length=5u
X62 a_3540_180844# VSS cap_mim_2f0_m4m5_noshield c_width=5u c_length=5u
X63 a_3540_180844# VSS cap_mim_2f0_m4m5_noshield c_width=5u c_length=5u
X64 a_3540_180844# VSS cap_mim_2f0_m4m5_noshield c_width=5u c_length=5u
X65 a_3540_180844# VSS cap_mim_2f0_m4m5_noshield c_width=5u c_length=5u
X66 a_3540_180844# VSS cap_mim_2f0_m4m5_noshield c_width=5u c_length=5u
X67 a_3540_180844# VSS cap_mim_2f0_m4m5_noshield c_width=5u c_length=5u
X68 a_3540_180844# VSS cap_mim_2f0_m4m5_noshield c_width=5u c_length=5u
X69 a_3540_180844# VSS cap_mim_2f0_m4m5_noshield c_width=5u c_length=5u
X70 a_3540_181966.t7 VSS cap_mim_2f0_m4m5_noshield c_width=5u c_length=5u
X71 a_3540_180844# VSS cap_mim_2f0_m4m5_noshield c_width=5u c_length=5u
X72 a_3540_180844# VSS cap_mim_2f0_m4m5_noshield c_width=5u c_length=5u
X73 a_3540_180844# VSS cap_mim_2f0_m4m5_noshield c_width=5u c_length=5u
X74 a_3540_180844# VSS cap_mim_2f0_m4m5_noshield c_width=5u c_length=5u
X75 a_3540_180844# VSS cap_mim_2f0_m4m5_noshield c_width=5u c_length=5u
X76 a_3540_180844# VSS cap_mim_2f0_m4m5_noshield c_width=5u c_length=5u
X77 a_3540_180844# VSS cap_mim_2f0_m4m5_noshield c_width=5u c_length=5u
X78 a_3540_180844# VSS cap_mim_2f0_m4m5_noshield c_width=5u c_length=5u
X79 a_3540_180844# VSS cap_mim_2f0_m4m5_noshield c_width=5u c_length=5u
X80 a_3540_180844# VSS cap_mim_2f0_m4m5_noshield c_width=5u c_length=5u
X81 a_3540_180844# VSS cap_mim_2f0_m4m5_noshield c_width=5u c_length=5u
X82 a_3540_180844# VSS cap_mim_2f0_m4m5_noshield c_width=5u c_length=5u
X83 a_17667_83249# REFCK.t4 VDD VDD pfet_03v3 ad=0.89p pd=4.89u as=0.89p ps=4.89u w=2u l=0.28u
X84 a_3540_180844# VSS cap_mim_2f0_m4m5_noshield c_width=5u c_length=5u
X85 a_3540_180844# VSS cap_mim_2f0_m4m5_noshield c_width=5u c_length=5u
X86 a_3540_180844# VSS cap_mim_2f0_m4m5_noshield c_width=5u c_length=5u
X87 a_3540_181966.t7 VSS cap_mim_2f0_m4m5_noshield c_width=5u c_length=5u
X88 a_3540_180844# VSS cap_mim_2f0_m4m5_noshield c_width=5u c_length=5u
X89 a_3540_181966.t7 VSS cap_mim_2f0_m4m5_noshield c_width=5u c_length=5u
X90 a_3540_180844# VSS cap_mim_2f0_m4m5_noshield c_width=5u c_length=5u
X91 a_3540_180844# VSS cap_mim_2f0_m4m5_noshield c_width=5u c_length=5u
X92 a_3540_180844# VSS cap_mim_2f0_m4m5_noshield c_width=5u c_length=5u
X93 a_3540_180844# VSS cap_mim_2f0_m4m5_noshield c_width=5u c_length=5u
X94 a_3540_180844# VSS cap_mim_2f0_m4m5_noshield c_width=5u c_length=5u
X95 a_3540_180844# VSS cap_mim_2f0_m4m5_noshield c_width=5u c_length=5u
X96 a_3540_180844# VSS cap_mim_2f0_m4m5_noshield c_width=5u c_length=5u
X97 a_3540_181966.t7 VSS cap_mim_2f0_m4m5_noshield c_width=5u c_length=5u
X98 a_3540_180844# VSS cap_mim_2f0_m4m5_noshield c_width=5u c_length=5u
X99 a_3540_180844# VSS cap_mim_2f0_m4m5_noshield c_width=5u c_length=5u
X100 a_3540_180844# VSS cap_mim_2f0_m4m5_noshield c_width=5u c_length=5u
X101 a_3540_181966.t5 a_3540_180844# VSS ppolyf_u_1k r_width=1u r_length=5u
X102 a_3540_180844# VSS cap_mim_2f0_m4m5_noshield c_width=5u c_length=5u
X103 a_3540_180844# VSS cap_mim_2f0_m4m5_noshield c_width=5u c_length=5u
X104 a_88109_80239# VSS cap_mim_2f0_m4m5_noshield c_width=5u c_length=5u
X105 a_3540_180844# VSS cap_mim_2f0_m4m5_noshield c_width=5u c_length=5u
X106 a_3540_180844# VSS cap_mim_2f0_m4m5_noshield c_width=5u c_length=5u
X107 a_3540_180844# VSS cap_mim_2f0_m4m5_noshield c_width=5u c_length=5u
X108 a_3540_180844# VSS cap_mim_2f0_m4m5_noshield c_width=5u c_length=5u
X109 a_3540_181966.t7 VSS cap_mim_2f0_m4m5_noshield c_width=5u c_length=5u
X110 a_3540_180844# VSS cap_mim_2f0_m4m5_noshield c_width=5u c_length=5u
X111 a_3540_180844# VSS cap_mim_2f0_m4m5_noshield c_width=5u c_length=5u
X112 a_3540_180844# VSS cap_mim_2f0_m4m5_noshield c_width=5u c_length=5u
X113 a_3540_180844# VSS cap_mim_2f0_m4m5_noshield c_width=5u c_length=5u
X114 a_3540_180844# VSS cap_mim_2f0_m4m5_noshield c_width=5u c_length=5u
X115 a_3540_180844# VSS cap_mim_2f0_m4m5_noshield c_width=5u c_length=5u
X116 a_3540_180844# VSS cap_mim_2f0_m4m5_noshield c_width=5u c_length=5u
X117 a_3540_180844# VSS cap_mim_2f0_m4m5_noshield c_width=5u c_length=5u
X118 a_3540_180844# VSS cap_mim_2f0_m4m5_noshield c_width=5u c_length=5u
X119 REFIN a_3667_12409# cap_mim_2f0_m4m5_noshield c_width=5u c_length=5u
X120 a_3540_180844# VSS cap_mim_2f0_m4m5_noshield c_width=5u c_length=5u
X121 a_3540_180844# VSS cap_mim_2f0_m4m5_noshield c_width=5u c_length=5u
X122 a_3540_180844# VSS cap_mim_2f0_m4m5_noshield c_width=5u c_length=5u
X123 a_61465_32882# a_61347_33269# VSS VSS nfet_03v3 ad=0.445p pd=2.89u as=0.445p ps=2.89u w=1u l=0.28u
X124 a_3540_180844# VSS cap_mim_2f0_m4m5_noshield c_width=5u c_length=5u
X125 a_3540_180844# VSS cap_mim_2f0_m4m5_noshield c_width=5u c_length=5u
X126 a_3540_180844# VSS cap_mim_2f0_m4m5_noshield c_width=5u c_length=5u
X127 a_3540_181966.t7 VSS cap_mim_2f0_m4m5_noshield c_width=5u c_length=5u
X128 a_3540_180844# VSS cap_mim_2f0_m4m5_noshield c_width=5u c_length=5u
X129 a_3540_180844# VSS cap_mim_2f0_m4m5_noshield c_width=5u c_length=5u
X130 a_3540_180844# VSS cap_mim_2f0_m4m5_noshield c_width=5u c_length=5u
X131 a_3540_180844# VSS cap_mim_2f0_m4m5_noshield c_width=5u c_length=5u
X132 a_3540_180844# VSS cap_mim_2f0_m4m5_noshield c_width=5u c_length=5u
X133 a_3540_180844# VSS cap_mim_2f0_m4m5_noshield c_width=5u c_length=5u
X134 a_3540_180844# VSS cap_mim_2f0_m4m5_noshield c_width=5u c_length=5u
X135 a_3540_180844# VSS cap_mim_2f0_m4m5_noshield c_width=5u c_length=5u
X136 a_3540_180844# VSS cap_mim_2f0_m4m5_noshield c_width=5u c_length=5u
X137 a_3540_180844# VSS cap_mim_2f0_m4m5_noshield c_width=5u c_length=5u
X138 a_39625_36740# a_39507_45729# VDD VDD pfet_03v3 ad=1.335p pd=6.89u as=1.335p ps=6.89u w=3u l=0.28u
X139 a_3540_180844# VSS cap_mim_2f0_m4m5_noshield c_width=5u c_length=5u
X140 a_89880_80239# a_92189_81289# a_89421_74820# VDD pfet_03v3 ad=1.59p pd=6.53u as=2.67p ps=12.89u w=6u l=0.28u
X141 a_3540_180844# VSS cap_mim_2f0_m4m5_noshield c_width=5u c_length=5u
X142 a_3540_180844# VSS cap_mim_2f0_m4m5_noshield c_width=5u c_length=5u
X143 a_3540_180844# VSS cap_mim_2f0_m4m5_noshield c_width=5u c_length=5u
X144 a_3540_180844# VSS cap_mim_2f0_m4m5_noshield c_width=5u c_length=5u
X145 a_3540_180844# VSS cap_mim_2f0_m4m5_noshield c_width=5u c_length=5u
X146 a_3540_180844# VSS cap_mim_2f0_m4m5_noshield c_width=5u c_length=5u
X147 a_3540_180844# VSS cap_mim_2f0_m4m5_noshield c_width=5u c_length=5u
X148 a_3540_180844# VSS cap_mim_2f0_m4m5_noshield c_width=5u c_length=5u
X149 a_3540_180844# VSS cap_mim_2f0_m4m5_noshield c_width=5u c_length=5u
X150 a_3540_180844# VSS cap_mim_2f0_m4m5_noshield c_width=5u c_length=5u
X151 a_3540_181966.t7 VSS cap_mim_2f0_m4m5_noshield c_width=5u c_length=5u
X152 a_3540_180844# VSS cap_mim_2f0_m4m5_noshield c_width=5u c_length=5u
X153 a_3540_180844# VSS cap_mim_2f0_m4m5_noshield c_width=5u c_length=5u
X154 a_3540_180844# VSS cap_mim_2f0_m4m5_noshield c_width=5u c_length=5u
X155 a_3540_181966.t7 VSS cap_mim_2f0_m4m5_noshield c_width=5u c_length=5u
X156 a_3540_180844# VSS cap_mim_2f0_m4m5_noshield c_width=5u c_length=5u
X157 a_3540_180844# VSS cap_mim_2f0_m4m5_noshield c_width=5u c_length=5u
X158 a_3540_180844# VSS cap_mim_2f0_m4m5_noshield c_width=5u c_length=5u
X159 a_3540_180844# VSS cap_mim_2f0_m4m5_noshield c_width=5u c_length=5u
X160 a_3540_180844# VSS cap_mim_2f0_m4m5_noshield c_width=5u c_length=5u
X161 a_3540_180844# VSS cap_mim_2f0_m4m5_noshield c_width=5u c_length=5u
X162 a_3540_180844# VSS cap_mim_2f0_m4m5_noshield c_width=5u c_length=5u
X163 a_3540_180844# VSS cap_mim_2f0_m4m5_noshield c_width=5u c_length=5u
X164 a_3540_180844# VSS cap_mim_2f0_m4m5_noshield c_width=5u c_length=5u
X165 a_3540_180844# VSS cap_mim_2f0_m4m5_noshield c_width=5u c_length=5u
X166 a_3540_180844# VSS cap_mim_2f0_m4m5_noshield c_width=5u c_length=5u
X167 a_3540_180844# VSS cap_mim_2f0_m4m5_noshield c_width=5u c_length=5u
X168 a_3540_181966.t7 VSS cap_mim_2f0_m4m5_noshield c_width=5u c_length=5u
X169 a_3540_180844# VSS cap_mim_2f0_m4m5_noshield c_width=5u c_length=5u
X170 a_3540_180844# VSS cap_mim_2f0_m4m5_noshield c_width=5u c_length=5u
X171 a_3540_181966.t7 VSS cap_mim_2f0_m4m5_noshield c_width=5u c_length=5u
X172 a_3540_180844# VSS cap_mim_2f0_m4m5_noshield c_width=5u c_length=5u
X173 LO a_17667_11569# cap_mim_2f0_m4m5_noshield c_width=5u c_length=5u
X174 a_8265_82520.t1 a_8147_83109# a_8120_82520# VSS nfet_03v3 ad=0.89p pd=4.89u as=0.89p ps=4.89u w=2u l=0.28u
X175 VDD PB.t4 a_87640_80239# VDD pfet_03v3 ad=2.12p pd=8.53u as=2.12p ps=8.53u w=8u l=2u
X176 a_3540_180844# VSS cap_mim_2f0_m4m5_noshield c_width=5u c_length=5u
X177 a_88109_80239# VSS cap_mim_2f0_m4m5_noshield c_width=5u c_length=5u
X178 a_3540_180844# VSS cap_mim_2f0_m4m5_noshield c_width=5u c_length=5u
X179 a_3540_180844# VSS cap_mim_2f0_m4m5_noshield c_width=5u c_length=5u
X180 a_3540_180844# VSS cap_mim_2f0_m4m5_noshield c_width=5u c_length=5u
X181 a_3540_180844# VSS cap_mim_2f0_m4m5_noshield c_width=5u c_length=5u
X182 a_3540_180844# VSS cap_mim_2f0_m4m5_noshield c_width=5u c_length=5u
X183 a_3540_180844# VSS cap_mim_2f0_m4m5_noshield c_width=5u c_length=5u
X184 a_18345_105682# a_12185_105682# VSS VSS nfet_03v3 ad=0.445p pd=2.89u as=0.445p ps=2.89u w=1u l=0.28u
X185 a_3540_180844# VSS cap_mim_2f0_m4m5_noshield c_width=5u c_length=5u
X186 a_3540_180844# VSS cap_mim_2f0_m4m5_noshield c_width=5u c_length=5u
X187 a_3540_180844# VSS cap_mim_2f0_m4m5_noshield c_width=5u c_length=5u
X188 a_3540_180844# VSS cap_mim_2f0_m4m5_noshield c_width=5u c_length=5u
X189 a_3540_180844# VSS cap_mim_2f0_m4m5_noshield c_width=5u c_length=5u
X190 a_3540_180844# VSS cap_mim_2f0_m4m5_noshield c_width=5u c_length=5u
X191 a_3540_180844# VSS cap_mim_2f0_m4m5_noshield c_width=5u c_length=5u
X192 a_3540_180844# VSS cap_mim_2f0_m4m5_noshield c_width=5u c_length=5u
X193 a_8147_62389# a_17667_83249# VDD VDD pfet_03v3 ad=0.89p pd=4.89u as=0.89p ps=4.89u w=2u l=0.28u
X194 a_3540_180844# VSS cap_mim_2f0_m4m5_noshield c_width=5u c_length=5u
X195 a_3540_180844# VSS cap_mim_2f0_m4m5_noshield c_width=5u c_length=5u
X196 a_3540_181966.t6 VSS cap_mim_2f0_m4m5_noshield c_width=5u c_length=5u
X197 a_3540_180844# VSS cap_mim_2f0_m4m5_noshield c_width=5u c_length=5u
X198 a_3540_180844# VSS cap_mim_2f0_m4m5_noshield c_width=5u c_length=5u
X199 a_3540_180844# VSS cap_mim_2f0_m4m5_noshield c_width=5u c_length=5u
X200 a_3540_180844# VSS cap_mim_2f0_m4m5_noshield c_width=5u c_length=5u
X201 a_3540_180844# VSS cap_mim_2f0_m4m5_noshield c_width=5u c_length=5u
X202 a_3540_180844# VSS cap_mim_2f0_m4m5_noshield c_width=5u c_length=5u
X203 a_3540_180844# VSS cap_mim_2f0_m4m5_noshield c_width=5u c_length=5u
X204 a_3540_181966.t7 VSS cap_mim_2f0_m4m5_noshield c_width=5u c_length=5u
X205 a_3540_180844# VSS cap_mim_2f0_m4m5_noshield c_width=5u c_length=5u
X206 a_3540_180844# VSS cap_mim_2f0_m4m5_noshield c_width=5u c_length=5u
X207 a_3540_180844# VSS cap_mim_2f0_m4m5_noshield c_width=5u c_length=5u
X208 a_3540_180844# VSS cap_mim_2f0_m4m5_noshield c_width=5u c_length=5u
X209 a_3540_180844# VSS cap_mim_2f0_m4m5_noshield c_width=5u c_length=5u
X210 a_3540_180844# VSS cap_mim_2f0_m4m5_noshield c_width=5u c_length=5u
X211 a_3540_180844# VSS cap_mim_2f0_m4m5_noshield c_width=5u c_length=5u
X212 a_3540_180844# VSS cap_mim_2f0_m4m5_noshield c_width=5u c_length=5u
X213 a_3540_180844# VSS cap_mim_2f0_m4m5_noshield c_width=5u c_length=5u
X214 a_3540_180844# VSS cap_mim_2f0_m4m5_noshield c_width=5u c_length=5u
X215 a_3540_180844# VSS cap_mim_2f0_m4m5_noshield c_width=5u c_length=5u
X216 a_3540_180844# VSS cap_mim_2f0_m4m5_noshield c_width=5u c_length=5u
X217 a_30665_105682.t1 a_8265_82520.t7 VDD VDD pfet_03v3 ad=0.89p pd=4.89u as=0.89p ps=4.89u w=2u l=0.28u
X218 a_3540_180844# VSS cap_mim_2f0_m4m5_noshield c_width=5u c_length=5u
X219 a_3540_180844# VSS cap_mim_2f0_m4m5_noshield c_width=5u c_length=5u
X220 a_3540_180844# VSS cap_mim_2f0_m4m5_noshield c_width=5u c_length=5u
X221 a_3540_180844# VSS cap_mim_2f0_m4m5_noshield c_width=5u c_length=5u
X222 a_89421_74820# PB.t25 VDD VDD pfet_03v3 ad=2.12p pd=8.53u as=2.12p ps=8.53u w=8u l=2u
X223 a_3540_180844# VSS cap_mim_2f0_m4m5_noshield c_width=5u c_length=5u
X224 a_3540_180844# VSS cap_mim_2f0_m4m5_noshield c_width=5u c_length=5u
X225 a_3540_180844# VSS cap_mim_2f0_m4m5_noshield c_width=5u c_length=5u
X226 a_3540_180844# VSS cap_mim_2f0_m4m5_noshield c_width=5u c_length=5u
X227 a_3540_181966.t7 VSS cap_mim_2f0_m4m5_noshield c_width=5u c_length=5u
X228 a_88109_80239# VSS cap_mim_2f0_m4m5_noshield c_width=5u c_length=5u
X229 a_3540_180844# VSS cap_mim_2f0_m4m5_noshield c_width=5u c_length=5u
X230 a_3540_180844# VSS cap_mim_2f0_m4m5_noshield c_width=5u c_length=5u
X231 a_3540_180844# VSS cap_mim_2f0_m4m5_noshield c_width=5u c_length=5u
X232 a_3540_180844# VSS cap_mim_2f0_m4m5_noshield c_width=5u c_length=5u
X233 a_3540_180844# VSS cap_mim_2f0_m4m5_noshield c_width=5u c_length=5u
X234 a_3540_181966.t7 VSS cap_mim_2f0_m4m5_noshield c_width=5u c_length=5u
X235 a_3540_180844# VSS cap_mim_2f0_m4m5_noshield c_width=5u c_length=5u
X236 a_3540_180844# VSS cap_mim_2f0_m4m5_noshield c_width=5u c_length=5u
X237 a_3540_180844# VSS cap_mim_2f0_m4m5_noshield c_width=5u c_length=5u
X238 a_3540_180844# VSS cap_mim_2f0_m4m5_noshield c_width=5u c_length=5u
X239 a_3540_180844# VSS cap_mim_2f0_m4m5_noshield c_width=5u c_length=5u
X240 a_3540_180844# VSS cap_mim_2f0_m4m5_noshield c_width=5u c_length=5u
X241 a_3540_180844# VSS cap_mim_2f0_m4m5_noshield c_width=5u c_length=5u
X242 a_3540_180844# VSS cap_mim_2f0_m4m5_noshield c_width=5u c_length=5u
X243 a_3540_180844# VSS cap_mim_2f0_m4m5_noshield c_width=5u c_length=5u
X244 a_3540_180844# VSS cap_mim_2f0_m4m5_noshield c_width=5u c_length=5u
X245 a_3540_180844# VSS cap_mim_2f0_m4m5_noshield c_width=5u c_length=5u
X246 a_3540_180844# VSS cap_mim_2f0_m4m5_noshield c_width=5u c_length=5u
X247 a_3540_180844# VSS cap_mim_2f0_m4m5_noshield c_width=5u c_length=5u
X248 a_3540_180844# VSS cap_mim_2f0_m4m5_noshield c_width=5u c_length=5u
X249 a_3540_180844# VSS cap_mim_2f0_m4m5_noshield c_width=5u c_length=5u
X250 a_3540_181966.t7 VSS cap_mim_2f0_m4m5_noshield c_width=5u c_length=5u
X251 a_3540_180844# VSS cap_mim_2f0_m4m5_noshield c_width=5u c_length=5u
X252 a_4380_18186# a_4800_16064# VSS ppolyf_u_1k r_width=1u r_length=10u
X253 a_88109_80239# VSS cap_mim_2f0_m4m5_noshield c_width=5u c_length=5u
X254 a_3540_180844# VSS cap_mim_2f0_m4m5_noshield c_width=5u c_length=5u
X255 a_3540_180844# VSS cap_mim_2f0_m4m5_noshield c_width=5u c_length=5u
X256 a_3540_180844# VSS cap_mim_2f0_m4m5_noshield c_width=5u c_length=5u
X257 a_3540_180844# VSS cap_mim_2f0_m4m5_noshield c_width=5u c_length=5u
X258 a_3540_180844# VSS cap_mim_2f0_m4m5_noshield c_width=5u c_length=5u
X259 a_17540_17346# a_17667_11569# VSS ppolyf_u_1k r_width=1u r_length=10u
X260 a_3540_181966.t7 VSS cap_mim_2f0_m4m5_noshield c_width=5u c_length=5u
X261 a_3540_180844# VSS cap_mim_2f0_m4m5_noshield c_width=5u c_length=5u
X262 a_3540_180844# VSS cap_mim_2f0_m4m5_noshield c_width=5u c_length=5u
X263 a_3540_180844# VSS cap_mim_2f0_m4m5_noshield c_width=5u c_length=5u
X264 a_3540_180844# VSS cap_mim_2f0_m4m5_noshield c_width=5u c_length=5u
X265 a_3540_180844# VSS cap_mim_2f0_m4m5_noshield c_width=5u c_length=5u
X266 a_3540_180844# VSS cap_mim_2f0_m4m5_noshield c_width=5u c_length=5u
X267 a_3540_180844# VSS cap_mim_2f0_m4m5_noshield c_width=5u c_length=5u
X268 a_3540_180844# VSS cap_mim_2f0_m4m5_noshield c_width=5u c_length=5u
X269 a_3540_16064# a_3667_12409# VSS VSS nfet_03v3 ad=0.89p pd=4.89u as=0.89p ps=4.89u w=2u l=0.28u
X270 a_3540_180844# VSS cap_mim_2f0_m4m5_noshield c_width=5u c_length=5u
X271 a_3540_181966.t6 VSS cap_mim_2f0_m4m5_noshield c_width=5u c_length=5u
X272 a_3540_180844# VSS cap_mim_2f0_m4m5_noshield c_width=5u c_length=5u
X273 a_3540_180844# VSS cap_mim_2f0_m4m5_noshield c_width=5u c_length=5u
X274 a_3540_180844# VSS cap_mim_2f0_m4m5_noshield c_width=5u c_length=5u
X275 a_92457_69640# a_88109_80239# a_88109_80239# VSS nfet_03v3 ad=1.78p pd=8.89u as=1.06p ps=4.53u w=4u l=1u
X276 a_3540_180844# VSS cap_mim_2f0_m4m5_noshield c_width=5u c_length=5u
X277 a_3540_180844# VSS cap_mim_2f0_m4m5_noshield c_width=5u c_length=5u
X278 a_43987_20669# a_44105_7822# a_45640_7480# VSS nfet_03v3 ad=0.6675p pd=3.89u as=0.6675p ps=3.89u w=1.5u l=0.28u
X279 a_3540_180844# VSS cap_mim_2f0_m4m5_noshield c_width=5u c_length=5u
X280 a_3540_180844# VSS cap_mim_2f0_m4m5_noshield c_width=5u c_length=5u
X281 a_3540_180844# VSS cap_mim_2f0_m4m5_noshield c_width=5u c_length=5u
X282 a_3540_180844# VSS cap_mim_2f0_m4m5_noshield c_width=5u c_length=5u
X283 a_3540_180844# VSS cap_mim_2f0_m4m5_noshield c_width=5u c_length=5u
X284 a_3540_180844# VSS cap_mim_2f0_m4m5_noshield c_width=5u c_length=5u
X285 a_3540_180844# VSS cap_mim_2f0_m4m5_noshield c_width=5u c_length=5u
X286 a_3540_180844# VSS cap_mim_2f0_m4m5_noshield c_width=5u c_length=5u
X287 a_3540_180844# VSS cap_mim_2f0_m4m5_noshield c_width=5u c_length=5u
X288 a_3540_180844# VSS cap_mim_2f0_m4m5_noshield c_width=5u c_length=5u
X289 a_3540_181966.t7 VSS cap_mim_2f0_m4m5_noshield c_width=5u c_length=5u
X290 a_3540_180844# VSS cap_mim_2f0_m4m5_noshield c_width=5u c_length=5u
X291 a_3540_180844# VSS cap_mim_2f0_m4m5_noshield c_width=5u c_length=5u
X292 a_3540_180844# VSS cap_mim_2f0_m4m5_noshield c_width=5u c_length=5u
X293 a_3540_180844# VSS cap_mim_2f0_m4m5_noshield c_width=5u c_length=5u
X294 a_3540_180844# VSS cap_mim_2f0_m4m5_noshield c_width=5u c_length=5u
X295 REFIN a_3667_12409# cap_mim_2f0_m4m5_noshield c_width=5u c_length=5u
X296 a_3540_181966.t7 VSS cap_mim_2f0_m4m5_noshield c_width=5u c_length=5u
X297 a_3540_180844# VSS cap_mim_2f0_m4m5_noshield c_width=5u c_length=5u
X298 a_3540_180844# VSS cap_mim_2f0_m4m5_noshield c_width=5u c_length=5u
X299 a_3540_181966.t7 VSS cap_mim_2f0_m4m5_noshield c_width=5u c_length=5u
X300 a_3540_180844# VSS cap_mim_2f0_m4m5_noshield c_width=5u c_length=5u
X301 a_3540_180844# VSS cap_mim_2f0_m4m5_noshield c_width=5u c_length=5u
X302 a_8265_82520.t2 a_8147_83109# VDD VDD pfet_03v3 ad=0.89p pd=4.89u as=0.89p ps=4.89u w=2u l=0.28u
X303 a_3540_180844# VSS cap_mim_2f0_m4m5_noshield c_width=5u c_length=5u
X304 a_3540_180844# VSS cap_mim_2f0_m4m5_noshield c_width=5u c_length=5u
X305 a_3540_180844# VSS cap_mim_2f0_m4m5_noshield c_width=5u c_length=5u
X306 a_3540_180844# VSS cap_mim_2f0_m4m5_noshield c_width=5u c_length=5u
X307 a_3540_180844# VSS cap_mim_2f0_m4m5_noshield c_width=5u c_length=5u
X308 a_3540_180844# VSS cap_mim_2f0_m4m5_noshield c_width=5u c_length=5u
X309 a_3540_180844# VSS cap_mim_2f0_m4m5_noshield c_width=5u c_length=5u
X310 a_3540_180844# VSS cap_mim_2f0_m4m5_noshield c_width=5u c_length=5u
X311 a_3540_180844# VSS cap_mim_2f0_m4m5_noshield c_width=5u c_length=5u
X312 a_3540_180844# VSS cap_mim_2f0_m4m5_noshield c_width=5u c_length=5u
X313 a_3540_180844# VSS cap_mim_2f0_m4m5_noshield c_width=5u c_length=5u
X314 a_3540_180844# VSS cap_mim_2f0_m4m5_noshield c_width=5u c_length=5u
X315 a_3540_180844# VSS cap_mim_2f0_m4m5_noshield c_width=5u c_length=5u
X316 a_3540_180844# VSS cap_mim_2f0_m4m5_noshield c_width=5u c_length=5u
X317 a_3540_180844# VSS cap_mim_2f0_m4m5_noshield c_width=5u c_length=5u
X318 a_3540_180844# VSS cap_mim_2f0_m4m5_noshield c_width=5u c_length=5u
X319 a_3540_180844# VSS cap_mim_2f0_m4m5_noshield c_width=5u c_length=5u
X320 a_3540_180844# VSS cap_mim_2f0_m4m5_noshield c_width=5u c_length=5u
X321 a_3540_180844# VSS cap_mim_2f0_m4m5_noshield c_width=5u c_length=5u
X322 a_88409_69640# NB.t17 VSS VSS nfet_03v3 ad=2.12p pd=8.53u as=3.56p ps=16.89u w=8u l=2u
X323 a_3540_180844# VSS cap_mim_2f0_m4m5_noshield c_width=5u c_length=5u
X324 a_3540_180844# VSS cap_mim_2f0_m4m5_noshield c_width=5u c_length=5u
X325 a_3540_180844# VSS cap_mim_2f0_m4m5_noshield c_width=5u c_length=5u
X326 a_3540_181966.t0 a_30665_105682.t3 a_89880_80239# VDD pfet_03v3 ad=1.06p pd=4.53u as=1.78p ps=8.89u w=4u l=0.28u
X327 a_3540_180844# VSS cap_mim_2f0_m4m5_noshield c_width=5u c_length=5u
X328 a_3540_180844# VSS cap_mim_2f0_m4m5_noshield c_width=5u c_length=5u
X329 a_3540_180844# VSS cap_mim_2f0_m4m5_noshield c_width=5u c_length=5u
X330 a_3540_180844# VSS cap_mim_2f0_m4m5_noshield c_width=5u c_length=5u
X331 a_3540_180844# VSS cap_mim_2f0_m4m5_noshield c_width=5u c_length=5u
X332 a_15960_82520# a_17667_83249# a_16105_86720# VSS nfet_03v3 ad=1.335p pd=6.89u as=1.335p ps=6.89u w=3u l=0.28u
X333 a_3540_180844# VSS cap_mim_2f0_m4m5_noshield c_width=5u c_length=5u
X334 a_3540_181966.t7 VSS cap_mim_2f0_m4m5_noshield c_width=5u c_length=5u
X335 a_3540_180844# VSS cap_mim_2f0_m4m5_noshield c_width=5u c_length=5u
X336 a_3540_180844# VSS cap_mim_2f0_m4m5_noshield c_width=5u c_length=5u
X337 a_3540_180844# VSS cap_mim_2f0_m4m5_noshield c_width=5u c_length=5u
X338 a_3540_180844# VSS cap_mim_2f0_m4m5_noshield c_width=5u c_length=5u
X339 a_89421_74820# PB.t11 VDD VDD pfet_03v3 ad=2.12p pd=8.53u as=2.12p ps=8.53u w=8u l=2u
X340 a_3540_180844# VSS cap_mim_2f0_m4m5_noshield c_width=5u c_length=5u
X341 a_3540_180844# VSS cap_mim_2f0_m4m5_noshield c_width=5u c_length=5u
X342 a_3540_180844# VSS cap_mim_2f0_m4m5_noshield c_width=5u c_length=5u
X343 a_3540_180844# VSS cap_mim_2f0_m4m5_noshield c_width=5u c_length=5u
X344 a_3540_180844# VSS cap_mim_2f0_m4m5_noshield c_width=5u c_length=5u
X345 VDD PB.t16 a_89421_74820# VDD pfet_03v3 ad=2.12p pd=8.53u as=2.12p ps=8.53u w=8u l=2u
X346 a_3540_180844# VSS cap_mim_2f0_m4m5_noshield c_width=5u c_length=5u
X347 a_3540_180844# VSS cap_mim_2f0_m4m5_noshield c_width=5u c_length=5u
X348 a_3540_180844# VSS cap_mim_2f0_m4m5_noshield c_width=5u c_length=5u
X349 a_3540_180844# VSS cap_mim_2f0_m4m5_noshield c_width=5u c_length=5u
X350 a_3540_180844# VSS cap_mim_2f0_m4m5_noshield c_width=5u c_length=5u
X351 a_3540_180844# VSS cap_mim_2f0_m4m5_noshield c_width=5u c_length=5u
X352 a_3540_180844# VSS cap_mim_2f0_m4m5_noshield c_width=5u c_length=5u
X353 a_3540_180844# VSS cap_mim_2f0_m4m5_noshield c_width=5u c_length=5u
X354 a_3540_180844# VSS cap_mim_2f0_m4m5_noshield c_width=5u c_length=5u
X355 a_5220_18186# a_4800_16064# VSS ppolyf_u_1k r_width=1u r_length=10u
X356 a_3540_180844# VSS cap_mim_2f0_m4m5_noshield c_width=5u c_length=5u
X357 a_3540_180844# VSS cap_mim_2f0_m4m5_noshield c_width=5u c_length=5u
X358 VDD PB.t28 a_89421_74820# VDD pfet_03v3 ad=2.12p pd=8.53u as=2.12p ps=8.53u w=8u l=2u
X359 a_3540_180844# VSS cap_mim_2f0_m4m5_noshield c_width=5u c_length=5u
X360 a_3540_180844# VSS cap_mim_2f0_m4m5_noshield c_width=5u c_length=5u
X361 a_3540_180844# VSS cap_mim_2f0_m4m5_noshield c_width=5u c_length=5u
X362 a_3540_180844# VSS cap_mim_2f0_m4m5_noshield c_width=5u c_length=5u
X363 VCTRL.t1 VSS cap_mim_2f0_m4m5_noshield c_width=5u c_length=5u
X364 a_3540_180844# VSS cap_mim_2f0_m4m5_noshield c_width=5u c_length=5u
X365 a_3540_180844# VSS cap_mim_2f0_m4m5_noshield c_width=5u c_length=5u
X366 a_3540_180844# VSS cap_mim_2f0_m4m5_noshield c_width=5u c_length=5u
X367 a_3540_181966.t7 VSS cap_mim_2f0_m4m5_noshield c_width=5u c_length=5u
X368 a_3540_180844# VSS cap_mim_2f0_m4m5_noshield c_width=5u c_length=5u
X369 VSS a_73225_30440# FS VSS nfet_03v3 ad=1.335p pd=6.89u as=0.795p ps=3.53u w=3u l=0.28u
X370 a_3540_180844# VSS cap_mim_2f0_m4m5_noshield c_width=5u c_length=5u
X371 a_3540_180844# VSS cap_mim_2f0_m4m5_noshield c_width=5u c_length=5u
X372 a_3540_180844# VSS cap_mim_2f0_m4m5_noshield c_width=5u c_length=5u
X373 a_3540_180844# VSS cap_mim_2f0_m4m5_noshield c_width=5u c_length=5u
X374 a_3540_180844# VSS cap_mim_2f0_m4m5_noshield c_width=5u c_length=5u
X375 a_3540_180844# VSS cap_mim_2f0_m4m5_noshield c_width=5u c_length=5u
X376 a_3540_180844# VSS cap_mim_2f0_m4m5_noshield c_width=5u c_length=5u
X377 a_3540_180844# VSS cap_mim_2f0_m4m5_noshield c_width=5u c_length=5u
X378 a_3540_180844# VSS cap_mim_2f0_m4m5_noshield c_width=5u c_length=5u
X379 a_3540_180844# VSS cap_mim_2f0_m4m5_noshield c_width=5u c_length=5u
X380 a_3540_180844# VSS cap_mim_2f0_m4m5_noshield c_width=5u c_length=5u
X381 a_3540_180844# VSS cap_mim_2f0_m4m5_noshield c_width=5u c_length=5u
X382 a_3540_180844# VSS cap_mim_2f0_m4m5_noshield c_width=5u c_length=5u
X383 a_29987_33269# a_41305_45000# VSS VSS nfet_03v3 ad=0.445p pd=2.89u as=0.445p ps=2.89u w=1u l=0.28u
X384 a_3540_180844# VSS cap_mim_2f0_m4m5_noshield c_width=5u c_length=5u
X385 a_88109_80239# VSS cap_mim_2f0_m4m5_noshield c_width=5u c_length=5u
X386 a_3540_180844# VSS cap_mim_2f0_m4m5_noshield c_width=5u c_length=5u
X387 a_3540_180844# VSS cap_mim_2f0_m4m5_noshield c_width=5u c_length=5u
X388 a_3540_180844# VSS cap_mim_2f0_m4m5_noshield c_width=5u c_length=5u
X389 a_3540_180844# VSS cap_mim_2f0_m4m5_noshield c_width=5u c_length=5u
X390 a_61320_36740# a_61347_45729# VSS VSS nfet_03v3 ad=0.6675p pd=3.89u as=0.6675p ps=3.89u w=1.5u l=0.28u
X391 a_3540_180844# VSS cap_mim_2f0_m4m5_noshield c_width=5u c_length=5u
X392 a_3540_181966.t7 VSS cap_mim_2f0_m4m5_noshield c_width=5u c_length=5u
X393 a_3540_180844# VSS cap_mim_2f0_m4m5_noshield c_width=5u c_length=5u
X394 a_43960_61800# a_43987_83109# VSS VSS nfet_03v3 ad=0.89p pd=4.89u as=0.89p ps=4.89u w=2u l=0.28u
X395 a_19465_10700# a_17540_15224# VDD VDD pfet_03v3 ad=3.56p pd=16.89u as=3.56p ps=16.89u w=8u l=0.28u
X396 a_3540_180844# VSS cap_mim_2f0_m4m5_noshield c_width=5u c_length=5u
X397 a_3540_180844# VSS cap_mim_2f0_m4m5_noshield c_width=5u c_length=5u
X398 a_3540_180844# VSS cap_mim_2f0_m4m5_noshield c_width=5u c_length=5u
X399 a_3540_180844# VSS cap_mim_2f0_m4m5_noshield c_width=5u c_length=5u
X400 a_3540_180844# VSS cap_mim_2f0_m4m5_noshield c_width=5u c_length=5u
X401 a_3540_180844# VSS cap_mim_2f0_m4m5_noshield c_width=5u c_length=5u
X402 a_3540_181966.t7 VSS cap_mim_2f0_m4m5_noshield c_width=5u c_length=5u
X403 a_3540_180844# VSS cap_mim_2f0_m4m5_noshield c_width=5u c_length=5u
X404 a_3540_180844# VSS cap_mim_2f0_m4m5_noshield c_width=5u c_length=5u
X405 a_7740_18186# a_7320_16064# VSS ppolyf_u_1k r_width=1u r_length=10u
X406 a_3540_180844# VSS cap_mim_2f0_m4m5_noshield c_width=5u c_length=5u
X407 a_3540_180844# VSS cap_mim_2f0_m4m5_noshield c_width=5u c_length=5u
X408 a_3540_180844# VSS cap_mim_2f0_m4m5_noshield c_width=5u c_length=5u
X409 a_3540_180844# VSS cap_mim_2f0_m4m5_noshield c_width=5u c_length=5u
X410 a_3540_180844# VSS cap_mim_2f0_m4m5_noshield c_width=5u c_length=5u
X411 a_3540_180844# VSS cap_mim_2f0_m4m5_noshield c_width=5u c_length=5u
X412 a_3540_180844# VSS cap_mim_2f0_m4m5_noshield c_width=5u c_length=5u
X413 a_3540_180844# VSS cap_mim_2f0_m4m5_noshield c_width=5u c_length=5u
X414 a_3540_180844# VSS cap_mim_2f0_m4m5_noshield c_width=5u c_length=5u
X415 a_3540_180844# VSS cap_mim_2f0_m4m5_noshield c_width=5u c_length=5u
X416 a_3540_180844# VSS cap_mim_2f0_m4m5_noshield c_width=5u c_length=5u
X417 a_3540_180844# VSS cap_mim_2f0_m4m5_noshield c_width=5u c_length=5u
X418 a_3540_180844# VSS cap_mim_2f0_m4m5_noshield c_width=5u c_length=5u
X419 a_3540_181966.t7 VSS cap_mim_2f0_m4m5_noshield c_width=5u c_length=5u
X420 a_3540_180844# VSS cap_mim_2f0_m4m5_noshield c_width=5u c_length=5u
X421 a_3540_180844# VSS cap_mim_2f0_m4m5_noshield c_width=5u c_length=5u
X422 a_3540_180844# VSS cap_mim_2f0_m4m5_noshield c_width=5u c_length=5u
X423 a_3540_180844# VSS cap_mim_2f0_m4m5_noshield c_width=5u c_length=5u
X424 a_3540_180844# VSS cap_mim_2f0_m4m5_noshield c_width=5u c_length=5u
X425 a_3540_180844# VSS cap_mim_2f0_m4m5_noshield c_width=5u c_length=5u
X426 a_3540_180844# VSS cap_mim_2f0_m4m5_noshield c_width=5u c_length=5u
X427 a_3540_180844# VSS cap_mim_2f0_m4m5_noshield c_width=5u c_length=5u
X428 a_3540_180844# VSS cap_mim_2f0_m4m5_noshield c_width=5u c_length=5u
X429 a_41160_32540# a_29987_37189.t2 VSS VSS nfet_03v3 ad=0.6675p pd=3.89u as=0.6675p ps=3.89u w=1.5u l=0.28u
X430 a_3540_180844# VSS cap_mim_2f0_m4m5_noshield c_width=5u c_length=5u
X431 a_3540_180844# VSS cap_mim_2f0_m4m5_noshield c_width=5u c_length=5u
X432 a_3540_180844# VSS cap_mim_2f0_m4m5_noshield c_width=5u c_length=5u
X433 a_29987_45729# a_30105_32882# a_31640_32540# VSS nfet_03v3 ad=0.6675p pd=3.89u as=0.6675p ps=3.89u w=1.5u l=0.28u
X434 a_3540_180844# VSS cap_mim_2f0_m4m5_noshield c_width=5u c_length=5u
X435 a_3540_180844# VSS cap_mim_2f0_m4m5_noshield c_width=5u c_length=5u
X436 a_3540_180844# VSS cap_mim_2f0_m4m5_noshield c_width=5u c_length=5u
X437 a_3540_180844# VSS cap_mim_2f0_m4m5_noshield c_width=5u c_length=5u
X438 a_3540_180844# VSS cap_mim_2f0_m4m5_noshield c_width=5u c_length=5u
X439 a_3540_180844# VSS cap_mim_2f0_m4m5_noshield c_width=5u c_length=5u
X440 a_3540_180844# VSS cap_mim_2f0_m4m5_noshield c_width=5u c_length=5u
X441 a_3540_180844# VSS cap_mim_2f0_m4m5_noshield c_width=5u c_length=5u
X442 a_3540_180844# VSS cap_mim_2f0_m4m5_noshield c_width=5u c_length=5u
X443 a_3540_180844# VSS cap_mim_2f0_m4m5_noshield c_width=5u c_length=5u
X444 a_5907_106069.t0 a_8265_82520.t3 a_77560_59700# VSS nfet_03v3 ad=0.89p pd=4.89u as=0.89p ps=4.89u w=2u l=0.28u
X445 a_3540_180844# VSS cap_mim_2f0_m4m5_noshield c_width=5u c_length=5u
X446 VCTRL.t1 VSS cap_mim_2f0_m4m5_noshield c_width=5u c_length=5u
X447 a_3540_180844# VSS cap_mim_2f0_m4m5_noshield c_width=5u c_length=5u
X448 a_12185_105682# a_6025_105682# VDD VDD pfet_03v3 ad=0.89p pd=4.89u as=0.89p ps=4.89u w=2u l=0.28u
X449 a_3540_180844# VSS cap_mim_2f0_m4m5_noshield c_width=5u c_length=5u
X450 a_88109_80239# VSS cap_mim_2f0_m4m5_noshield c_width=5u c_length=5u
X451 a_3540_180844# VSS cap_mim_2f0_m4m5_noshield c_width=5u c_length=5u
X452 a_3540_180844# VSS cap_mim_2f0_m4m5_noshield c_width=5u c_length=5u
X453 a_3540_180844# VSS cap_mim_2f0_m4m5_noshield c_width=5u c_length=5u
X454 a_3540_181966.t7 VSS cap_mim_2f0_m4m5_noshield c_width=5u c_length=5u
X455 a_3540_180844# VSS cap_mim_2f0_m4m5_noshield c_width=5u c_length=5u
X456 a_3540_180844# VSS cap_mim_2f0_m4m5_noshield c_width=5u c_length=5u
X457 a_3540_180844# VSS cap_mim_2f0_m4m5_noshield c_width=5u c_length=5u
X458 a_3540_180844# VSS cap_mim_2f0_m4m5_noshield c_width=5u c_length=5u
X459 a_3540_181966.t7 VSS cap_mim_2f0_m4m5_noshield c_width=5u c_length=5u
X460 a_3540_180844# VSS cap_mim_2f0_m4m5_noshield c_width=5u c_length=5u
X461 a_3540_180844# VSS cap_mim_2f0_m4m5_noshield c_width=5u c_length=5u
X462 a_3540_180844# VSS cap_mim_2f0_m4m5_noshield c_width=5u c_length=5u
X463 a_3540_180844# VSS cap_mim_2f0_m4m5_noshield c_width=5u c_length=5u
X464 a_9827_83109# a_17667_83249# VDD VDD pfet_03v3 ad=0.89p pd=4.89u as=0.89p ps=4.89u w=2u l=0.28u
X465 a_3540_180844# VSS cap_mim_2f0_m4m5_noshield c_width=5u c_length=5u
X466 a_3540_180844# VSS cap_mim_2f0_m4m5_noshield c_width=5u c_length=5u
X467 a_3540_180844# VSS cap_mim_2f0_m4m5_noshield c_width=5u c_length=5u
X468 a_3540_180844# VSS cap_mim_2f0_m4m5_noshield c_width=5u c_length=5u
X469 a_3540_180844# VSS cap_mim_2f0_m4m5_noshield c_width=5u c_length=5u
X470 a_3540_180844# VSS cap_mim_2f0_m4m5_noshield c_width=5u c_length=5u
X471 a_3540_180844# VSS cap_mim_2f0_m4m5_noshield c_width=5u c_length=5u
X472 a_3540_180844# VSS cap_mim_2f0_m4m5_noshield c_width=5u c_length=5u
X473 a_3540_180844# VSS cap_mim_2f0_m4m5_noshield c_width=5u c_length=5u
X474 a_3540_181966.t7 VSS cap_mim_2f0_m4m5_noshield c_width=5u c_length=5u
X475 a_3540_180844# VSS cap_mim_2f0_m4m5_noshield c_width=5u c_length=5u
X476 a_3540_180844# VSS cap_mim_2f0_m4m5_noshield c_width=5u c_length=5u
X477 a_3540_180844# VSS cap_mim_2f0_m4m5_noshield c_width=5u c_length=5u
X478 a_3540_181966.t7 VSS cap_mim_2f0_m4m5_noshield c_width=5u c_length=5u
X479 a_3540_180844# VSS cap_mim_2f0_m4m5_noshield c_width=5u c_length=5u
X480 a_3540_180844# VSS cap_mim_2f0_m4m5_noshield c_width=5u c_length=5u
X481 a_3540_180844# VSS cap_mim_2f0_m4m5_noshield c_width=5u c_length=5u
X482 a_3540_180844# VSS cap_mim_2f0_m4m5_noshield c_width=5u c_length=5u
X483 a_3540_180844# VSS cap_mim_2f0_m4m5_noshield c_width=5u c_length=5u
X484 a_3540_180844# VSS cap_mim_2f0_m4m5_noshield c_width=5u c_length=5u
X485 a_3540_180844# VSS cap_mim_2f0_m4m5_noshield c_width=5u c_length=5u
X486 a_3540_180844# VSS cap_mim_2f0_m4m5_noshield c_width=5u c_length=5u
X487 a_3540_180844# VSS cap_mim_2f0_m4m5_noshield c_width=5u c_length=5u
X488 a_3540_180844# VSS cap_mim_2f0_m4m5_noshield c_width=5u c_length=5u
X489 a_3540_180844# VSS cap_mim_2f0_m4m5_noshield c_width=5u c_length=5u
X490 a_3540_180844# VSS cap_mim_2f0_m4m5_noshield c_width=5u c_length=5u
X491 a_3540_180844# VSS cap_mim_2f0_m4m5_noshield c_width=5u c_length=5u
X492 a_3540_180844# VSS cap_mim_2f0_m4m5_noshield c_width=5u c_length=5u
X493 a_3540_180844# VSS cap_mim_2f0_m4m5_noshield c_width=5u c_length=5u
X494 VCTRL.t1 VSS cap_mim_2f0_m4m5_noshield c_width=5u c_length=5u
X495 a_3540_180844# VSS cap_mim_2f0_m4m5_noshield c_width=5u c_length=5u
X496 a_3540_180844# VSS cap_mim_2f0_m4m5_noshield c_width=5u c_length=5u
X497 a_3540_180844# VSS cap_mim_2f0_m4m5_noshield c_width=5u c_length=5u
X498 a_3540_181966.t7 VSS cap_mim_2f0_m4m5_noshield c_width=5u c_length=5u
X499 a_3540_181966.t7 VSS cap_mim_2f0_m4m5_noshield c_width=5u c_length=5u
X500 a_3540_181966.t7 VSS cap_mim_2f0_m4m5_noshield c_width=5u c_length=5u
X501 a_51945_66000# a_15987_66729.t5 VSS VSS nfet_03v3 ad=1.335p pd=6.89u as=1.335p ps=6.89u w=3u l=0.28u
X502 a_3540_180844# VSS cap_mim_2f0_m4m5_noshield c_width=5u c_length=5u
X503 a_3540_180844# VSS cap_mim_2f0_m4m5_noshield c_width=5u c_length=5u
X504 a_3540_180844# VSS cap_mim_2f0_m4m5_noshield c_width=5u c_length=5u
X505 a_3540_180844# VSS cap_mim_2f0_m4m5_noshield c_width=5u c_length=5u
X506 a_3540_180844# VSS cap_mim_2f0_m4m5_noshield c_width=5u c_length=5u
X507 a_3540_180844# VSS cap_mim_2f0_m4m5_noshield c_width=5u c_length=5u
X508 a_3540_181966.t7 VSS cap_mim_2f0_m4m5_noshield c_width=5u c_length=5u
X509 a_3540_180844# VSS cap_mim_2f0_m4m5_noshield c_width=5u c_length=5u
X510 a_3540_180844# VSS cap_mim_2f0_m4m5_noshield c_width=5u c_length=5u
X511 a_3540_180844# VSS cap_mim_2f0_m4m5_noshield c_width=5u c_length=5u
X512 a_3540_180844# VSS cap_mim_2f0_m4m5_noshield c_width=5u c_length=5u
X513 a_3540_180844# VSS cap_mim_2f0_m4m5_noshield c_width=5u c_length=5u
X514 VDD PB.t6 a_89421_74820# VDD pfet_03v3 ad=2.12p pd=8.53u as=2.12p ps=8.53u w=8u l=2u
X515 a_3540_180844# VSS cap_mim_2f0_m4m5_noshield c_width=5u c_length=5u
X516 a_3540_180844# VSS cap_mim_2f0_m4m5_noshield c_width=5u c_length=5u
X517 a_7740_18186# a_8160_16064# VSS ppolyf_u_1k r_width=1u r_length=10u
X518 a_3540_180844# VSS cap_mim_2f0_m4m5_noshield c_width=5u c_length=5u
X519 a_3540_180844# VSS cap_mim_2f0_m4m5_noshield c_width=5u c_length=5u
X520 a_3540_180844# VSS cap_mim_2f0_m4m5_noshield c_width=5u c_length=5u
X521 a_3540_180844# VSS cap_mim_2f0_m4m5_noshield c_width=5u c_length=5u
X522 a_3540_180844# VSS cap_mim_2f0_m4m5_noshield c_width=5u c_length=5u
X523 a_3540_180844# VSS cap_mim_2f0_m4m5_noshield c_width=5u c_length=5u
X524 REFIN a_3667_12409# cap_mim_2f0_m4m5_noshield c_width=5u c_length=5u
X525 a_3540_180844# VSS cap_mim_2f0_m4m5_noshield c_width=5u c_length=5u
X526 a_3540_180844# VSS cap_mim_2f0_m4m5_noshield c_width=5u c_length=5u
X527 a_3540_180844# VSS cap_mim_2f0_m4m5_noshield c_width=5u c_length=5u
X528 a_3540_180844# VSS cap_mim_2f0_m4m5_noshield c_width=5u c_length=5u
X529 a_3540_180844# VSS cap_mim_2f0_m4m5_noshield c_width=5u c_length=5u
X530 a_3540_180844# VSS cap_mim_2f0_m4m5_noshield c_width=5u c_length=5u
X531 a_3540_180844# VSS cap_mim_2f0_m4m5_noshield c_width=5u c_length=5u
X532 a_44105_61800# a_43987_83109# VDD VDD pfet_03v3 ad=0.89p pd=4.89u as=0.89p ps=4.89u w=2u l=0.28u
X533 a_3540_181966.t7 VSS cap_mim_2f0_m4m5_noshield c_width=5u c_length=5u
X534 a_3540_180844# VSS cap_mim_2f0_m4m5_noshield c_width=5u c_length=5u
X535 a_3540_180844# VSS cap_mim_2f0_m4m5_noshield c_width=5u c_length=5u
X536 a_3540_180844# VSS cap_mim_2f0_m4m5_noshield c_width=5u c_length=5u
X537 a_3540_180844# VSS cap_mim_2f0_m4m5_noshield c_width=5u c_length=5u
X538 a_3540_180844# VSS cap_mim_2f0_m4m5_noshield c_width=5u c_length=5u
X539 a_3540_180844# VSS cap_mim_2f0_m4m5_noshield c_width=5u c_length=5u
X540 a_3540_180844# VSS cap_mim_2f0_m4m5_noshield c_width=5u c_length=5u
X541 a_3540_180844# VSS cap_mim_2f0_m4m5_noshield c_width=5u c_length=5u
X542 a_87640_80239# a_88033_80029# a_88109_80239# VDD pfet_03v3 ad=1.78p pd=8.89u as=1.06p ps=4.53u w=4u l=0.28u
X543 a_3540_180844# VSS cap_mim_2f0_m4m5_noshield c_width=5u c_length=5u
X544 a_3540_180844# VSS cap_mim_2f0_m4m5_noshield c_width=5u c_length=5u
X545 a_3540_180844# VSS cap_mim_2f0_m4m5_noshield c_width=5u c_length=5u
X546 a_3540_180844# VSS cap_mim_2f0_m4m5_noshield c_width=5u c_length=5u
X547 a_3540_180844# VSS cap_mim_2f0_m4m5_noshield c_width=5u c_length=5u
X548 a_3540_180844# VSS cap_mim_2f0_m4m5_noshield c_width=5u c_length=5u
X549 a_3540_181966.t7 VSS cap_mim_2f0_m4m5_noshield c_width=5u c_length=5u
X550 a_3540_180844# VSS cap_mim_2f0_m4m5_noshield c_width=5u c_length=5u
X551 a_3540_180844# VSS cap_mim_2f0_m4m5_noshield c_width=5u c_length=5u
X552 a_3540_180844# VSS cap_mim_2f0_m4m5_noshield c_width=5u c_length=5u
X553 a_3540_181966.t7 VSS cap_mim_2f0_m4m5_noshield c_width=5u c_length=5u
X554 a_3540_180844# VSS cap_mim_2f0_m4m5_noshield c_width=5u c_length=5u
X555 a_3540_180844# VSS cap_mim_2f0_m4m5_noshield c_width=5u c_length=5u
X556 a_3540_180844# VSS cap_mim_2f0_m4m5_noshield c_width=5u c_length=5u
X557 a_3540_180844# VSS cap_mim_2f0_m4m5_noshield c_width=5u c_length=5u
X558 a_58105_7822# a_57987_8209# VSS VSS nfet_03v3 ad=0.445p pd=2.89u as=0.445p ps=2.89u w=1u l=0.28u
X559 a_3540_180844# VSS cap_mim_2f0_m4m5_noshield c_width=5u c_length=5u
X560 a_3540_180844# VSS cap_mim_2f0_m4m5_noshield c_width=5u c_length=5u
X561 a_105420_69640# ICP2.t1 a_89421_69640# VSS nfet_03v3 ad=0.53p pd=2.53u as=0.89p ps=4.89u w=2u l=0.28u
X562 a_3540_180844# VSS cap_mim_2f0_m4m5_noshield c_width=5u c_length=5u
X563 a_3540_180844# VSS cap_mim_2f0_m4m5_noshield c_width=5u c_length=5u
X564 a_3540_180844# VSS cap_mim_2f0_m4m5_noshield c_width=5u c_length=5u
X565 a_41305_45000# a_39625_36740# VDD VDD pfet_03v3 ad=0.89p pd=4.89u as=0.89p ps=4.89u w=2u l=0.28u
X566 a_30105_36740# a_29987_45729# VDD VDD pfet_03v3 ad=1.335p pd=6.89u as=1.335p ps=6.89u w=3u l=0.28u
X567 a_39507_45729# a_29987_37189.t6 VDD VDD pfet_03v3 ad=0.89p pd=4.89u as=0.89p ps=4.89u w=2u l=0.28u
X568 a_3540_180844# VSS cap_mim_2f0_m4m5_noshield c_width=5u c_length=5u
X569 a_30105_32882# a_29987_37189.t9 a_30105_40940# VDD pfet_03v3 ad=0.89p pd=4.89u as=0.89p ps=4.89u w=2u l=0.28u
X570 a_3540_180844# VSS cap_mim_2f0_m4m5_noshield c_width=5u c_length=5u
X571 a_3540_180844# VSS cap_mim_2f0_m4m5_noshield c_width=5u c_length=5u
X572 a_3540_180844# VSS cap_mim_2f0_m4m5_noshield c_width=5u c_length=5u
X573 VCTRL.t1 VSS cap_mim_2f0_m4m5_noshield c_width=5u c_length=5u
X574 a_3540_180844# VSS cap_mim_2f0_m4m5_noshield c_width=5u c_length=5u
X575 a_3540_180844# VSS cap_mim_2f0_m4m5_noshield c_width=5u c_length=5u
X576 VSS NB.t10 a_89421_69640# VSS nfet_03v3 ad=2.12p pd=8.53u as=2.12p ps=8.53u w=8u l=2u
X577 a_3540_180844# VSS cap_mim_2f0_m4m5_noshield c_width=5u c_length=5u
X578 a_3540_180844# VSS cap_mim_2f0_m4m5_noshield c_width=5u c_length=5u
X579 a_3540_180844# VSS cap_mim_2f0_m4m5_noshield c_width=5u c_length=5u
X580 a_3540_180844# VSS cap_mim_2f0_m4m5_noshield c_width=5u c_length=5u
X581 a_3540_180844# VSS cap_mim_2f0_m4m5_noshield c_width=5u c_length=5u
X582 VDD PB.t2 a_89421_74820# VDD pfet_03v3 ad=2.12p pd=8.53u as=2.12p ps=8.53u w=8u l=2u
X583 a_3540_180844# VSS cap_mim_2f0_m4m5_noshield c_width=5u c_length=5u
X584 a_3540_180844# VSS cap_mim_2f0_m4m5_noshield c_width=5u c_length=5u
X585 a_3540_180844# VSS cap_mim_2f0_m4m5_noshield c_width=5u c_length=5u
X586 a_15987_66729.t0 a_18345_105682# VSS VSS nfet_03v3 ad=0.445p pd=2.89u as=0.445p ps=2.89u w=1u l=0.28u
X587 a_3540_180844# VSS cap_mim_2f0_m4m5_noshield c_width=5u c_length=5u
X588 a_3540_180844# VSS cap_mim_2f0_m4m5_noshield c_width=5u c_length=5u
X589 a_3540_180844# VSS cap_mim_2f0_m4m5_noshield c_width=5u c_length=5u
X590 a_3540_180844# VSS cap_mim_2f0_m4m5_noshield c_width=5u c_length=5u
X591 a_3540_180844# VSS cap_mim_2f0_m4m5_noshield c_width=5u c_length=5u
X592 a_3540_180844# VSS cap_mim_2f0_m4m5_noshield c_width=5u c_length=5u
X593 a_3540_180844# VSS cap_mim_2f0_m4m5_noshield c_width=5u c_length=5u
X594 a_3540_181966.t7 VSS cap_mim_2f0_m4m5_noshield c_width=5u c_length=5u
X595 a_3540_180844# VSS cap_mim_2f0_m4m5_noshield c_width=5u c_length=5u
X596 a_3540_180844# VSS cap_mim_2f0_m4m5_noshield c_width=5u c_length=5u
X597 a_88109_80239# VSS cap_mim_2f0_m4m5_noshield c_width=5u c_length=5u
X598 a_3540_180844# VSS cap_mim_2f0_m4m5_noshield c_width=5u c_length=5u
X599 a_3540_180844# VSS cap_mim_2f0_m4m5_noshield c_width=5u c_length=5u
X600 a_3540_180844# VSS cap_mim_2f0_m4m5_noshield c_width=5u c_length=5u
X601 a_3540_180844# VSS cap_mim_2f0_m4m5_noshield c_width=5u c_length=5u
X602 a_3540_180844# VSS cap_mim_2f0_m4m5_noshield c_width=5u c_length=5u
X603 a_3540_180844# VSS cap_mim_2f0_m4m5_noshield c_width=5u c_length=5u
X604 a_3540_180844# VSS cap_mim_2f0_m4m5_noshield c_width=5u c_length=5u
X605 a_3540_180844# VSS cap_mim_2f0_m4m5_noshield c_width=5u c_length=5u
X606 a_3540_180844# VSS cap_mim_2f0_m4m5_noshield c_width=5u c_length=5u
X607 a_3540_180844# VSS cap_mim_2f0_m4m5_noshield c_width=5u c_length=5u
X608 a_3540_180844# VSS cap_mim_2f0_m4m5_noshield c_width=5u c_length=5u
X609 a_3540_180844# VSS cap_mim_2f0_m4m5_noshield c_width=5u c_length=5u
X610 a_3540_180844# VSS cap_mim_2f0_m4m5_noshield c_width=5u c_length=5u
X611 a_88109_80239# VSS cap_mim_2f0_m4m5_noshield c_width=5u c_length=5u
X612 a_3540_180844# VSS cap_mim_2f0_m4m5_noshield c_width=5u c_length=5u
X613 a_3540_180844# VSS cap_mim_2f0_m4m5_noshield c_width=5u c_length=5u
X614 a_3540_180844# VSS cap_mim_2f0_m4m5_noshield c_width=5u c_length=5u
X615 a_3540_180844# VSS cap_mim_2f0_m4m5_noshield c_width=5u c_length=5u
X616 a_3540_180844# VSS cap_mim_2f0_m4m5_noshield c_width=5u c_length=5u
X617 a_3540_180844# VSS cap_mim_2f0_m4m5_noshield c_width=5u c_length=5u
X618 a_3540_180844# VSS cap_mim_2f0_m4m5_noshield c_width=5u c_length=5u
X619 a_3540_180844# VSS cap_mim_2f0_m4m5_noshield c_width=5u c_length=5u
X620 a_3540_180844# VSS cap_mim_2f0_m4m5_noshield c_width=5u c_length=5u
X621 a_3540_180844# VSS cap_mim_2f0_m4m5_noshield c_width=5u c_length=5u
X622 a_3540_180844# VSS cap_mim_2f0_m4m5_noshield c_width=5u c_length=5u
X623 a_3540_180844# VSS cap_mim_2f0_m4m5_noshield c_width=5u c_length=5u
X624 a_3540_180844# VSS cap_mim_2f0_m4m5_noshield c_width=5u c_length=5u
X625 a_3540_180844# VSS cap_mim_2f0_m4m5_noshield c_width=5u c_length=5u
X626 VCTRL.t1 VSS cap_mim_2f0_m4m5_noshield c_width=5u c_length=5u
X627 a_3540_180844# VSS cap_mim_2f0_m4m5_noshield c_width=5u c_length=5u
X628 a_3540_180844# VSS cap_mim_2f0_m4m5_noshield c_width=5u c_length=5u
X629 a_3540_180844# VSS cap_mim_2f0_m4m5_noshield c_width=5u c_length=5u
X630 a_3540_181966.t7 VSS cap_mim_2f0_m4m5_noshield c_width=5u c_length=5u
X631 a_87640_80239# PB.t23 VDD VDD pfet_03v3 ad=2.12p pd=8.53u as=2.12p ps=8.53u w=8u l=2u
X632 a_3540_180844# VSS cap_mim_2f0_m4m5_noshield c_width=5u c_length=5u
X633 a_3540_180844# VSS cap_mim_2f0_m4m5_noshield c_width=5u c_length=5u
X634 a_3540_180844# VSS cap_mim_2f0_m4m5_noshield c_width=5u c_length=5u
X635 a_3540_180844# VSS cap_mim_2f0_m4m5_noshield c_width=5u c_length=5u
X636 a_3540_180844# VSS cap_mim_2f0_m4m5_noshield c_width=5u c_length=5u
X637 a_3540_180844# VSS cap_mim_2f0_m4m5_noshield c_width=5u c_length=5u
X638 a_3540_180844# VSS cap_mim_2f0_m4m5_noshield c_width=5u c_length=5u
X639 a_3540_180844# VSS cap_mim_2f0_m4m5_noshield c_width=5u c_length=5u
X640 a_3540_180844# VSS cap_mim_2f0_m4m5_noshield c_width=5u c_length=5u
X641 a_3540_180844# VSS cap_mim_2f0_m4m5_noshield c_width=5u c_length=5u
X642 a_3540_180844# VSS cap_mim_2f0_m4m5_noshield c_width=5u c_length=5u
X643 a_3540_180844# VSS cap_mim_2f0_m4m5_noshield c_width=5u c_length=5u
X644 a_3540_180844# VSS cap_mim_2f0_m4m5_noshield c_width=5u c_length=5u
X645 a_3540_180844# VSS cap_mim_2f0_m4m5_noshield c_width=5u c_length=5u
X646 a_3540_181966.t7 VSS cap_mim_2f0_m4m5_noshield c_width=5u c_length=5u
X647 a_3540_180844# VSS cap_mim_2f0_m4m5_noshield c_width=5u c_length=5u
X648 a_3540_180844# VSS cap_mim_2f0_m4m5_noshield c_width=5u c_length=5u
X649 a_3540_180844# VSS cap_mim_2f0_m4m5_noshield c_width=5u c_length=5u
X650 a_3540_180844# VSS cap_mim_2f0_m4m5_noshield c_width=5u c_length=5u
X651 a_3540_180844# VSS cap_mim_2f0_m4m5_noshield c_width=5u c_length=5u
X652 a_3540_180844# VSS cap_mim_2f0_m4m5_noshield c_width=5u c_length=5u
X653 a_88109_80239# a_88033_80029# a_89880_80239# VDD pfet_03v3 ad=1.06p pd=4.53u as=1.06p ps=4.53u w=4u l=0.28u
X654 a_3540_180844# VSS cap_mim_2f0_m4m5_noshield c_width=5u c_length=5u
X655 a_3540_181966.t7 VSS cap_mim_2f0_m4m5_noshield c_width=5u c_length=5u
X656 a_3540_180844# VSS cap_mim_2f0_m4m5_noshield c_width=5u c_length=5u
X657 a_3540_180844# VSS cap_mim_2f0_m4m5_noshield c_width=5u c_length=5u
X658 a_3540_180844# VSS cap_mim_2f0_m4m5_noshield c_width=5u c_length=5u
X659 a_3540_180844# VSS cap_mim_2f0_m4m5_noshield c_width=5u c_length=5u
X660 a_3540_180844# VSS cap_mim_2f0_m4m5_noshield c_width=5u c_length=5u
X661 a_3540_180844# VSS cap_mim_2f0_m4m5_noshield c_width=5u c_length=5u
X662 a_39625_40940# a_31785_45000# VDD VDD pfet_03v3 ad=0.89p pd=4.89u as=0.89p ps=4.89u w=2u l=0.28u
X663 a_3540_180844# VSS cap_mim_2f0_m4m5_noshield c_width=5u c_length=5u
X664 a_3540_180844# VSS cap_mim_2f0_m4m5_noshield c_width=5u c_length=5u
X665 a_3540_180844# VSS cap_mim_2f0_m4m5_noshield c_width=5u c_length=5u
X666 a_3540_180844# VSS cap_mim_2f0_m4m5_noshield c_width=5u c_length=5u
X667 a_17667_83249# a_8147_83109# a_23800_61800# VSS nfet_03v3 ad=1.335p pd=6.89u as=1.335p ps=6.89u w=3u l=0.28u
X668 a_3540_180844# VSS cap_mim_2f0_m4m5_noshield c_width=5u c_length=5u
X669 a_3540_180844# VSS cap_mim_2f0_m4m5_noshield c_width=5u c_length=5u
X670 a_3540_180844# VSS cap_mim_2f0_m4m5_noshield c_width=5u c_length=5u
X671 a_3540_180844# VSS cap_mim_2f0_m4m5_noshield c_width=5u c_length=5u
X672 a_3540_181966.t7 VSS cap_mim_2f0_m4m5_noshield c_width=5u c_length=5u
X673 a_3540_181966.t7 VSS cap_mim_2f0_m4m5_noshield c_width=5u c_length=5u
X674 a_51800_82520# a_53507_83249# a_51945_86720# VSS nfet_03v3 ad=1.335p pd=6.89u as=1.335p ps=6.89u w=3u l=0.28u
X675 a_3540_180844# VSS cap_mim_2f0_m4m5_noshield c_width=5u c_length=5u
X676 a_3540_180844# VSS cap_mim_2f0_m4m5_noshield c_width=5u c_length=5u
X677 a_3540_181966.t7 VSS cap_mim_2f0_m4m5_noshield c_width=5u c_length=5u
X678 a_3540_180844# VSS cap_mim_2f0_m4m5_noshield c_width=5u c_length=5u
X679 a_3540_180844# VSS cap_mim_2f0_m4m5_noshield c_width=5u c_length=5u
X680 a_3540_180844# VSS cap_mim_2f0_m4m5_noshield c_width=5u c_length=5u
X681 a_3540_180844# VSS cap_mim_2f0_m4m5_noshield c_width=5u c_length=5u
X682 a_3540_180844# VSS cap_mim_2f0_m4m5_noshield c_width=5u c_length=5u
X683 a_3540_180844# VSS cap_mim_2f0_m4m5_noshield c_width=5u c_length=5u
X684 a_3540_180844# VSS cap_mim_2f0_m4m5_noshield c_width=5u c_length=5u
X685 a_3540_180844# VSS cap_mim_2f0_m4m5_noshield c_width=5u c_length=5u
X686 a_3540_180844# VSS cap_mim_2f0_m4m5_noshield c_width=5u c_length=5u
X687 a_3540_180844# VSS cap_mim_2f0_m4m5_noshield c_width=5u c_length=5u
X688 a_3540_180844# VSS cap_mim_2f0_m4m5_noshield c_width=5u c_length=5u
X689 a_3540_180844# VSS cap_mim_2f0_m4m5_noshield c_width=5u c_length=5u
X690 a_3540_180844# VSS cap_mim_2f0_m4m5_noshield c_width=5u c_length=5u
X691 a_3540_180844# VSS cap_mim_2f0_m4m5_noshield c_width=5u c_length=5u
X692 a_87640_80239# PB.t19 VDD VDD pfet_03v3 ad=2.12p pd=8.53u as=2.12p ps=8.53u w=8u l=2u
X693 a_3540_180844# VSS cap_mim_2f0_m4m5_noshield c_width=5u c_length=5u
X694 a_3540_180844# VSS cap_mim_2f0_m4m5_noshield c_width=5u c_length=5u
X695 a_3540_180844# VSS cap_mim_2f0_m4m5_noshield c_width=5u c_length=5u
X696 a_3540_180844# VSS cap_mim_2f0_m4m5_noshield c_width=5u c_length=5u
X697 a_3540_181966.t7 VSS cap_mim_2f0_m4m5_noshield c_width=5u c_length=5u
X698 a_3540_180844# VSS cap_mim_2f0_m4m5_noshield c_width=5u c_length=5u
X699 a_88109_80239# VSS cap_mim_2f0_m4m5_noshield c_width=5u c_length=5u
X700 a_3540_180844# VSS cap_mim_2f0_m4m5_noshield c_width=5u c_length=5u
X701 a_3540_180844# VSS cap_mim_2f0_m4m5_noshield c_width=5u c_length=5u
X702 a_3540_180844# VSS cap_mim_2f0_m4m5_noshield c_width=5u c_length=5u
X703 a_3540_180844# VSS cap_mim_2f0_m4m5_noshield c_width=5u c_length=5u
X704 a_10260_18186# a_9840_16064# VSS ppolyf_u_1k r_width=1u r_length=10u
X705 VCTRL.t1 VSS cap_mim_2f0_m4m5_noshield c_width=5u c_length=5u
X706 a_3540_180844# VSS cap_mim_2f0_m4m5_noshield c_width=5u c_length=5u
X707 a_3540_180844# VSS cap_mim_2f0_m4m5_noshield c_width=5u c_length=5u
X708 REFIN a_3667_12409# cap_mim_2f0_m4m5_noshield c_width=5u c_length=5u
X709 a_3540_180844# VSS cap_mim_2f0_m4m5_noshield c_width=5u c_length=5u
X710 a_3540_180844# VSS cap_mim_2f0_m4m5_noshield c_width=5u c_length=5u
X711 a_3540_180844# VSS cap_mim_2f0_m4m5_noshield c_width=5u c_length=5u
X712 a_3540_180844# VSS cap_mim_2f0_m4m5_noshield c_width=5u c_length=5u
X713 a_3540_180844# VSS cap_mim_2f0_m4m5_noshield c_width=5u c_length=5u
X714 a_3540_180844# VSS cap_mim_2f0_m4m5_noshield c_width=5u c_length=5u
X715 a_3540_180844# VSS cap_mim_2f0_m4m5_noshield c_width=5u c_length=5u
X716 a_3540_180844# VSS cap_mim_2f0_m4m5_noshield c_width=5u c_length=5u
X717 a_3540_180844# VSS cap_mim_2f0_m4m5_noshield c_width=5u c_length=5u
X718 a_45640_7480# a_31785_19940# VSS VSS nfet_03v3 ad=0.6675p pd=3.89u as=0.6675p ps=3.89u w=1.5u l=0.28u
X719 a_3540_180844# VSS cap_mim_2f0_m4m5_noshield c_width=5u c_length=5u
X720 a_3540_180844# VSS cap_mim_2f0_m4m5_noshield c_width=5u c_length=5u
X721 a_3540_180844# VSS cap_mim_2f0_m4m5_noshield c_width=5u c_length=5u
X722 a_3540_180844# VSS cap_mim_2f0_m4m5_noshield c_width=5u c_length=5u
X723 a_3540_180844# VSS cap_mim_2f0_m4m5_noshield c_width=5u c_length=5u
X724 a_3540_180844# VSS cap_mim_2f0_m4m5_noshield c_width=5u c_length=5u
X725 a_3540_180844# VSS cap_mim_2f0_m4m5_noshield c_width=5u c_length=5u
X726 a_3540_180844# VSS cap_mim_2f0_m4m5_noshield c_width=5u c_length=5u
X727 a_3540_180844# VSS cap_mim_2f0_m4m5_noshield c_width=5u c_length=5u
X728 a_3540_180844# VSS cap_mim_2f0_m4m5_noshield c_width=5u c_length=5u
X729 a_3540_180844# VSS cap_mim_2f0_m4m5_noshield c_width=5u c_length=5u
X730 a_3540_180844# VSS cap_mim_2f0_m4m5_noshield c_width=5u c_length=5u
X731 a_3540_180844# VSS cap_mim_2f0_m4m5_noshield c_width=5u c_length=5u
X732 a_3540_180844# VSS cap_mim_2f0_m4m5_noshield c_width=5u c_length=5u
X733 a_3540_180844# VSS cap_mim_2f0_m4m5_noshield c_width=5u c_length=5u
X734 a_53507_83249# a_43987_83109# a_59640_61800# VSS nfet_03v3 ad=1.335p pd=6.89u as=1.335p ps=6.89u w=3u l=0.28u
X735 a_3540_180844# VSS cap_mim_2f0_m4m5_noshield c_width=5u c_length=5u
X736 a_3540_180844# VSS cap_mim_2f0_m4m5_noshield c_width=5u c_length=5u
X737 a_3540_180844# VSS cap_mim_2f0_m4m5_noshield c_width=5u c_length=5u
X738 a_88109_80239# VSS cap_mim_2f0_m4m5_noshield c_width=5u c_length=5u
X739 a_3540_180844# VSS cap_mim_2f0_m4m5_noshield c_width=5u c_length=5u
X740 a_3540_180844# VSS cap_mim_2f0_m4m5_noshield c_width=5u c_length=5u
X741 a_3540_181966.t7 VSS cap_mim_2f0_m4m5_noshield c_width=5u c_length=5u
X742 a_3540_180844# VSS cap_mim_2f0_m4m5_noshield c_width=5u c_length=5u
X743 a_3540_181966.t7 VSS cap_mim_2f0_m4m5_noshield c_width=5u c_length=5u
X744 a_3540_181966.t7 VSS cap_mim_2f0_m4m5_noshield c_width=5u c_length=5u
X745 a_3540_180844# VSS cap_mim_2f0_m4m5_noshield c_width=5u c_length=5u
X746 a_3540_180844# VSS cap_mim_2f0_m4m5_noshield c_width=5u c_length=5u
X747 a_3540_180844# VSS cap_mim_2f0_m4m5_noshield c_width=5u c_length=5u
X748 a_3540_180844# VSS cap_mim_2f0_m4m5_noshield c_width=5u c_length=5u
X749 a_3540_180844# VSS cap_mim_2f0_m4m5_noshield c_width=5u c_length=5u
X750 a_3540_181966.t7 VSS cap_mim_2f0_m4m5_noshield c_width=5u c_length=5u
X751 a_3540_180844# VSS cap_mim_2f0_m4m5_noshield c_width=5u c_length=5u
X752 VCTRL.t1 VSS cap_mim_2f0_m4m5_noshield c_width=5u c_length=5u
X753 a_3540_180844# VSS cap_mim_2f0_m4m5_noshield c_width=5u c_length=5u
X754 a_3540_180844# VSS cap_mim_2f0_m4m5_noshield c_width=5u c_length=5u
X755 a_3540_180844# VSS cap_mim_2f0_m4m5_noshield c_width=5u c_length=5u
X756 a_3540_180844# VSS cap_mim_2f0_m4m5_noshield c_width=5u c_length=5u
X757 a_3540_180844# VSS cap_mim_2f0_m4m5_noshield c_width=5u c_length=5u
X758 a_3540_180844# VSS cap_mim_2f0_m4m5_noshield c_width=5u c_length=5u
X759 a_3540_180844# VSS cap_mim_2f0_m4m5_noshield c_width=5u c_length=5u
X760 a_3540_180844# VSS cap_mim_2f0_m4m5_noshield c_width=5u c_length=5u
X761 a_3540_180844# VSS cap_mim_2f0_m4m5_noshield c_width=5u c_length=5u
X762 a_3540_180844# VSS cap_mim_2f0_m4m5_noshield c_width=5u c_length=5u
X763 a_3540_181966.t7 VSS cap_mim_2f0_m4m5_noshield c_width=5u c_length=5u
X764 a_3540_180844# VSS cap_mim_2f0_m4m5_noshield c_width=5u c_length=5u
X765 a_3540_180844# VSS cap_mim_2f0_m4m5_noshield c_width=5u c_length=5u
X766 a_3540_180844# VSS cap_mim_2f0_m4m5_noshield c_width=5u c_length=5u
X767 a_3540_180844# VSS cap_mim_2f0_m4m5_noshield c_width=5u c_length=5u
X768 a_3540_180844# VSS cap_mim_2f0_m4m5_noshield c_width=5u c_length=5u
X769 a_3540_180844# VSS cap_mim_2f0_m4m5_noshield c_width=5u c_length=5u
X770 a_3540_180844# VSS cap_mim_2f0_m4m5_noshield c_width=5u c_length=5u
X771 a_3540_180844# VSS cap_mim_2f0_m4m5_noshield c_width=5u c_length=5u
X772 a_3540_180844# VSS cap_mim_2f0_m4m5_noshield c_width=5u c_length=5u
X773 a_3540_180844# VSS cap_mim_2f0_m4m5_noshield c_width=5u c_length=5u
X774 a_3540_180844# VSS cap_mim_2f0_m4m5_noshield c_width=5u c_length=5u
X775 a_3540_180844# VSS cap_mim_2f0_m4m5_noshield c_width=5u c_length=5u
X776 a_3540_180844# VSS cap_mim_2f0_m4m5_noshield c_width=5u c_length=5u
X777 a_3540_180844# VSS cap_mim_2f0_m4m5_noshield c_width=5u c_length=5u
X778 a_3540_180844# VSS cap_mim_2f0_m4m5_noshield c_width=5u c_length=5u
X779 a_3540_180844# VSS cap_mim_2f0_m4m5_noshield c_width=5u c_length=5u
X780 a_3540_180844# VSS cap_mim_2f0_m4m5_noshield c_width=5u c_length=5u
X781 a_3540_180844# VSS cap_mim_2f0_m4m5_noshield c_width=5u c_length=5u
X782 a_3540_180844# VSS cap_mim_2f0_m4m5_noshield c_width=5u c_length=5u
X783 a_45667_83109# a_53507_83249# VDD VDD pfet_03v3 ad=0.89p pd=4.89u as=0.89p ps=4.89u w=2u l=0.28u
X784 a_3540_180844# VSS cap_mim_2f0_m4m5_noshield c_width=5u c_length=5u
X785 a_3540_181966.t7 VSS cap_mim_2f0_m4m5_noshield c_width=5u c_length=5u
X786 a_3540_180844# VSS cap_mim_2f0_m4m5_noshield c_width=5u c_length=5u
X787 a_3540_180844# VSS cap_mim_2f0_m4m5_noshield c_width=5u c_length=5u
X788 a_3540_180844# VSS cap_mim_2f0_m4m5_noshield c_width=5u c_length=5u
X789 a_3540_180844# VSS cap_mim_2f0_m4m5_noshield c_width=5u c_length=5u
X790 a_3540_180844# VSS cap_mim_2f0_m4m5_noshield c_width=5u c_length=5u
X791 a_3540_180844# VSS cap_mim_2f0_m4m5_noshield c_width=5u c_length=5u
X792 a_3540_180844# VSS cap_mim_2f0_m4m5_noshield c_width=5u c_length=5u
X793 a_3540_181966.t8 VSS cap_mim_2f0_m4m5_noshield c_width=5u c_length=5u
X794 a_88109_80239# a_36825_105682.t3 a_88409_69640# VSS nfet_03v3 ad=0.89p pd=4.89u as=0.89p ps=4.89u w=2u l=0.28u
X795 a_5220_18186# a_5640_16064# VSS ppolyf_u_1k r_width=1u r_length=10u
X796 a_29987_20669# a_19465_10700# VDD VDD pfet_03v3 ad=0.89p pd=4.89u as=0.89p ps=4.89u w=2u l=0.28u
X797 a_3540_180844# VSS cap_mim_2f0_m4m5_noshield c_width=5u c_length=5u
X798 a_3540_180844# VSS cap_mim_2f0_m4m5_noshield c_width=5u c_length=5u
X799 a_3540_180844# VSS cap_mim_2f0_m4m5_noshield c_width=5u c_length=5u
X800 a_3540_180844# VSS cap_mim_2f0_m4m5_noshield c_width=5u c_length=5u
X801 a_3540_180844# VSS cap_mim_2f0_m4m5_noshield c_width=5u c_length=5u
X802 a_3540_180844# VSS cap_mim_2f0_m4m5_noshield c_width=5u c_length=5u
X803 a_3540_180844# VSS cap_mim_2f0_m4m5_noshield c_width=5u c_length=5u
X804 a_3540_180844# VSS cap_mim_2f0_m4m5_noshield c_width=5u c_length=5u
X805 a_3540_180844# VSS cap_mim_2f0_m4m5_noshield c_width=5u c_length=5u
X806 a_3540_180844# VSS cap_mim_2f0_m4m5_noshield c_width=5u c_length=5u
X807 a_3540_180844# VSS cap_mim_2f0_m4m5_noshield c_width=5u c_length=5u
X808 VCTRL.t1 VSS cap_mim_2f0_m4m5_noshield c_width=5u c_length=5u
X809 a_3540_180844# VSS cap_mim_2f0_m4m5_noshield c_width=5u c_length=5u
X810 a_3540_180844# VSS cap_mim_2f0_m4m5_noshield c_width=5u c_length=5u
X811 a_3540_180844# VSS cap_mim_2f0_m4m5_noshield c_width=5u c_length=5u
X812 a_3540_180844# VSS cap_mim_2f0_m4m5_noshield c_width=5u c_length=5u
X813 a_3540_180844# VSS cap_mim_2f0_m4m5_noshield c_width=5u c_length=5u
X814 a_3540_180844# VSS cap_mim_2f0_m4m5_noshield c_width=5u c_length=5u
X815 a_3540_180844# VSS cap_mim_2f0_m4m5_noshield c_width=5u c_length=5u
X816 a_3540_180844# VSS cap_mim_2f0_m4m5_noshield c_width=5u c_length=5u
X817 a_3540_180844# VSS cap_mim_2f0_m4m5_noshield c_width=5u c_length=5u
X818 a_3540_180844# VSS cap_mim_2f0_m4m5_noshield c_width=5u c_length=5u
X819 a_3540_180844# VSS cap_mim_2f0_m4m5_noshield c_width=5u c_length=5u
X820 a_3540_180844# VSS cap_mim_2f0_m4m5_noshield c_width=5u c_length=5u
X821 VCTRL.t1 VSS cap_mim_2f0_m4m5_noshield c_width=5u c_length=5u
X822 a_3540_180844# VSS cap_mim_2f0_m4m5_noshield c_width=5u c_length=5u
X823 a_3540_180844# VSS cap_mim_2f0_m4m5_noshield c_width=5u c_length=5u
X824 a_3540_180844# VSS cap_mim_2f0_m4m5_noshield c_width=5u c_length=5u
X825 a_3540_181966.t7 VSS cap_mim_2f0_m4m5_noshield c_width=5u c_length=5u
X826 a_3540_180844# VSS cap_mim_2f0_m4m5_noshield c_width=5u c_length=5u
X827 a_3540_180844# VSS cap_mim_2f0_m4m5_noshield c_width=5u c_length=5u
X828 a_9827_83109# a_8265_82520.t5 a_15960_82520# VSS nfet_03v3 ad=1.335p pd=6.89u as=1.335p ps=6.89u w=3u l=0.28u
X829 a_3540_180844# VSS cap_mim_2f0_m4m5_noshield c_width=5u c_length=5u
X830 a_3540_180844# VSS cap_mim_2f0_m4m5_noshield c_width=5u c_length=5u
X831 a_3540_180844# VSS cap_mim_2f0_m4m5_noshield c_width=5u c_length=5u
X832 a_3540_180844# VSS cap_mim_2f0_m4m5_noshield c_width=5u c_length=5u
X833 a_3540_181966.t7 VSS cap_mim_2f0_m4m5_noshield c_width=5u c_length=5u
X834 a_3540_180844# VSS cap_mim_2f0_m4m5_noshield c_width=5u c_length=5u
X835 a_3540_180844# VSS cap_mim_2f0_m4m5_noshield c_width=5u c_length=5u
X836 a_3540_180844# VSS cap_mim_2f0_m4m5_noshield c_width=5u c_length=5u
X837 a_3540_180844# VSS cap_mim_2f0_m4m5_noshield c_width=5u c_length=5u
X838 a_3540_180844# VSS cap_mim_2f0_m4m5_noshield c_width=5u c_length=5u
X839 a_3540_180844# VSS cap_mim_2f0_m4m5_noshield c_width=5u c_length=5u
X840 a_3540_180844# VSS cap_mim_2f0_m4m5_noshield c_width=5u c_length=5u
X841 a_3540_180844# VSS cap_mim_2f0_m4m5_noshield c_width=5u c_length=5u
X842 a_3540_180844# VSS cap_mim_2f0_m4m5_noshield c_width=5u c_length=5u
X843 a_3540_180844# VSS cap_mim_2f0_m4m5_noshield c_width=5u c_length=5u
X844 LO a_17667_11569# cap_mim_2f0_m4m5_noshield c_width=5u c_length=5u
X845 a_29960_11680# a_29987_20669# VSS VSS nfet_03v3 ad=0.6675p pd=3.89u as=0.6675p ps=3.89u w=1.5u l=0.28u
X846 a_3540_180844# VSS cap_mim_2f0_m4m5_noshield c_width=5u c_length=5u
X847 a_3540_180844# VSS cap_mim_2f0_m4m5_noshield c_width=5u c_length=5u
X848 a_3540_180844# VSS cap_mim_2f0_m4m5_noshield c_width=5u c_length=5u
X849 a_3540_180844# VSS cap_mim_2f0_m4m5_noshield c_width=5u c_length=5u
X850 a_3540_180844# VSS cap_mim_2f0_m4m5_noshield c_width=5u c_length=5u
X851 a_3540_180844# VSS cap_mim_2f0_m4m5_noshield c_width=5u c_length=5u
X852 a_3540_180844# VSS cap_mim_2f0_m4m5_noshield c_width=5u c_length=5u
X853 a_3540_180844# VSS cap_mim_2f0_m4m5_noshield c_width=5u c_length=5u
X854 a_3540_181966.t7 VSS cap_mim_2f0_m4m5_noshield c_width=5u c_length=5u
X855 a_3540_180844# VSS cap_mim_2f0_m4m5_noshield c_width=5u c_length=5u
X856 a_3540_181966.t7 VSS cap_mim_2f0_m4m5_noshield c_width=5u c_length=5u
X857 a_3540_180844# VSS cap_mim_2f0_m4m5_noshield c_width=5u c_length=5u
X858 a_3540_180844# VSS cap_mim_2f0_m4m5_noshield c_width=5u c_length=5u
X859 REFIN a_3667_12409# cap_mim_2f0_m4m5_noshield c_width=5u c_length=5u
X860 a_3540_180844# VSS cap_mim_2f0_m4m5_noshield c_width=5u c_length=5u
X861 a_3540_181966.t8 VSS cap_mim_2f0_m4m5_noshield c_width=5u c_length=5u
X862 a_3540_180844# VSS cap_mim_2f0_m4m5_noshield c_width=5u c_length=5u
X863 a_3540_180844# VSS cap_mim_2f0_m4m5_noshield c_width=5u c_length=5u
X864 a_3540_180844# VSS cap_mim_2f0_m4m5_noshield c_width=5u c_length=5u
X865 a_3540_180844# VSS cap_mim_2f0_m4m5_noshield c_width=5u c_length=5u
X866 VDD a_99409_69879# a_99409_69879# VDD pfet_03v3 ad=1.06p pd=4.53u as=1.06p ps=4.53u w=4u l=1u
X867 a_3540_180844# VSS cap_mim_2f0_m4m5_noshield c_width=5u c_length=5u
X868 a_3540_180844# VSS cap_mim_2f0_m4m5_noshield c_width=5u c_length=5u
X869 a_3540_180844# VSS cap_mim_2f0_m4m5_noshield c_width=5u c_length=5u
X870 a_3540_181966.t7 VSS cap_mim_2f0_m4m5_noshield c_width=5u c_length=5u
X871 a_3540_180844# VSS cap_mim_2f0_m4m5_noshield c_width=5u c_length=5u
X872 a_3540_180844# VSS cap_mim_2f0_m4m5_noshield c_width=5u c_length=5u
X873 a_88109_80239# VSS cap_mim_2f0_m4m5_noshield c_width=5u c_length=5u
X874 a_3540_180844# VSS cap_mim_2f0_m4m5_noshield c_width=5u c_length=5u
X875 VCTRL.t1 VSS cap_mim_2f0_m4m5_noshield c_width=5u c_length=5u
X876 a_3540_180844# VSS cap_mim_2f0_m4m5_noshield c_width=5u c_length=5u
X877 a_3540_180844# VSS cap_mim_2f0_m4m5_noshield c_width=5u c_length=5u
X878 a_3540_180844# VSS cap_mim_2f0_m4m5_noshield c_width=5u c_length=5u
X879 a_3540_180844# VSS cap_mim_2f0_m4m5_noshield c_width=5u c_length=5u
X880 a_3540_180844# VSS cap_mim_2f0_m4m5_noshield c_width=5u c_length=5u
X881 a_88109_80239# VSS cap_mim_2f0_m4m5_noshield c_width=5u c_length=5u
X882 a_3540_180844# VSS cap_mim_2f0_m4m5_noshield c_width=5u c_length=5u
X883 a_3540_180844# VSS cap_mim_2f0_m4m5_noshield c_width=5u c_length=5u
X884 a_3540_180844# VSS cap_mim_2f0_m4m5_noshield c_width=5u c_length=5u
X885 a_88109_80239# VSS cap_mim_2f0_m4m5_noshield c_width=5u c_length=5u
X886 a_3540_180844# VSS cap_mim_2f0_m4m5_noshield c_width=5u c_length=5u
X887 a_3540_180844# VSS cap_mim_2f0_m4m5_noshield c_width=5u c_length=5u
X888 a_3540_180844# VSS cap_mim_2f0_m4m5_noshield c_width=5u c_length=5u
X889 a_92457_69640# a_3540_181966.t9 a_99409_69879# VSS nfet_03v3 ad=1.06p pd=4.53u as=1.06p ps=4.53u w=4u l=1u
X890 a_3540_180844# VSS cap_mim_2f0_m4m5_noshield c_width=5u c_length=5u
X891 a_44105_61800# a_43987_62389# a_43960_61800# VSS nfet_03v3 ad=0.89p pd=4.89u as=0.89p ps=4.89u w=2u l=0.28u
X892 a_3540_180844# VSS cap_mim_2f0_m4m5_noshield c_width=5u c_length=5u
X893 VSS NB.t12 a_88409_69640# VSS nfet_03v3 ad=2.12p pd=8.53u as=2.12p ps=8.53u w=8u l=2u
X894 a_88109_80239# VSS cap_mim_2f0_m4m5_noshield c_width=5u c_length=5u
X895 a_3540_180844# VSS cap_mim_2f0_m4m5_noshield c_width=5u c_length=5u
X896 a_3540_180844# VSS cap_mim_2f0_m4m5_noshield c_width=5u c_length=5u
X897 a_3540_180844# VSS cap_mim_2f0_m4m5_noshield c_width=5u c_length=5u
X898 a_3540_181966.t1 a_30665_105682.t5 a_87640_80239# VDD pfet_03v3 ad=1.06p pd=4.53u as=1.78p ps=8.89u w=4u l=0.28u
X899 a_3540_180844# VSS cap_mim_2f0_m4m5_noshield c_width=5u c_length=5u
X900 a_6060_18186# a_5640_16064# VSS ppolyf_u_1k r_width=1u r_length=10u
X901 a_3540_180844# VSS cap_mim_2f0_m4m5_noshield c_width=5u c_length=5u
X902 a_3540_180844# VSS cap_mim_2f0_m4m5_noshield c_width=5u c_length=5u
X903 a_3540_180844# VSS cap_mim_2f0_m4m5_noshield c_width=5u c_length=5u
X904 a_3540_180844# VSS cap_mim_2f0_m4m5_noshield c_width=5u c_length=5u
X905 a_3540_180844# VSS cap_mim_2f0_m4m5_noshield c_width=5u c_length=5u
X906 a_3540_180844# VSS cap_mim_2f0_m4m5_noshield c_width=5u c_length=5u
X907 a_3540_180844# VSS cap_mim_2f0_m4m5_noshield c_width=5u c_length=5u
X908 a_3540_180844# VSS cap_mim_2f0_m4m5_noshield c_width=5u c_length=5u
X909 a_3540_180844# VSS cap_mim_2f0_m4m5_noshield c_width=5u c_length=5u
X910 a_3540_180844# VSS cap_mim_2f0_m4m5_noshield c_width=5u c_length=5u
X911 a_3540_180844# VSS cap_mim_2f0_m4m5_noshield c_width=5u c_length=5u
X912 a_3540_180844# VSS cap_mim_2f0_m4m5_noshield c_width=5u c_length=5u
X913 a_3540_180844# VSS cap_mim_2f0_m4m5_noshield c_width=5u c_length=5u
X914 a_3540_180844# VSS cap_mim_2f0_m4m5_noshield c_width=5u c_length=5u
X915 a_3540_180844# VSS cap_mim_2f0_m4m5_noshield c_width=5u c_length=5u
X916 a_17667_83249# a_8147_83109# VDD VDD pfet_03v3 ad=0.89p pd=4.89u as=0.89p ps=4.89u w=2u l=0.28u
X917 REFCK.t1 a_3540_16064# VDD VDD pfet_03v3 ad=1.78p pd=8.89u as=1.78p ps=8.89u w=4u l=0.28u
X918 a_3540_180844# VSS cap_mim_2f0_m4m5_noshield c_width=5u c_length=5u
X919 a_3540_180844# VSS cap_mim_2f0_m4m5_noshield c_width=5u c_length=5u
X920 a_3540_180844# VSS cap_mim_2f0_m4m5_noshield c_width=5u c_length=5u
X921 a_3540_180844# VSS cap_mim_2f0_m4m5_noshield c_width=5u c_length=5u
X922 a_3540_180844# VSS cap_mim_2f0_m4m5_noshield c_width=5u c_length=5u
X923 a_3540_180844# VSS cap_mim_2f0_m4m5_noshield c_width=5u c_length=5u
X924 a_3540_180844# VSS cap_mim_2f0_m4m5_noshield c_width=5u c_length=5u
X925 a_3540_180844# VSS cap_mim_2f0_m4m5_noshield c_width=5u c_length=5u
X926 a_3540_180844# VSS cap_mim_2f0_m4m5_noshield c_width=5u c_length=5u
X927 a_3540_181966.t7 VSS cap_mim_2f0_m4m5_noshield c_width=5u c_length=5u
X928 a_3540_180844# VSS cap_mim_2f0_m4m5_noshield c_width=5u c_length=5u
X929 a_39507_45729# a_39625_32882# a_41160_32540# VSS nfet_03v3 ad=0.6675p pd=3.89u as=0.6675p ps=3.89u w=1.5u l=0.28u
X930 a_3540_180844# VSS cap_mim_2f0_m4m5_noshield c_width=5u c_length=5u
X931 a_3540_180844# VSS cap_mim_2f0_m4m5_noshield c_width=5u c_length=5u
X932 a_3540_180844# VSS cap_mim_2f0_m4m5_noshield c_width=5u c_length=5u
X933 a_3540_180844# VSS cap_mim_2f0_m4m5_noshield c_width=5u c_length=5u
X934 a_3540_181966.t7 VSS cap_mim_2f0_m4m5_noshield c_width=5u c_length=5u
X935 a_3540_180844# VSS cap_mim_2f0_m4m5_noshield c_width=5u c_length=5u
X936 a_3540_180844# VSS cap_mim_2f0_m4m5_noshield c_width=5u c_length=5u
X937 a_3540_180844# VSS cap_mim_2f0_m4m5_noshield c_width=5u c_length=5u
X938 a_3540_180844# VSS cap_mim_2f0_m4m5_noshield c_width=5u c_length=5u
X939 a_3540_180844# VSS cap_mim_2f0_m4m5_noshield c_width=5u c_length=5u
X940 a_3540_180844# VSS cap_mim_2f0_m4m5_noshield c_width=5u c_length=5u
X941 a_3540_180844# VSS cap_mim_2f0_m4m5_noshield c_width=5u c_length=5u
X942 a_3540_180844# VSS cap_mim_2f0_m4m5_noshield c_width=5u c_length=5u
X943 a_6025_105682# a_5907_106069.t3 VDD VDD pfet_03v3 ad=0.89p pd=4.89u as=0.89p ps=4.89u w=2u l=0.28u
X944 a_8580_18186# a_8160_16064# VSS ppolyf_u_1k r_width=1u r_length=10u
X945 a_3540_180844# VSS cap_mim_2f0_m4m5_noshield c_width=5u c_length=5u
X946 a_3540_180844# VSS cap_mim_2f0_m4m5_noshield c_width=5u c_length=5u
X947 a_3540_180844# VSS cap_mim_2f0_m4m5_noshield c_width=5u c_length=5u
X948 a_3540_181966.t7 VSS cap_mim_2f0_m4m5_noshield c_width=5u c_length=5u
X949 a_3540_180844# VSS cap_mim_2f0_m4m5_noshield c_width=5u c_length=5u
X950 a_3540_180844# VSS cap_mim_2f0_m4m5_noshield c_width=5u c_length=5u
X951 a_3540_180844# VSS cap_mim_2f0_m4m5_noshield c_width=5u c_length=5u
X952 a_3540_180844# VSS cap_mim_2f0_m4m5_noshield c_width=5u c_length=5u
X953 a_3540_180844# VSS cap_mim_2f0_m4m5_noshield c_width=5u c_length=5u
X954 a_3540_181966.t7 VSS cap_mim_2f0_m4m5_noshield c_width=5u c_length=5u
X955 a_3540_180844# VSS cap_mim_2f0_m4m5_noshield c_width=5u c_length=5u
X956 a_3540_180844# VSS cap_mim_2f0_m4m5_noshield c_width=5u c_length=5u
X957 a_9827_83109# a_8265_82520.t5 VDD VDD pfet_03v3 ad=0.89p pd=4.89u as=0.89p ps=4.89u w=2u l=0.28u
X958 a_3540_180844# VSS cap_mim_2f0_m4m5_noshield c_width=5u c_length=5u
X959 VSS NB.t8 a_92457_69640# VSS nfet_03v3 ad=2.12p pd=8.53u as=2.12p ps=8.53u w=8u l=2u
X960 a_3540_180844# VSS cap_mim_2f0_m4m5_noshield c_width=5u c_length=5u
X961 a_3540_180844# VSS cap_mim_2f0_m4m5_noshield c_width=5u c_length=5u
X962 a_3540_180844# VSS cap_mim_2f0_m4m5_noshield c_width=5u c_length=5u
X963 VDD PB.t0 a_87640_80239# VDD pfet_03v3 ad=3.56p pd=16.89u as=2.12p ps=8.53u w=8u l=2u
X964 a_3540_180844# VSS cap_mim_2f0_m4m5_noshield c_width=5u c_length=5u
X965 a_3540_180844# VSS cap_mim_2f0_m4m5_noshield c_width=5u c_length=5u
X966 a_3540_180844# VSS cap_mim_2f0_m4m5_noshield c_width=5u c_length=5u
X967 a_30665_105682.t0 a_8265_82520.t6 VSS VSS nfet_03v3 ad=0.445p pd=2.89u as=0.445p ps=2.89u w=1u l=0.28u
X968 a_3540_180844# VSS cap_mim_2f0_m4m5_noshield c_width=5u c_length=5u
X969 a_88109_80239# VSS cap_mim_2f0_m4m5_noshield c_width=5u c_length=5u
X970 a_17667_83249# a_8147_62389# VDD VDD pfet_03v3 ad=0.89p pd=4.89u as=0.89p ps=4.89u w=2u l=0.28u
X971 REFIN a_3667_12409# cap_mim_2f0_m4m5_noshield c_width=5u c_length=5u
X972 a_3540_180844# VSS cap_mim_2f0_m4m5_noshield c_width=5u c_length=5u
X973 a_3540_180844# VSS cap_mim_2f0_m4m5_noshield c_width=5u c_length=5u
X974 a_3540_180844# VSS cap_mim_2f0_m4m5_noshield c_width=5u c_length=5u
X975 a_3540_180844# VSS cap_mim_2f0_m4m5_noshield c_width=5u c_length=5u
X976 a_3540_180844# VSS cap_mim_2f0_m4m5_noshield c_width=5u c_length=5u
X977 a_3540_180844# VSS cap_mim_2f0_m4m5_noshield c_width=5u c_length=5u
X978 a_31785_19940# a_29987_8209# VDD VDD pfet_03v3 ad=0.89p pd=4.89u as=0.89p ps=4.89u w=2u l=0.28u
X979 a_3540_180844# VSS cap_mim_2f0_m4m5_noshield c_width=5u c_length=5u
X980 a_3540_180844# VSS cap_mim_2f0_m4m5_noshield c_width=5u c_length=5u
X981 a_3540_180844# VSS cap_mim_2f0_m4m5_noshield c_width=5u c_length=5u
X982 a_3540_180844# VSS cap_mim_2f0_m4m5_noshield c_width=5u c_length=5u
X983 a_3540_180844# VSS cap_mim_2f0_m4m5_noshield c_width=5u c_length=5u
X984 a_3540_180844# VSS cap_mim_2f0_m4m5_noshield c_width=5u c_length=5u
X985 a_3540_180844# VSS cap_mim_2f0_m4m5_noshield c_width=5u c_length=5u
X986 a_3540_180844# VSS cap_mim_2f0_m4m5_noshield c_width=5u c_length=5u
X987 a_3540_180844# VSS cap_mim_2f0_m4m5_noshield c_width=5u c_length=5u
X988 a_3540_180844# VSS cap_mim_2f0_m4m5_noshield c_width=5u c_length=5u
X989 a_3540_180844# VSS cap_mim_2f0_m4m5_noshield c_width=5u c_length=5u
X990 a_3540_180844# VSS cap_mim_2f0_m4m5_noshield c_width=5u c_length=5u
X991 a_3540_180844# VSS cap_mim_2f0_m4m5_noshield c_width=5u c_length=5u
X992 a_3540_180844# VSS cap_mim_2f0_m4m5_noshield c_width=5u c_length=5u
X993 a_3540_180844# VSS cap_mim_2f0_m4m5_noshield c_width=5u c_length=5u
X994 a_3540_180844# VSS cap_mim_2f0_m4m5_noshield c_width=5u c_length=5u
X995 a_31785_19940# a_29987_8209# VSS VSS nfet_03v3 ad=0.445p pd=2.89u as=0.445p ps=2.89u w=1u l=0.28u
X996 a_53507_83249# a_43987_83109# VDD VDD pfet_03v3 ad=0.89p pd=4.89u as=0.89p ps=4.89u w=2u l=0.28u
X997 VDD PB.t14 a_89421_74820# VDD pfet_03v3 ad=2.12p pd=8.53u as=2.12p ps=8.53u w=8u l=2u
X998 a_3540_180844# VSS cap_mim_2f0_m4m5_noshield c_width=5u c_length=5u
X999 a_3540_180844# VSS cap_mim_2f0_m4m5_noshield c_width=5u c_length=5u
X1000 a_3540_180844# VSS cap_mim_2f0_m4m5_noshield c_width=5u c_length=5u
X1001 a_3540_180844# VSS cap_mim_2f0_m4m5_noshield c_width=5u c_length=5u
X1002 a_3540_180844# VSS cap_mim_2f0_m4m5_noshield c_width=5u c_length=5u
X1003 a_3540_180844# VSS cap_mim_2f0_m4m5_noshield c_width=5u c_length=5u
X1004 a_3540_180844# VSS cap_mim_2f0_m4m5_noshield c_width=5u c_length=5u
X1005 a_3540_180844# VSS cap_mim_2f0_m4m5_noshield c_width=5u c_length=5u
X1006 a_3540_180844# VSS cap_mim_2f0_m4m5_noshield c_width=5u c_length=5u
X1007 a_3540_180844# VSS cap_mim_2f0_m4m5_noshield c_width=5u c_length=5u
X1008 a_3540_180844# VSS cap_mim_2f0_m4m5_noshield c_width=5u c_length=5u
X1009 a_9827_83109# a_15987_66729.t13 VDD VDD pfet_03v3 ad=0.89p pd=4.89u as=0.89p ps=4.89u w=2u l=0.28u
X1010 a_3540_180844# VSS cap_mim_2f0_m4m5_noshield c_width=5u c_length=5u
X1011 a_3540_180844# VSS cap_mim_2f0_m4m5_noshield c_width=5u c_length=5u
X1012 a_3540_180844# VSS cap_mim_2f0_m4m5_noshield c_width=5u c_length=5u
X1013 a_89421_74820# PB.t21 VDD VDD pfet_03v3 ad=2.12p pd=8.53u as=2.12p ps=8.53u w=8u l=2u
X1014 a_3540_180844# VSS cap_mim_2f0_m4m5_noshield c_width=5u c_length=5u
X1015 a_3540_180844# VSS cap_mim_2f0_m4m5_noshield c_width=5u c_length=5u
X1016 a_3540_180844# VSS cap_mim_2f0_m4m5_noshield c_width=5u c_length=5u
X1017 a_3540_180844# VSS cap_mim_2f0_m4m5_noshield c_width=5u c_length=5u
X1018 a_3540_180844# VSS cap_mim_2f0_m4m5_noshield c_width=5u c_length=5u
X1019 a_3540_180844# VSS cap_mim_2f0_m4m5_noshield c_width=5u c_length=5u
X1020 a_92189_81289# ICP2.t2 VSS VSS nfet_03v3 ad=0.445p pd=2.89u as=0.445p ps=2.89u w=1u l=0.28u
X1021 a_3540_180844# VSS cap_mim_2f0_m4m5_noshield c_width=5u c_length=5u
X1022 a_3540_180844# VSS cap_mim_2f0_m4m5_noshield c_width=5u c_length=5u
X1023 a_3540_180844# VSS cap_mim_2f0_m4m5_noshield c_width=5u c_length=5u
X1024 a_3540_180844# VSS cap_mim_2f0_m4m5_noshield c_width=5u c_length=5u
X1025 LO a_17667_11569# cap_mim_2f0_m4m5_noshield c_width=5u c_length=5u
X1026 a_3540_180844# VSS cap_mim_2f0_m4m5_noshield c_width=5u c_length=5u
X1027 a_3540_180844# VSS cap_mim_2f0_m4m5_noshield c_width=5u c_length=5u
X1028 a_88109_80239# VSS cap_mim_2f0_m4m5_noshield c_width=5u c_length=5u
X1029 a_44105_61800# a_43987_62389# VDD VDD pfet_03v3 ad=0.89p pd=4.89u as=0.89p ps=4.89u w=2u l=0.28u
X1030 a_3540_180844# VSS cap_mim_2f0_m4m5_noshield c_width=5u c_length=5u
X1031 a_3540_180844# VSS cap_mim_2f0_m4m5_noshield c_width=5u c_length=5u
X1032 a_3540_180844# VSS cap_mim_2f0_m4m5_noshield c_width=5u c_length=5u
X1033 a_3540_181966.t7 VSS cap_mim_2f0_m4m5_noshield c_width=5u c_length=5u
X1034 a_3540_180844# VSS cap_mim_2f0_m4m5_noshield c_width=5u c_length=5u
X1035 a_3540_181966.t7 VSS cap_mim_2f0_m4m5_noshield c_width=5u c_length=5u
X1036 a_3540_181966.t7 VSS cap_mim_2f0_m4m5_noshield c_width=5u c_length=5u
X1037 a_3540_180844# VSS cap_mim_2f0_m4m5_noshield c_width=5u c_length=5u
X1038 a_3540_180844# VSS cap_mim_2f0_m4m5_noshield c_width=5u c_length=5u
X1039 a_3540_180844# VSS cap_mim_2f0_m4m5_noshield c_width=5u c_length=5u
X1040 a_3540_180844# VSS cap_mim_2f0_m4m5_noshield c_width=5u c_length=5u
X1041 a_3540_180844# VSS cap_mim_2f0_m4m5_noshield c_width=5u c_length=5u
X1042 a_3540_180844# VSS cap_mim_2f0_m4m5_noshield c_width=5u c_length=5u
X1043 a_3540_180844# VSS cap_mim_2f0_m4m5_noshield c_width=5u c_length=5u
X1044 a_3540_180844# VSS cap_mim_2f0_m4m5_noshield c_width=5u c_length=5u
X1045 a_3540_180844# VSS cap_mim_2f0_m4m5_noshield c_width=5u c_length=5u
X1046 a_3540_180844# VSS cap_mim_2f0_m4m5_noshield c_width=5u c_length=5u
X1047 a_3540_180844# VSS cap_mim_2f0_m4m5_noshield c_width=5u c_length=5u
X1048 a_3540_180844# VSS cap_mim_2f0_m4m5_noshield c_width=5u c_length=5u
X1049 a_3540_180844# VSS cap_mim_2f0_m4m5_noshield c_width=5u c_length=5u
X1050 a_53507_83249# a_43987_62389# VDD VDD pfet_03v3 ad=0.89p pd=4.89u as=0.89p ps=4.89u w=2u l=0.28u
X1051 a_3540_180844# VSS cap_mim_2f0_m4m5_noshield c_width=5u c_length=5u
X1052 a_3540_180844# VSS cap_mim_2f0_m4m5_noshield c_width=5u c_length=5u
X1053 a_3540_180844# VSS cap_mim_2f0_m4m5_noshield c_width=5u c_length=5u
X1054 a_3540_180844# VSS cap_mim_2f0_m4m5_noshield c_width=5u c_length=5u
X1055 a_3540_180844# VSS cap_mim_2f0_m4m5_noshield c_width=5u c_length=5u
X1056 a_3540_180844# VSS cap_mim_2f0_m4m5_noshield c_width=5u c_length=5u
X1057 a_88109_80239# a_36825_105682.t2 a_105420_69640# VSS nfet_03v3 ad=0.89p pd=4.89u as=0.89p ps=4.89u w=2u l=0.28u
X1058 a_3540_180844# VSS cap_mim_2f0_m4m5_noshield c_width=5u c_length=5u
X1059 a_3540_180844# VSS cap_mim_2f0_m4m5_noshield c_width=5u c_length=5u
X1060 a_3540_180844# VSS cap_mim_2f0_m4m5_noshield c_width=5u c_length=5u
X1061 a_3540_180844# VSS cap_mim_2f0_m4m5_noshield c_width=5u c_length=5u
X1062 a_39625_32882# a_29987_37189.t7 a_39625_40940# VDD pfet_03v3 ad=0.89p pd=4.89u as=0.89p ps=4.89u w=2u l=0.28u
X1063 a_3540_180844# VSS cap_mim_2f0_m4m5_noshield c_width=5u c_length=5u
X1064 a_30105_40940# a_29987_33269# VDD VDD pfet_03v3 ad=0.89p pd=4.89u as=0.89p ps=4.89u w=2u l=0.28u
X1065 a_3540_180844# VSS cap_mim_2f0_m4m5_noshield c_width=5u c_length=5u
X1066 a_3540_180844# VSS cap_mim_2f0_m4m5_noshield c_width=5u c_length=5u
X1067 a_3540_180844# VSS cap_mim_2f0_m4m5_noshield c_width=5u c_length=5u
X1068 a_3540_180844# VSS cap_mim_2f0_m4m5_noshield c_width=5u c_length=5u
X1069 a_3540_180844# VSS cap_mim_2f0_m4m5_noshield c_width=5u c_length=5u
X1070 a_3540_180844# VSS cap_mim_2f0_m4m5_noshield c_width=5u c_length=5u
X1071 a_3540_180844# VSS cap_mim_2f0_m4m5_noshield c_width=5u c_length=5u
X1072 a_3540_180844# VSS cap_mim_2f0_m4m5_noshield c_width=5u c_length=5u
X1073 a_3540_180844# VSS cap_mim_2f0_m4m5_noshield c_width=5u c_length=5u
X1074 a_3540_180844# VSS cap_mim_2f0_m4m5_noshield c_width=5u c_length=5u
X1075 a_3540_181966.t7 VSS cap_mim_2f0_m4m5_noshield c_width=5u c_length=5u
X1076 a_3540_181966.t7 VSS cap_mim_2f0_m4m5_noshield c_width=5u c_length=5u
X1077 a_89880_80239# a_30665_105682.t2 a_3540_181966.t0 VDD pfet_03v3 ad=1.06p pd=4.53u as=1.06p ps=4.53u w=4u l=0.28u
X1078 a_3540_180844# VSS cap_mim_2f0_m4m5_noshield c_width=5u c_length=5u
X1079 a_3540_180844# VSS cap_mim_2f0_m4m5_noshield c_width=5u c_length=5u
X1080 a_89421_74820# PB.t17 VDD VDD pfet_03v3 ad=2.12p pd=8.53u as=2.12p ps=8.53u w=8u l=2u
X1081 a_3540_180844# VSS cap_mim_2f0_m4m5_noshield c_width=5u c_length=5u
X1082 a_3540_180844# VSS cap_mim_2f0_m4m5_noshield c_width=5u c_length=5u
X1083 a_3540_180844# VSS cap_mim_2f0_m4m5_noshield c_width=5u c_length=5u
X1084 a_3540_180844# VSS cap_mim_2f0_m4m5_noshield c_width=5u c_length=5u
X1085 a_3540_180844# VSS cap_mim_2f0_m4m5_noshield c_width=5u c_length=5u
X1086 a_3540_180844# VSS cap_mim_2f0_m4m5_noshield c_width=5u c_length=5u
X1087 a_3540_180844# VSS cap_mim_2f0_m4m5_noshield c_width=5u c_length=5u
X1088 a_3540_180844# VSS cap_mim_2f0_m4m5_noshield c_width=5u c_length=5u
X1089 a_3540_180844# VSS cap_mim_2f0_m4m5_noshield c_width=5u c_length=5u
X1090 a_3540_180844# VSS cap_mim_2f0_m4m5_noshield c_width=5u c_length=5u
X1091 a_3540_180844# VSS cap_mim_2f0_m4m5_noshield c_width=5u c_length=5u
X1092 a_3540_180844# VSS cap_mim_2f0_m4m5_noshield c_width=5u c_length=5u
X1093 a_3540_180844# VSS cap_mim_2f0_m4m5_noshield c_width=5u c_length=5u
X1094 a_3540_180844# VSS cap_mim_2f0_m4m5_noshield c_width=5u c_length=5u
X1095 REFIN a_3667_12409# cap_mim_2f0_m4m5_noshield c_width=5u c_length=5u
X1096 a_3540_180844# VSS cap_mim_2f0_m4m5_noshield c_width=5u c_length=5u
X1097 a_3540_180844# VSS cap_mim_2f0_m4m5_noshield c_width=5u c_length=5u
X1098 a_3540_181966.t7 VSS cap_mim_2f0_m4m5_noshield c_width=5u c_length=5u
X1099 a_3540_180844# VSS cap_mim_2f0_m4m5_noshield c_width=5u c_length=5u
X1100 a_3540_180844# VSS cap_mim_2f0_m4m5_noshield c_width=5u c_length=5u
X1101 a_89421_74820# PB.t29 VDD VDD pfet_03v3 ad=2.12p pd=8.53u as=2.12p ps=8.53u w=8u l=2u
X1102 a_3540_180844# VSS cap_mim_2f0_m4m5_noshield c_width=5u c_length=5u
X1103 a_3540_180844# VSS cap_mim_2f0_m4m5_noshield c_width=5u c_length=5u
X1104 a_3540_180844# VSS cap_mim_2f0_m4m5_noshield c_width=5u c_length=5u
X1105 a_3540_180844# VSS cap_mim_2f0_m4m5_noshield c_width=5u c_length=5u
X1106 a_3540_180844# VSS cap_mim_2f0_m4m5_noshield c_width=5u c_length=5u
X1107 a_3540_180844# VSS cap_mim_2f0_m4m5_noshield c_width=5u c_length=5u
X1108 a_3540_180844# VSS cap_mim_2f0_m4m5_noshield c_width=5u c_length=5u
X1109 a_3540_180844# VSS cap_mim_2f0_m4m5_noshield c_width=5u c_length=5u
X1110 a_88109_80239# VSS cap_mim_2f0_m4m5_noshield c_width=5u c_length=5u
X1111 a_3540_180844# VSS cap_mim_2f0_m4m5_noshield c_width=5u c_length=5u
X1112 a_3540_180844# VSS cap_mim_2f0_m4m5_noshield c_width=5u c_length=5u
X1113 a_3540_181966.t7 VSS cap_mim_2f0_m4m5_noshield c_width=5u c_length=5u
X1114 a_88033_80029# a_30665_105682.t6 VSS VSS nfet_03v3 ad=0.445p pd=2.89u as=0.445p ps=2.89u w=1u l=0.28u
X1115 a_3540_181966.t7 VSS cap_mim_2f0_m4m5_noshield c_width=5u c_length=5u
X1116 a_3540_181966.t7 VSS cap_mim_2f0_m4m5_noshield c_width=5u c_length=5u
X1117 a_3540_180844# VSS cap_mim_2f0_m4m5_noshield c_width=5u c_length=5u
X1118 a_3540_180844# VSS cap_mim_2f0_m4m5_noshield c_width=5u c_length=5u
X1119 a_3540_180844# VSS cap_mim_2f0_m4m5_noshield c_width=5u c_length=5u
X1120 a_3540_180844# VSS cap_mim_2f0_m4m5_noshield c_width=5u c_length=5u
X1121 a_3540_180844# VSS cap_mim_2f0_m4m5_noshield c_width=5u c_length=5u
X1122 a_3540_180844# VSS cap_mim_2f0_m4m5_noshield c_width=5u c_length=5u
X1123 a_3540_180844# VSS cap_mim_2f0_m4m5_noshield c_width=5u c_length=5u
X1124 a_3540_180844# VSS cap_mim_2f0_m4m5_noshield c_width=5u c_length=5u
X1125 a_3540_180844# VSS cap_mim_2f0_m4m5_noshield c_width=5u c_length=5u
X1126 a_3540_180844# VSS cap_mim_2f0_m4m5_noshield c_width=5u c_length=5u
X1127 a_3540_180844# VSS cap_mim_2f0_m4m5_noshield c_width=5u c_length=5u
X1128 a_3540_180844# VSS cap_mim_2f0_m4m5_noshield c_width=5u c_length=5u
X1129 a_10260_18186# a_10680_16064# VSS ppolyf_u_1k r_width=1u r_length=10u
X1130 a_3540_180844# VSS cap_mim_2f0_m4m5_noshield c_width=5u c_length=5u
X1131 a_3540_181966.t7 VSS cap_mim_2f0_m4m5_noshield c_width=5u c_length=5u
X1132 a_3540_180844# VSS cap_mim_2f0_m4m5_noshield c_width=5u c_length=5u
X1133 a_3540_180844# VSS cap_mim_2f0_m4m5_noshield c_width=5u c_length=5u
X1134 a_3540_180844# VSS cap_mim_2f0_m4m5_noshield c_width=5u c_length=5u
X1135 a_3540_180844# VSS cap_mim_2f0_m4m5_noshield c_width=5u c_length=5u
X1136 a_61347_33269# a_61347_45729# VDD VDD pfet_03v3 ad=1.335p pd=6.89u as=1.335p ps=6.89u w=3u l=0.28u
X1137 a_3540_180844# VSS cap_mim_2f0_m4m5_noshield c_width=5u c_length=5u
X1138 a_43987_20669# a_31785_19940# VDD VDD pfet_03v3 ad=0.89p pd=4.89u as=0.89p ps=4.89u w=2u l=0.28u
X1139 a_3540_180844# VSS cap_mim_2f0_m4m5_noshield c_width=5u c_length=5u
X1140 a_3540_180844# VSS cap_mim_2f0_m4m5_noshield c_width=5u c_length=5u
X1141 a_29960_36740# a_29987_45729# VSS VSS nfet_03v3 ad=0.6675p pd=3.89u as=0.6675p ps=3.89u w=1.5u l=0.28u
X1142 a_3540_180844# VSS cap_mim_2f0_m4m5_noshield c_width=5u c_length=5u
X1143 a_59640_61800# FB.t4 a_59785_66000# VSS nfet_03v3 ad=1.335p pd=6.89u as=1.335p ps=6.89u w=3u l=0.28u
X1144 a_3540_180844# VSS cap_mim_2f0_m4m5_noshield c_width=5u c_length=5u
X1145 a_3540_180844# VSS cap_mim_2f0_m4m5_noshield c_width=5u c_length=5u
X1146 a_3540_180844# VSS cap_mim_2f0_m4m5_noshield c_width=5u c_length=5u
X1147 a_3540_180844# VSS cap_mim_2f0_m4m5_noshield c_width=5u c_length=5u
X1148 a_3540_180844# VSS cap_mim_2f0_m4m5_noshield c_width=5u c_length=5u
X1149 a_3540_180844# VSS cap_mim_2f0_m4m5_noshield c_width=5u c_length=5u
X1150 a_3540_180844# VSS cap_mim_2f0_m4m5_noshield c_width=5u c_length=5u
X1151 a_3540_180844# VSS cap_mim_2f0_m4m5_noshield c_width=5u c_length=5u
X1152 a_3540_180844# VSS cap_mim_2f0_m4m5_noshield c_width=5u c_length=5u
X1153 a_3540_181966.t7 VSS cap_mim_2f0_m4m5_noshield c_width=5u c_length=5u
X1154 a_3540_180844# VSS cap_mim_2f0_m4m5_noshield c_width=5u c_length=5u
X1155 a_3540_180844# VSS cap_mim_2f0_m4m5_noshield c_width=5u c_length=5u
X1156 a_3540_181966.t7 VSS cap_mim_2f0_m4m5_noshield c_width=5u c_length=5u
X1157 a_3540_180844# VSS cap_mim_2f0_m4m5_noshield c_width=5u c_length=5u
X1158 a_3540_180844# VSS cap_mim_2f0_m4m5_noshield c_width=5u c_length=5u
X1159 a_3540_180844# VSS cap_mim_2f0_m4m5_noshield c_width=5u c_length=5u
X1160 a_3540_180844# VSS cap_mim_2f0_m4m5_noshield c_width=5u c_length=5u
X1161 a_3540_180844# VSS cap_mim_2f0_m4m5_noshield c_width=5u c_length=5u
X1162 a_3540_180844# VSS cap_mim_2f0_m4m5_noshield c_width=5u c_length=5u
X1163 a_3540_180844# VSS cap_mim_2f0_m4m5_noshield c_width=5u c_length=5u
X1164 a_3540_180844# VSS cap_mim_2f0_m4m5_noshield c_width=5u c_length=5u
X1165 a_3540_180844# VSS cap_mim_2f0_m4m5_noshield c_width=5u c_length=5u
X1166 a_3540_180844# VSS cap_mim_2f0_m4m5_noshield c_width=5u c_length=5u
X1167 VDD a_73225_30440# FS VDD pfet_03v3 ad=0.795p pd=3.53u as=0.795p ps=3.53u w=3u l=0.28u
X1168 a_3540_180844# VSS cap_mim_2f0_m4m5_noshield c_width=5u c_length=5u
X1169 a_3540_180844# VSS cap_mim_2f0_m4m5_noshield c_width=5u c_length=5u
X1170 a_3540_180844# VSS cap_mim_2f0_m4m5_noshield c_width=5u c_length=5u
X1171 a_3540_180844# VSS cap_mim_2f0_m4m5_noshield c_width=5u c_length=5u
X1172 a_3540_180844# VSS cap_mim_2f0_m4m5_noshield c_width=5u c_length=5u
X1173 a_3540_180844# VSS cap_mim_2f0_m4m5_noshield c_width=5u c_length=5u
X1174 a_3540_181966.t7 VSS cap_mim_2f0_m4m5_noshield c_width=5u c_length=5u
X1175 a_3540_180844# VSS cap_mim_2f0_m4m5_noshield c_width=5u c_length=5u
X1176 a_3540_181966.t7 VSS cap_mim_2f0_m4m5_noshield c_width=5u c_length=5u
X1177 a_3540_180844# VSS cap_mim_2f0_m4m5_noshield c_width=5u c_length=5u
X1178 a_3540_180844# VSS cap_mim_2f0_m4m5_noshield c_width=5u c_length=5u
X1179 a_3540_180844# VSS cap_mim_2f0_m4m5_noshield c_width=5u c_length=5u
X1180 a_3540_180844# VSS cap_mim_2f0_m4m5_noshield c_width=5u c_length=5u
X1181 a_3540_180844# VSS cap_mim_2f0_m4m5_noshield c_width=5u c_length=5u
X1182 a_3540_180844# VSS cap_mim_2f0_m4m5_noshield c_width=5u c_length=5u
X1183 a_3540_180844# VSS cap_mim_2f0_m4m5_noshield c_width=5u c_length=5u
X1184 a_3540_180844# VSS cap_mim_2f0_m4m5_noshield c_width=5u c_length=5u
X1185 a_3540_180844# VSS cap_mim_2f0_m4m5_noshield c_width=5u c_length=5u
X1186 a_3540_180844# VSS cap_mim_2f0_m4m5_noshield c_width=5u c_length=5u
X1187 a_3540_180844# VSS cap_mim_2f0_m4m5_noshield c_width=5u c_length=5u
X1188 a_3540_180844# VSS cap_mim_2f0_m4m5_noshield c_width=5u c_length=5u
X1189 a_43960_11680# a_43987_20669# VSS VSS nfet_03v3 ad=0.6675p pd=3.89u as=0.6675p ps=3.89u w=1.5u l=0.28u
X1190 a_3540_180844# VSS cap_mim_2f0_m4m5_noshield c_width=5u c_length=5u
X1191 a_3540_180844# VSS cap_mim_2f0_m4m5_noshield c_width=5u c_length=5u
X1192 a_3540_180844# VSS cap_mim_2f0_m4m5_noshield c_width=5u c_length=5u
X1193 a_3540_180844# VSS cap_mim_2f0_m4m5_noshield c_width=5u c_length=5u
X1194 a_3540_180844# VSS cap_mim_2f0_m4m5_noshield c_width=5u c_length=5u
X1195 a_3540_180844# VSS cap_mim_2f0_m4m5_noshield c_width=5u c_length=5u
X1196 a_3540_180844# VSS cap_mim_2f0_m4m5_noshield c_width=5u c_length=5u
X1197 a_3540_181966.t6 VSS cap_mim_2f0_m4m5_noshield c_width=5u c_length=5u
X1198 a_3540_180844# VSS cap_mim_2f0_m4m5_noshield c_width=5u c_length=5u
X1199 a_12185_105682# a_6025_105682# VSS VSS nfet_03v3 ad=0.445p pd=2.89u as=0.445p ps=2.89u w=1u l=0.28u
X1200 a_3540_18186# a_3540_16064# VSS ppolyf_u_1k r_width=1u r_length=10u
X1201 REFIN a_3667_12409# cap_mim_2f0_m4m5_noshield c_width=5u c_length=5u
X1202 a_3540_180844# VSS cap_mim_2f0_m4m5_noshield c_width=5u c_length=5u
X1203 a_3540_180844# VSS cap_mim_2f0_m4m5_noshield c_width=5u c_length=5u
X1204 a_3540_181966.t7 VSS cap_mim_2f0_m4m5_noshield c_width=5u c_length=5u
X1205 a_3540_180844# VSS cap_mim_2f0_m4m5_noshield c_width=5u c_length=5u
X1206 a_3540_180844# VSS cap_mim_2f0_m4m5_noshield c_width=5u c_length=5u
X1207 a_89880_80239# a_88033_80029# a_88109_80239# VDD pfet_03v3 ad=1.78p pd=8.89u as=1.06p ps=4.53u w=4u l=0.28u
X1208 a_3540_180844# VSS cap_mim_2f0_m4m5_noshield c_width=5u c_length=5u
X1209 a_3540_180844# VSS cap_mim_2f0_m4m5_noshield c_width=5u c_length=5u
X1210 a_3540_180844# VSS cap_mim_2f0_m4m5_noshield c_width=5u c_length=5u
X1211 a_3540_180844# VSS cap_mim_2f0_m4m5_noshield c_width=5u c_length=5u
X1212 a_3540_180844# VSS cap_mim_2f0_m4m5_noshield c_width=5u c_length=5u
X1213 a_3540_180844# VSS cap_mim_2f0_m4m5_noshield c_width=5u c_length=5u
X1214 a_3540_180844# VSS cap_mim_2f0_m4m5_noshield c_width=5u c_length=5u
X1215 a_3540_180844# VSS cap_mim_2f0_m4m5_noshield c_width=5u c_length=5u
X1216 a_3540_180844# VSS cap_mim_2f0_m4m5_noshield c_width=5u c_length=5u
X1217 a_3540_180844# VSS cap_mim_2f0_m4m5_noshield c_width=5u c_length=5u
X1218 a_3540_180844# VSS cap_mim_2f0_m4m5_noshield c_width=5u c_length=5u
X1219 a_3540_180844# VSS cap_mim_2f0_m4m5_noshield c_width=5u c_length=5u
X1220 a_3540_180844# VSS cap_mim_2f0_m4m5_noshield c_width=5u c_length=5u
X1221 a_3540_180844# VSS cap_mim_2f0_m4m5_noshield c_width=5u c_length=5u
X1222 a_3540_180844# VSS cap_mim_2f0_m4m5_noshield c_width=5u c_length=5u
X1223 a_3540_180844# VSS cap_mim_2f0_m4m5_noshield c_width=5u c_length=5u
X1224 a_3540_180844# VSS cap_mim_2f0_m4m5_noshield c_width=5u c_length=5u
X1225 a_39625_36740# a_29987_37189.t4 a_39480_36740# VSS nfet_03v3 ad=0.6675p pd=3.89u as=0.6675p ps=3.89u w=1.5u l=0.28u
X1226 a_3540_180844# VSS cap_mim_2f0_m4m5_noshield c_width=5u c_length=5u
X1227 a_3540_180844# VSS cap_mim_2f0_m4m5_noshield c_width=5u c_length=5u
X1228 a_3540_180844# VSS cap_mim_2f0_m4m5_noshield c_width=5u c_length=5u
X1229 a_3540_181966.t7 VSS cap_mim_2f0_m4m5_noshield c_width=5u c_length=5u
X1230 a_3540_180844# VSS cap_mim_2f0_m4m5_noshield c_width=5u c_length=5u
X1231 a_3540_180844# VSS cap_mim_2f0_m4m5_noshield c_width=5u c_length=5u
X1232 a_3540_180844# VSS cap_mim_2f0_m4m5_noshield c_width=5u c_length=5u
X1233 a_3540_180844# VSS cap_mim_2f0_m4m5_noshield c_width=5u c_length=5u
X1234 a_67480_61800# a_15987_66729.t2 VSS VSS nfet_03v3 ad=0.89p pd=4.89u as=0.89p ps=4.89u w=2u l=0.28u
X1235 a_17540_15224# a_17667_11569# VDD VDD pfet_03v3 ad=3.56p pd=16.89u as=3.56p ps=16.89u w=8u l=0.28u
X1236 a_3540_180844# VSS cap_mim_2f0_m4m5_noshield c_width=5u c_length=5u
X1237 a_3540_180844# VSS cap_mim_2f0_m4m5_noshield c_width=5u c_length=5u
X1238 a_3540_180844# VSS cap_mim_2f0_m4m5_noshield c_width=5u c_length=5u
X1239 a_3540_180844# VSS cap_mim_2f0_m4m5_noshield c_width=5u c_length=5u
X1240 a_89421_74820# PB.t7 VDD VDD pfet_03v3 ad=2.12p pd=8.53u as=2.12p ps=8.53u w=8u l=2u
X1241 a_3540_180844# VSS cap_mim_2f0_m4m5_noshield c_width=5u c_length=5u
X1242 a_3540_180844# VSS cap_mim_2f0_m4m5_noshield c_width=5u c_length=5u
X1243 a_3540_180844# VSS cap_mim_2f0_m4m5_noshield c_width=5u c_length=5u
X1244 a_3540_180844# VSS cap_mim_2f0_m4m5_noshield c_width=5u c_length=5u
X1245 a_3540_181966.t7 VSS cap_mim_2f0_m4m5_noshield c_width=5u c_length=5u
X1246 a_3540_180844# VSS cap_mim_2f0_m4m5_noshield c_width=5u c_length=5u
X1247 a_3540_181966.t7 VSS cap_mim_2f0_m4m5_noshield c_width=5u c_length=5u
X1248 a_3540_181966.t7 VSS cap_mim_2f0_m4m5_noshield c_width=5u c_length=5u
X1249 a_3540_180844# VSS cap_mim_2f0_m4m5_noshield c_width=5u c_length=5u
X1250 a_3540_180844# VSS cap_mim_2f0_m4m5_noshield c_width=5u c_length=5u
X1251 a_8265_61800# a_8147_62389# a_8120_61800# VSS nfet_03v3 ad=0.89p pd=4.89u as=0.89p ps=4.89u w=2u l=0.28u
X1252 a_3540_180844# VSS cap_mim_2f0_m4m5_noshield c_width=5u c_length=5u
X1253 a_3540_180844# VSS cap_mim_2f0_m4m5_noshield c_width=5u c_length=5u
X1254 a_88109_80239# VSS cap_mim_2f0_m4m5_noshield c_width=5u c_length=5u
X1255 a_3540_180844# VSS cap_mim_2f0_m4m5_noshield c_width=5u c_length=5u
X1256 a_3540_180844# VSS cap_mim_2f0_m4m5_noshield c_width=5u c_length=5u
X1257 a_3540_180844# VSS cap_mim_2f0_m4m5_noshield c_width=5u c_length=5u
X1258 a_3540_181966.t7 VSS cap_mim_2f0_m4m5_noshield c_width=5u c_length=5u
X1259 a_3540_180844# VSS cap_mim_2f0_m4m5_noshield c_width=5u c_length=5u
X1260 a_3540_180844# VSS cap_mim_2f0_m4m5_noshield c_width=5u c_length=5u
X1261 a_3540_180844# VSS cap_mim_2f0_m4m5_noshield c_width=5u c_length=5u
X1262 a_3540_180844# VSS cap_mim_2f0_m4m5_noshield c_width=5u c_length=5u
X1263 a_3540_180844# VSS cap_mim_2f0_m4m5_noshield c_width=5u c_length=5u
X1264 a_3540_180844# VSS cap_mim_2f0_m4m5_noshield c_width=5u c_length=5u
X1265 a_3540_180844# VSS cap_mim_2f0_m4m5_noshield c_width=5u c_length=5u
X1266 a_3540_180844# VSS cap_mim_2f0_m4m5_noshield c_width=5u c_length=5u
X1267 a_3540_180844# VSS cap_mim_2f0_m4m5_noshield c_width=5u c_length=5u
X1268 a_3540_180844# VSS cap_mim_2f0_m4m5_noshield c_width=5u c_length=5u
X1269 a_3540_180844# VSS cap_mim_2f0_m4m5_noshield c_width=5u c_length=5u
X1270 a_3540_180844# VSS cap_mim_2f0_m4m5_noshield c_width=5u c_length=5u
X1271 a_3540_180844# VSS cap_mim_2f0_m4m5_noshield c_width=5u c_length=5u
X1272 a_3540_181966.t6 VSS cap_mim_2f0_m4m5_noshield c_width=5u c_length=5u
X1273 a_3540_180844# VSS cap_mim_2f0_m4m5_noshield c_width=5u c_length=5u
X1274 a_3540_181966.t7 VSS cap_mim_2f0_m4m5_noshield c_width=5u c_length=5u
X1275 a_3540_180844# VSS cap_mim_2f0_m4m5_noshield c_width=5u c_length=5u
X1276 a_3540_180844# VSS cap_mim_2f0_m4m5_noshield c_width=5u c_length=5u
X1277 a_3540_180844# VSS cap_mim_2f0_m4m5_noshield c_width=5u c_length=5u
X1278 a_3540_180844# VSS cap_mim_2f0_m4m5_noshield c_width=5u c_length=5u
X1279 a_3540_180844# VSS cap_mim_2f0_m4m5_noshield c_width=5u c_length=5u
X1280 a_3540_180844# VSS cap_mim_2f0_m4m5_noshield c_width=5u c_length=5u
X1281 a_3540_180844# VSS cap_mim_2f0_m4m5_noshield c_width=5u c_length=5u
X1282 a_3540_180844# VSS cap_mim_2f0_m4m5_noshield c_width=5u c_length=5u
X1283 a_3540_180844# VSS cap_mim_2f0_m4m5_noshield c_width=5u c_length=5u
X1284 a_3540_180844# VSS cap_mim_2f0_m4m5_noshield c_width=5u c_length=5u
X1285 a_3540_180844# VSS cap_mim_2f0_m4m5_noshield c_width=5u c_length=5u
X1286 a_3540_180844# VSS cap_mim_2f0_m4m5_noshield c_width=5u c_length=5u
X1287 a_3540_180844# VSS cap_mim_2f0_m4m5_noshield c_width=5u c_length=5u
X1288 a_3540_180844# VSS cap_mim_2f0_m4m5_noshield c_width=5u c_length=5u
X1289 a_3540_181966.t7 VSS cap_mim_2f0_m4m5_noshield c_width=5u c_length=5u
X1290 a_3540_180844# VSS cap_mim_2f0_m4m5_noshield c_width=5u c_length=5u
X1291 a_3540_180844# VSS cap_mim_2f0_m4m5_noshield c_width=5u c_length=5u
X1292 a_3540_180844# VSS cap_mim_2f0_m4m5_noshield c_width=5u c_length=5u
X1293 a_3540_180844# VSS cap_mim_2f0_m4m5_noshield c_width=5u c_length=5u
X1294 a_3540_180844# VSS cap_mim_2f0_m4m5_noshield c_width=5u c_length=5u
X1295 a_3540_180844# VSS cap_mim_2f0_m4m5_noshield c_width=5u c_length=5u
X1296 a_3540_180844# VSS cap_mim_2f0_m4m5_noshield c_width=5u c_length=5u
X1297 a_3540_180844# VSS cap_mim_2f0_m4m5_noshield c_width=5u c_length=5u
X1298 a_3540_180844# VSS cap_mim_2f0_m4m5_noshield c_width=5u c_length=5u
X1299 a_88109_80239# VSS cap_mim_2f0_m4m5_noshield c_width=5u c_length=5u
X1300 a_5907_106069.t1 a_36707_106069.t4 VDD VDD pfet_03v3 ad=0.89p pd=4.89u as=0.89p ps=4.89u w=2u l=0.28u
X1301 a_3540_180844# VSS cap_mim_2f0_m4m5_noshield c_width=5u c_length=5u
X1302 a_3540_180844# VSS cap_mim_2f0_m4m5_noshield c_width=5u c_length=5u
X1303 a_3540_180844# VSS cap_mim_2f0_m4m5_noshield c_width=5u c_length=5u
X1304 a_3540_180844# VSS cap_mim_2f0_m4m5_noshield c_width=5u c_length=5u
X1305 a_3540_180844# VSS cap_mim_2f0_m4m5_noshield c_width=5u c_length=5u
X1306 a_3540_180844# VSS cap_mim_2f0_m4m5_noshield c_width=5u c_length=5u
X1307 a_3540_181966.t7 VSS cap_mim_2f0_m4m5_noshield c_width=5u c_length=5u
X1308 a_3540_180844# VSS cap_mim_2f0_m4m5_noshield c_width=5u c_length=5u
X1309 a_3540_181966.t2 a_36707_106069.t6 a_88409_69640# VSS nfet_03v3 ad=0.89p pd=4.89u as=0.89p ps=4.89u w=2u l=0.28u
X1310 a_3540_181966.t7 VSS cap_mim_2f0_m4m5_noshield c_width=5u c_length=5u
X1311 a_3540_180844# VSS cap_mim_2f0_m4m5_noshield c_width=5u c_length=5u
X1312 a_3540_180844# VSS cap_mim_2f0_m4m5_noshield c_width=5u c_length=5u
X1313 a_3540_180844# VSS cap_mim_2f0_m4m5_noshield c_width=5u c_length=5u
X1314 a_3540_180844# VSS cap_mim_2f0_m4m5_noshield c_width=5u c_length=5u
X1315 a_3540_180844# VSS cap_mim_2f0_m4m5_noshield c_width=5u c_length=5u
X1316 a_3540_180844# VSS cap_mim_2f0_m4m5_noshield c_width=5u c_length=5u
X1317 a_3540_180844# VSS cap_mim_2f0_m4m5_noshield c_width=5u c_length=5u
X1318 a_3540_180844# VSS cap_mim_2f0_m4m5_noshield c_width=5u c_length=5u
X1319 a_45785_19940# a_43987_8209# VDD VDD pfet_03v3 ad=0.89p pd=4.89u as=0.89p ps=4.89u w=2u l=0.28u
X1320 a_3540_180844# VSS cap_mim_2f0_m4m5_noshield c_width=5u c_length=5u
X1321 a_3540_180844# VSS cap_mim_2f0_m4m5_noshield c_width=5u c_length=5u
X1322 a_3540_180844# VSS cap_mim_2f0_m4m5_noshield c_width=5u c_length=5u
X1323 a_3540_180844# VSS cap_mim_2f0_m4m5_noshield c_width=5u c_length=5u
X1324 a_3540_180844# VSS cap_mim_2f0_m4m5_noshield c_width=5u c_length=5u
X1325 a_3540_180844# VSS cap_mim_2f0_m4m5_noshield c_width=5u c_length=5u
X1326 a_3540_180844# VSS cap_mim_2f0_m4m5_noshield c_width=5u c_length=5u
X1327 a_3540_180844# VSS cap_mim_2f0_m4m5_noshield c_width=5u c_length=5u
X1328 a_3540_180844# VSS cap_mim_2f0_m4m5_noshield c_width=5u c_length=5u
X1329 a_3540_180844# VSS cap_mim_2f0_m4m5_noshield c_width=5u c_length=5u
X1330 a_3540_180844# VSS cap_mim_2f0_m4m5_noshield c_width=5u c_length=5u
X1331 a_3540_180844# VSS cap_mim_2f0_m4m5_noshield c_width=5u c_length=5u
X1332 a_45785_19940# a_43987_8209# VSS VSS nfet_03v3 ad=0.445p pd=2.89u as=0.445p ps=2.89u w=1u l=0.28u
X1333 a_3540_181966.t7 VSS cap_mim_2f0_m4m5_noshield c_width=5u c_length=5u
X1334 a_3540_180844# VSS cap_mim_2f0_m4m5_noshield c_width=5u c_length=5u
X1335 a_3540_180844# VSS cap_mim_2f0_m4m5_noshield c_width=5u c_length=5u
X1336 a_3540_180844# VSS cap_mim_2f0_m4m5_noshield c_width=5u c_length=5u
X1337 a_3540_180844# VSS cap_mim_2f0_m4m5_noshield c_width=5u c_length=5u
X1338 a_3540_180844# VSS cap_mim_2f0_m4m5_noshield c_width=5u c_length=5u
X1339 a_3540_180844# VSS cap_mim_2f0_m4m5_noshield c_width=5u c_length=5u
X1340 a_3540_180844# VSS cap_mim_2f0_m4m5_noshield c_width=5u c_length=5u
X1341 a_3540_180844# VSS cap_mim_2f0_m4m5_noshield c_width=5u c_length=5u
X1342 a_3540_180844# VSS cap_mim_2f0_m4m5_noshield c_width=5u c_length=5u
X1343 a_3540_180844# VSS cap_mim_2f0_m4m5_noshield c_width=5u c_length=5u
X1344 a_3540_181966.t7 VSS cap_mim_2f0_m4m5_noshield c_width=5u c_length=5u
X1345 a_3540_180844# VSS cap_mim_2f0_m4m5_noshield c_width=5u c_length=5u
X1346 a_6060_18186# a_6480_16064# VSS ppolyf_u_1k r_width=1u r_length=10u
X1347 a_3540_180844# VSS cap_mim_2f0_m4m5_noshield c_width=5u c_length=5u
X1348 a_3540_180844# VSS cap_mim_2f0_m4m5_noshield c_width=5u c_length=5u
X1349 a_3540_180844# VSS cap_mim_2f0_m4m5_noshield c_width=5u c_length=5u
X1350 a_88409_69640# NB.t1 VSS VSS nfet_03v3 ad=2.12p pd=8.53u as=2.12p ps=8.53u w=8u l=2u
X1351 a_3540_180844# VSS cap_mim_2f0_m4m5_noshield c_width=5u c_length=5u
X1352 a_3540_180844# VSS cap_mim_2f0_m4m5_noshield c_width=5u c_length=5u
X1353 a_3540_180844# VSS cap_mim_2f0_m4m5_noshield c_width=5u c_length=5u
X1354 a_3540_180844# VSS cap_mim_2f0_m4m5_noshield c_width=5u c_length=5u
X1355 a_29987_8209# a_19465_10700# a_29960_11680# VSS nfet_03v3 ad=0.6675p pd=3.89u as=0.6675p ps=3.89u w=1.5u l=0.28u
X1356 a_3540_180844# VSS cap_mim_2f0_m4m5_noshield c_width=5u c_length=5u
X1357 a_3540_180844# VSS cap_mim_2f0_m4m5_noshield c_width=5u c_length=5u
X1358 a_43987_62389# a_15987_66729.t4 VDD VDD pfet_03v3 ad=0.89p pd=4.89u as=0.89p ps=4.89u w=2u l=0.28u
X1359 VSS NB.t6 a_89421_69640# VSS nfet_03v3 ad=2.12p pd=8.53u as=2.12p ps=8.53u w=8u l=2u
X1360 a_3540_180844# VSS cap_mim_2f0_m4m5_noshield c_width=5u c_length=5u
X1361 a_3540_180844# VSS cap_mim_2f0_m4m5_noshield c_width=5u c_length=5u
X1362 a_3540_180844# VSS cap_mim_2f0_m4m5_noshield c_width=5u c_length=5u
X1363 VCTRL.t1 VSS cap_mim_2f0_m4m5_noshield c_width=5u c_length=5u
X1364 a_3540_180844# VSS cap_mim_2f0_m4m5_noshield c_width=5u c_length=5u
X1365 a_3540_180844# VSS cap_mim_2f0_m4m5_noshield c_width=5u c_length=5u
X1366 a_3540_180844# VSS cap_mim_2f0_m4m5_noshield c_width=5u c_length=5u
X1367 a_3540_180844# VSS cap_mim_2f0_m4m5_noshield c_width=5u c_length=5u
X1368 REFIN a_3667_12409# cap_mim_2f0_m4m5_noshield c_width=5u c_length=5u
X1369 a_3540_180844# VSS cap_mim_2f0_m4m5_noshield c_width=5u c_length=5u
X1370 a_3540_181966.t7 VSS cap_mim_2f0_m4m5_noshield c_width=5u c_length=5u
X1371 a_3540_180844# VSS cap_mim_2f0_m4m5_noshield c_width=5u c_length=5u
X1372 a_3540_181966.t7 VSS cap_mim_2f0_m4m5_noshield c_width=5u c_length=5u
X1373 a_8265_61800# a_8147_62389# VDD VDD pfet_03v3 ad=0.89p pd=4.89u as=0.89p ps=4.89u w=2u l=0.28u
X1374 a_3540_180844# VSS cap_mim_2f0_m4m5_noshield c_width=5u c_length=5u
X1375 a_3540_180844# VSS cap_mim_2f0_m4m5_noshield c_width=5u c_length=5u
X1376 a_3540_180844# VSS cap_mim_2f0_m4m5_noshield c_width=5u c_length=5u
X1377 a_3540_180844# VSS cap_mim_2f0_m4m5_noshield c_width=5u c_length=5u
X1378 a_3540_180844# VSS cap_mim_2f0_m4m5_noshield c_width=5u c_length=5u
X1379 a_3540_180844# VSS cap_mim_2f0_m4m5_noshield c_width=5u c_length=5u
X1380 a_3540_180844# VSS cap_mim_2f0_m4m5_noshield c_width=5u c_length=5u
X1381 a_3540_180844# VSS cap_mim_2f0_m4m5_noshield c_width=5u c_length=5u
X1382 a_3540_180844# VSS cap_mim_2f0_m4m5_noshield c_width=5u c_length=5u
X1383 a_3540_180844# VSS cap_mim_2f0_m4m5_noshield c_width=5u c_length=5u
X1384 a_3540_180844# VSS cap_mim_2f0_m4m5_noshield c_width=5u c_length=5u
X1385 a_3540_180844# VSS cap_mim_2f0_m4m5_noshield c_width=5u c_length=5u
X1386 a_3540_180844# VSS cap_mim_2f0_m4m5_noshield c_width=5u c_length=5u
X1387 a_3540_180844# VSS cap_mim_2f0_m4m5_noshield c_width=5u c_length=5u
X1388 a_3540_180844# VSS cap_mim_2f0_m4m5_noshield c_width=5u c_length=5u
X1389 a_3540_180844# VSS cap_mim_2f0_m4m5_noshield c_width=5u c_length=5u
X1390 a_3540_180844# VSS cap_mim_2f0_m4m5_noshield c_width=5u c_length=5u
X1391 a_3540_180844# VSS cap_mim_2f0_m4m5_noshield c_width=5u c_length=5u
X1392 a_3540_180844# VSS cap_mim_2f0_m4m5_noshield c_width=5u c_length=5u
X1393 a_3540_180844# VSS cap_mim_2f0_m4m5_noshield c_width=5u c_length=5u
X1394 a_3540_180844# VSS cap_mim_2f0_m4m5_noshield c_width=5u c_length=5u
X1395 a_3540_180844# VSS cap_mim_2f0_m4m5_noshield c_width=5u c_length=5u
X1396 a_3540_180844# VSS cap_mim_2f0_m4m5_noshield c_width=5u c_length=5u
X1397 a_3540_180844# VSS cap_mim_2f0_m4m5_noshield c_width=5u c_length=5u
X1398 a_3540_180844# VSS cap_mim_2f0_m4m5_noshield c_width=5u c_length=5u
X1399 VDD PB.t12 a_87640_80239# VDD pfet_03v3 ad=2.12p pd=8.53u as=2.12p ps=8.53u w=8u l=2u
X1400 a_15960_61800# REFCK.t3 a_16105_66000# VSS nfet_03v3 ad=1.335p pd=6.89u as=1.335p ps=6.89u w=3u l=0.28u
X1401 a_3540_180844# VSS cap_mim_2f0_m4m5_noshield c_width=5u c_length=5u
X1402 a_3540_180844# VSS cap_mim_2f0_m4m5_noshield c_width=5u c_length=5u
X1403 a_3540_180844# VSS cap_mim_2f0_m4m5_noshield c_width=5u c_length=5u
X1404 a_3540_180844# VSS cap_mim_2f0_m4m5_noshield c_width=5u c_length=5u
X1405 a_3540_180844# VSS cap_mim_2f0_m4m5_noshield c_width=5u c_length=5u
X1406 a_29987_20669# a_30105_7822# a_31640_7480# VSS nfet_03v3 ad=0.6675p pd=3.89u as=0.6675p ps=3.89u w=1.5u l=0.28u
X1407 a_3540_180844# VSS cap_mim_2f0_m4m5_noshield c_width=5u c_length=5u
X1408 a_3540_180844# VSS cap_mim_2f0_m4m5_noshield c_width=5u c_length=5u
X1409 a_3540_180844# VSS cap_mim_2f0_m4m5_noshield c_width=5u c_length=5u
X1410 a_53507_83249# FB.t6 VDD VDD pfet_03v3 ad=0.89p pd=4.89u as=0.89p ps=4.89u w=2u l=0.28u
X1411 a_3540_180844# VSS cap_mim_2f0_m4m5_noshield c_width=5u c_length=5u
X1412 a_3540_180844# VSS cap_mim_2f0_m4m5_noshield c_width=5u c_length=5u
X1413 a_3540_180844# VSS cap_mim_2f0_m4m5_noshield c_width=5u c_length=5u
X1414 a_3540_180844# VSS cap_mim_2f0_m4m5_noshield c_width=5u c_length=5u
X1415 a_3540_180844# VSS cap_mim_2f0_m4m5_noshield c_width=5u c_length=5u
X1416 a_3540_180844# VSS cap_mim_2f0_m4m5_noshield c_width=5u c_length=5u
X1417 a_3540_180844# VSS cap_mim_2f0_m4m5_noshield c_width=5u c_length=5u
X1418 a_3540_180844# VSS cap_mim_2f0_m4m5_noshield c_width=5u c_length=5u
X1419 a_3540_180844# VSS cap_mim_2f0_m4m5_noshield c_width=5u c_length=5u
X1420 a_3540_180844# VSS cap_mim_2f0_m4m5_noshield c_width=5u c_length=5u
X1421 a_3540_180844# VSS cap_mim_2f0_m4m5_noshield c_width=5u c_length=5u
X1422 a_3540_180844# VSS cap_mim_2f0_m4m5_noshield c_width=5u c_length=5u
X1423 a_3540_180844# VSS cap_mim_2f0_m4m5_noshield c_width=5u c_length=5u
X1424 a_3540_180844# VSS cap_mim_2f0_m4m5_noshield c_width=5u c_length=5u
X1425 a_3540_180844# VSS cap_mim_2f0_m4m5_noshield c_width=5u c_length=5u
X1426 a_3540_180844# VSS cap_mim_2f0_m4m5_noshield c_width=5u c_length=5u
X1427 a_87640_80239# PB.t31 VDD VDD pfet_03v3 ad=2.12p pd=8.53u as=3.56p ps=16.89u w=8u l=2u
X1428 a_3540_180844# VSS cap_mim_2f0_m4m5_noshield c_width=5u c_length=5u
X1429 a_3540_180844# VSS cap_mim_2f0_m4m5_noshield c_width=5u c_length=5u
X1430 a_3540_180844# VSS cap_mim_2f0_m4m5_noshield c_width=5u c_length=5u
X1431 a_3540_180844# VSS cap_mim_2f0_m4m5_noshield c_width=5u c_length=5u
X1432 a_3540_180844# VSS cap_mim_2f0_m4m5_noshield c_width=5u c_length=5u
X1433 a_3540_180844# VSS cap_mim_2f0_m4m5_noshield c_width=5u c_length=5u
X1434 a_3540_180844# VSS cap_mim_2f0_m4m5_noshield c_width=5u c_length=5u
X1435 VCTRL.t1 VSS cap_mim_2f0_m4m5_noshield c_width=5u c_length=5u
X1436 a_3540_180844# VSS cap_mim_2f0_m4m5_noshield c_width=5u c_length=5u
X1437 a_3540_180844# VSS cap_mim_2f0_m4m5_noshield c_width=5u c_length=5u
X1438 a_3540_180844# VSS cap_mim_2f0_m4m5_noshield c_width=5u c_length=5u
X1439 a_3540_180844# VSS cap_mim_2f0_m4m5_noshield c_width=5u c_length=5u
X1440 a_3540_180844# VSS cap_mim_2f0_m4m5_noshield c_width=5u c_length=5u
X1441 a_3540_180844# VSS cap_mim_2f0_m4m5_noshield c_width=5u c_length=5u
X1442 a_3540_181966.t7 VSS cap_mim_2f0_m4m5_noshield c_width=5u c_length=5u
X1443 a_3540_180844# VSS cap_mim_2f0_m4m5_noshield c_width=5u c_length=5u
X1444 a_3540_181966.t7 VSS cap_mim_2f0_m4m5_noshield c_width=5u c_length=5u
X1445 a_3540_180844# VSS cap_mim_2f0_m4m5_noshield c_width=5u c_length=5u
X1446 a_3540_180844# VSS cap_mim_2f0_m4m5_noshield c_width=5u c_length=5u
X1447 a_3540_180844# VSS cap_mim_2f0_m4m5_noshield c_width=5u c_length=5u
X1448 a_3540_180844# VSS cap_mim_2f0_m4m5_noshield c_width=5u c_length=5u
X1449 a_3540_180844# VSS cap_mim_2f0_m4m5_noshield c_width=5u c_length=5u
X1450 a_3540_180844# VSS cap_mim_2f0_m4m5_noshield c_width=5u c_length=5u
X1451 a_88109_80239# VSS cap_mim_2f0_m4m5_noshield c_width=5u c_length=5u
X1452 a_3540_180844# VSS cap_mim_2f0_m4m5_noshield c_width=5u c_length=5u
X1453 a_3540_180844# VSS cap_mim_2f0_m4m5_noshield c_width=5u c_length=5u
X1454 a_3540_180844# VSS cap_mim_2f0_m4m5_noshield c_width=5u c_length=5u
X1455 a_3540_180844# VSS cap_mim_2f0_m4m5_noshield c_width=5u c_length=5u
X1456 a_3540_180844# VSS cap_mim_2f0_m4m5_noshield c_width=5u c_length=5u
X1457 a_3540_180844# VSS cap_mim_2f0_m4m5_noshield c_width=5u c_length=5u
X1458 a_3540_180844# VSS cap_mim_2f0_m4m5_noshield c_width=5u c_length=5u
X1459 a_3540_180844# VSS cap_mim_2f0_m4m5_noshield c_width=5u c_length=5u
X1460 a_3540_180844# VSS cap_mim_2f0_m4m5_noshield c_width=5u c_length=5u
X1461 a_3540_180844# VSS cap_mim_2f0_m4m5_noshield c_width=5u c_length=5u
X1462 a_3540_180844# VSS cap_mim_2f0_m4m5_noshield c_width=5u c_length=5u
X1463 a_3540_180844# VSS cap_mim_2f0_m4m5_noshield c_width=5u c_length=5u
X1464 a_3540_180844# VSS cap_mim_2f0_m4m5_noshield c_width=5u c_length=5u
X1465 a_3540_180844# VSS cap_mim_2f0_m4m5_noshield c_width=5u c_length=5u
X1466 a_3540_180844# VSS cap_mim_2f0_m4m5_noshield c_width=5u c_length=5u
X1467 a_3540_181966.t7 VSS cap_mim_2f0_m4m5_noshield c_width=5u c_length=5u
X1468 a_3540_180844# VSS cap_mim_2f0_m4m5_noshield c_width=5u c_length=5u
X1469 a_3540_180844# VSS cap_mim_2f0_m4m5_noshield c_width=5u c_length=5u
X1470 a_3540_180844# VSS cap_mim_2f0_m4m5_noshield c_width=5u c_length=5u
X1471 a_3540_180844# VSS cap_mim_2f0_m4m5_noshield c_width=5u c_length=5u
X1472 a_3540_180844# VSS cap_mim_2f0_m4m5_noshield c_width=5u c_length=5u
X1473 a_3540_180844# VSS cap_mim_2f0_m4m5_noshield c_width=5u c_length=5u
X1474 a_3540_180844# VSS cap_mim_2f0_m4m5_noshield c_width=5u c_length=5u
X1475 a_3540_180844# VSS cap_mim_2f0_m4m5_noshield c_width=5u c_length=5u
X1476 a_3540_180844# VSS cap_mim_2f0_m4m5_noshield c_width=5u c_length=5u
X1477 a_3540_180844# VSS cap_mim_2f0_m4m5_noshield c_width=5u c_length=5u
X1478 a_3540_180844# VSS cap_mim_2f0_m4m5_noshield c_width=5u c_length=5u
X1479 a_3540_180844# VSS cap_mim_2f0_m4m5_noshield c_width=5u c_length=5u
X1480 a_3540_180844# VSS cap_mim_2f0_m4m5_noshield c_width=5u c_length=5u
X1481 a_3540_180844# VSS cap_mim_2f0_m4m5_noshield c_width=5u c_length=5u
X1482 a_3540_180844# VSS cap_mim_2f0_m4m5_noshield c_width=5u c_length=5u
X1483 a_3540_180844# VSS cap_mim_2f0_m4m5_noshield c_width=5u c_length=5u
X1484 a_3540_180844# VSS cap_mim_2f0_m4m5_noshield c_width=5u c_length=5u
X1485 a_3540_180844# VSS cap_mim_2f0_m4m5_noshield c_width=5u c_length=5u
X1486 a_3540_180844# VSS cap_mim_2f0_m4m5_noshield c_width=5u c_length=5u
X1487 a_29987_8209# a_29987_20669# VDD VDD pfet_03v3 ad=1.335p pd=6.89u as=1.335p ps=6.89u w=3u l=0.28u
X1488 a_3540_180844# VSS cap_mim_2f0_m4m5_noshield c_width=5u c_length=5u
X1489 a_3540_181966.t7 VSS cap_mim_2f0_m4m5_noshield c_width=5u c_length=5u
X1490 a_3540_180844# VSS cap_mim_2f0_m4m5_noshield c_width=5u c_length=5u
X1491 a_3540_180844# VSS cap_mim_2f0_m4m5_noshield c_width=5u c_length=5u
X1492 a_3540_180844# VSS cap_mim_2f0_m4m5_noshield c_width=5u c_length=5u
X1493 a_3540_180844# VSS cap_mim_2f0_m4m5_noshield c_width=5u c_length=5u
X1494 a_45667_83109# a_36707_106069.t7 a_51800_82520# VSS nfet_03v3 ad=1.335p pd=6.89u as=1.335p ps=6.89u w=3u l=0.28u
X1495 a_3540_180844# VSS cap_mim_2f0_m4m5_noshield c_width=5u c_length=5u
X1496 a_3540_180844# VSS cap_mim_2f0_m4m5_noshield c_width=5u c_length=5u
X1497 a_3540_180844# VSS cap_mim_2f0_m4m5_noshield c_width=5u c_length=5u
X1498 a_3540_180844# VSS cap_mim_2f0_m4m5_noshield c_width=5u c_length=5u
X1499 a_3540_181966.t7 VSS cap_mim_2f0_m4m5_noshield c_width=5u c_length=5u
X1500 a_3540_180844# VSS cap_mim_2f0_m4m5_noshield c_width=5u c_length=5u
X1501 a_23945_66000# a_8147_62389# VSS VSS nfet_03v3 ad=1.335p pd=6.89u as=1.335p ps=6.89u w=3u l=0.28u
X1502 a_3540_180844# VSS cap_mim_2f0_m4m5_noshield c_width=5u c_length=5u
X1503 a_3540_180844# VSS cap_mim_2f0_m4m5_noshield c_width=5u c_length=5u
X1504 a_3540_180844# VSS cap_mim_2f0_m4m5_noshield c_width=5u c_length=5u
X1505 a_3540_180844# VSS cap_mim_2f0_m4m5_noshield c_width=5u c_length=5u
X1506 a_3540_180844# VSS cap_mim_2f0_m4m5_noshield c_width=5u c_length=5u
X1507 a_3540_181966.t7 VSS cap_mim_2f0_m4m5_noshield c_width=5u c_length=5u
X1508 a_3540_180844# VSS cap_mim_2f0_m4m5_noshield c_width=5u c_length=5u
X1509 a_3540_180844# VSS cap_mim_2f0_m4m5_noshield c_width=5u c_length=5u
X1510 a_3540_180844# VSS cap_mim_2f0_m4m5_noshield c_width=5u c_length=5u
X1511 a_3540_180844# VSS cap_mim_2f0_m4m5_noshield c_width=5u c_length=5u
X1512 a_3540_180844# VSS cap_mim_2f0_m4m5_noshield c_width=5u c_length=5u
X1513 a_3540_180844# VSS cap_mim_2f0_m4m5_noshield c_width=5u c_length=5u
X1514 a_3540_180844# VSS cap_mim_2f0_m4m5_noshield c_width=5u c_length=5u
X1515 a_3540_180844# VSS cap_mim_2f0_m4m5_noshield c_width=5u c_length=5u
X1516 a_57960_11680# a_57987_20669# VSS VSS nfet_03v3 ad=0.6675p pd=3.89u as=0.6675p ps=3.89u w=1.5u l=0.28u
X1517 a_3540_180844# VSS cap_mim_2f0_m4m5_noshield c_width=5u c_length=5u
X1518 a_3540_181966.t7 VSS cap_mim_2f0_m4m5_noshield c_width=5u c_length=5u
X1519 a_3540_180844# VSS cap_mim_2f0_m4m5_noshield c_width=5u c_length=5u
X1520 a_3540_180844# VSS cap_mim_2f0_m4m5_noshield c_width=5u c_length=5u
X1521 a_3540_180844# VSS cap_mim_2f0_m4m5_noshield c_width=5u c_length=5u
X1522 a_3540_180844# VSS cap_mim_2f0_m4m5_noshield c_width=5u c_length=5u
X1523 a_3540_180844# VSS cap_mim_2f0_m4m5_noshield c_width=5u c_length=5u
X1524 a_3540_180844# VSS cap_mim_2f0_m4m5_noshield c_width=5u c_length=5u
X1525 a_3540_180844# VSS cap_mim_2f0_m4m5_noshield c_width=5u c_length=5u
X1526 a_3540_180844# VSS cap_mim_2f0_m4m5_noshield c_width=5u c_length=5u
X1527 a_3540_180844# VSS cap_mim_2f0_m4m5_noshield c_width=5u c_length=5u
X1528 a_3540_180844# VSS cap_mim_2f0_m4m5_noshield c_width=5u c_length=5u
X1529 a_3540_180844# VSS cap_mim_2f0_m4m5_noshield c_width=5u c_length=5u
X1530 a_3540_180844# VSS cap_mim_2f0_m4m5_noshield c_width=5u c_length=5u
X1531 a_3540_180844# VSS cap_mim_2f0_m4m5_noshield c_width=5u c_length=5u
X1532 a_3540_180844# VSS cap_mim_2f0_m4m5_noshield c_width=5u c_length=5u
X1533 a_3540_180844# VSS cap_mim_2f0_m4m5_noshield c_width=5u c_length=5u
X1534 a_3540_180844# VSS cap_mim_2f0_m4m5_noshield c_width=5u c_length=5u
X1535 a_16105_86720# a_15987_66729.t11 VSS VSS nfet_03v3 ad=1.335p pd=6.89u as=1.335p ps=6.89u w=3u l=0.28u
X1536 a_3540_181966.t7 VSS cap_mim_2f0_m4m5_noshield c_width=5u c_length=5u
X1537 a_3540_180844# VSS cap_mim_2f0_m4m5_noshield c_width=5u c_length=5u
X1538 FS a_73225_30440# VSS VSS nfet_03v3 ad=0.795p pd=3.53u as=1.335p ps=6.89u w=3u l=0.28u
X1539 a_3540_180844# VSS cap_mim_2f0_m4m5_noshield c_width=5u c_length=5u
X1540 a_3540_181966.t7 VSS cap_mim_2f0_m4m5_noshield c_width=5u c_length=5u
X1541 a_3540_180844# VSS cap_mim_2f0_m4m5_noshield c_width=5u c_length=5u
X1542 a_3540_180844# VSS cap_mim_2f0_m4m5_noshield c_width=5u c_length=5u
X1543 a_3540_180844# VSS cap_mim_2f0_m4m5_noshield c_width=5u c_length=5u
X1544 a_3540_180844# VSS cap_mim_2f0_m4m5_noshield c_width=5u c_length=5u
X1545 a_3540_180844# VSS cap_mim_2f0_m4m5_noshield c_width=5u c_length=5u
X1546 REFIN a_3667_12409# cap_mim_2f0_m4m5_noshield c_width=5u c_length=5u
X1547 a_3540_180844# VSS cap_mim_2f0_m4m5_noshield c_width=5u c_length=5u
X1548 a_3540_180844# VSS cap_mim_2f0_m4m5_noshield c_width=5u c_length=5u
X1549 a_3540_180844# VSS cap_mim_2f0_m4m5_noshield c_width=5u c_length=5u
X1550 a_3540_180844# VSS cap_mim_2f0_m4m5_noshield c_width=5u c_length=5u
X1551 a_3540_180844# VSS cap_mim_2f0_m4m5_noshield c_width=5u c_length=5u
X1552 a_3540_180844# VSS cap_mim_2f0_m4m5_noshield c_width=5u c_length=5u
X1553 a_3540_180844# VSS cap_mim_2f0_m4m5_noshield c_width=5u c_length=5u
X1554 a_3540_180844# VSS cap_mim_2f0_m4m5_noshield c_width=5u c_length=5u
X1555 a_3540_180844# VSS cap_mim_2f0_m4m5_noshield c_width=5u c_length=5u
X1556 a_3540_180844# VSS cap_mim_2f0_m4m5_noshield c_width=5u c_length=5u
X1557 a_3540_180844# VSS cap_mim_2f0_m4m5_noshield c_width=5u c_length=5u
X1558 VCTRL.t1 VSS cap_mim_2f0_m4m5_noshield c_width=5u c_length=5u
X1559 a_3540_180844# VSS cap_mim_2f0_m4m5_noshield c_width=5u c_length=5u
X1560 a_3540_180844# VSS cap_mim_2f0_m4m5_noshield c_width=5u c_length=5u
X1561 a_3540_181966.t7 VSS cap_mim_2f0_m4m5_noshield c_width=5u c_length=5u
X1562 a_3540_181966.t7 VSS cap_mim_2f0_m4m5_noshield c_width=5u c_length=5u
X1563 FB.t0 a_61347_33269# VSS VSS nfet_03v3 ad=0.445p pd=2.89u as=0.445p ps=2.89u w=1u l=0.28u
X1564 a_3540_180844# VSS cap_mim_2f0_m4m5_noshield c_width=5u c_length=5u
X1565 a_3540_180844# VSS cap_mim_2f0_m4m5_noshield c_width=5u c_length=5u
X1566 a_3540_180844# VSS cap_mim_2f0_m4m5_noshield c_width=5u c_length=5u
X1567 a_3540_180844# VSS cap_mim_2f0_m4m5_noshield c_width=5u c_length=5u
X1568 a_3540_180844# VSS cap_mim_2f0_m4m5_noshield c_width=5u c_length=5u
X1569 a_59785_66000# a_43987_62389# VSS VSS nfet_03v3 ad=1.335p pd=6.89u as=1.335p ps=6.89u w=3u l=0.28u
X1570 a_3540_180844# VSS cap_mim_2f0_m4m5_noshield c_width=5u c_length=5u
X1571 a_3540_180844# VSS cap_mim_2f0_m4m5_noshield c_width=5u c_length=5u
X1572 a_3540_180844# VSS cap_mim_2f0_m4m5_noshield c_width=5u c_length=5u
X1573 a_3540_180844# VSS cap_mim_2f0_m4m5_noshield c_width=5u c_length=5u
X1574 a_3540_180844# VSS cap_mim_2f0_m4m5_noshield c_width=5u c_length=5u
X1575 a_3540_180844# VSS cap_mim_2f0_m4m5_noshield c_width=5u c_length=5u
X1576 a_3540_180844# VSS cap_mim_2f0_m4m5_noshield c_width=5u c_length=5u
X1577 a_3540_180844# VSS cap_mim_2f0_m4m5_noshield c_width=5u c_length=5u
X1578 a_3540_181966.t7 VSS cap_mim_2f0_m4m5_noshield c_width=5u c_length=5u
X1579 a_3540_180844# VSS cap_mim_2f0_m4m5_noshield c_width=5u c_length=5u
X1580 a_3540_181966.t7 VSS cap_mim_2f0_m4m5_noshield c_width=5u c_length=5u
X1581 a_3540_180844# VSS cap_mim_2f0_m4m5_noshield c_width=5u c_length=5u
X1582 a_3540_180844# VSS cap_mim_2f0_m4m5_noshield c_width=5u c_length=5u
X1583 a_3540_180844# VSS cap_mim_2f0_m4m5_noshield c_width=5u c_length=5u
X1584 a_3540_181966.t7 VSS cap_mim_2f0_m4m5_noshield c_width=5u c_length=5u
X1585 a_3540_180844# VSS cap_mim_2f0_m4m5_noshield c_width=5u c_length=5u
X1586 a_3540_180844# VSS cap_mim_2f0_m4m5_noshield c_width=5u c_length=5u
X1587 a_3540_180844# VSS cap_mim_2f0_m4m5_noshield c_width=5u c_length=5u
X1588 a_3540_180844# VSS cap_mim_2f0_m4m5_noshield c_width=5u c_length=5u
X1589 a_3540_180844# VSS cap_mim_2f0_m4m5_noshield c_width=5u c_length=5u
X1590 a_88109_80239# VSS cap_mim_2f0_m4m5_noshield c_width=5u c_length=5u
X1591 a_3540_180844# VSS cap_mim_2f0_m4m5_noshield c_width=5u c_length=5u
X1592 a_3540_180844# VSS cap_mim_2f0_m4m5_noshield c_width=5u c_length=5u
X1593 a_3540_180844# VSS cap_mim_2f0_m4m5_noshield c_width=5u c_length=5u
X1594 a_3540_180844# VSS cap_mim_2f0_m4m5_noshield c_width=5u c_length=5u
X1595 a_3540_180844# VSS cap_mim_2f0_m4m5_noshield c_width=5u c_length=5u
X1596 a_3540_180844# VSS cap_mim_2f0_m4m5_noshield c_width=5u c_length=5u
X1597 a_3540_180844# VSS cap_mim_2f0_m4m5_noshield c_width=5u c_length=5u
X1598 a_3540_180844# VSS cap_mim_2f0_m4m5_noshield c_width=5u c_length=5u
X1599 a_8120_82520# a_9827_83109# VSS VSS nfet_03v3 ad=0.89p pd=4.89u as=0.89p ps=4.89u w=2u l=0.28u
X1600 a_3540_180844# VSS cap_mim_2f0_m4m5_noshield c_width=5u c_length=5u
X1601 VCTRL.t1 VSS cap_mim_2f0_m4m5_noshield c_width=5u c_length=5u
X1602 a_3540_180844# VSS cap_mim_2f0_m4m5_noshield c_width=5u c_length=5u
X1603 a_3540_180844# VSS cap_mim_2f0_m4m5_noshield c_width=5u c_length=5u
X1604 a_3540_180844# VSS cap_mim_2f0_m4m5_noshield c_width=5u c_length=5u
X1605 a_3540_180844# VSS cap_mim_2f0_m4m5_noshield c_width=5u c_length=5u
X1606 a_3540_180844# VSS cap_mim_2f0_m4m5_noshield c_width=5u c_length=5u
X1607 a_3540_180844# VSS cap_mim_2f0_m4m5_noshield c_width=5u c_length=5u
X1608 a_3540_180844# VSS cap_mim_2f0_m4m5_noshield c_width=5u c_length=5u
X1609 a_3540_180844# VSS cap_mim_2f0_m4m5_noshield c_width=5u c_length=5u
X1610 a_3540_180844# VSS cap_mim_2f0_m4m5_noshield c_width=5u c_length=5u
X1611 a_3540_180844# VSS cap_mim_2f0_m4m5_noshield c_width=5u c_length=5u
X1612 a_3540_181966.t7 VSS cap_mim_2f0_m4m5_noshield c_width=5u c_length=5u
X1613 a_3540_180844# VSS cap_mim_2f0_m4m5_noshield c_width=5u c_length=5u
X1614 a_3540_180844# VSS cap_mim_2f0_m4m5_noshield c_width=5u c_length=5u
X1615 a_3540_181966.t7 VSS cap_mim_2f0_m4m5_noshield c_width=5u c_length=5u
X1616 a_3540_180844# VSS cap_mim_2f0_m4m5_noshield c_width=5u c_length=5u
X1617 a_3540_180844# VSS cap_mim_2f0_m4m5_noshield c_width=5u c_length=5u
X1618 a_3540_180844# VSS cap_mim_2f0_m4m5_noshield c_width=5u c_length=5u
X1619 a_3540_181966.t7 VSS cap_mim_2f0_m4m5_noshield c_width=5u c_length=5u
X1620 a_3540_180844# VSS cap_mim_2f0_m4m5_noshield c_width=5u c_length=5u
X1621 a_3540_180844# VSS cap_mim_2f0_m4m5_noshield c_width=5u c_length=5u
X1622 a_3540_180844# VSS cap_mim_2f0_m4m5_noshield c_width=5u c_length=5u
X1623 a_3540_180844# VSS cap_mim_2f0_m4m5_noshield c_width=5u c_length=5u
X1624 a_45667_83109# a_36707_106069.t8 VDD VDD pfet_03v3 ad=0.89p pd=4.89u as=0.89p ps=4.89u w=2u l=0.28u
X1625 a_3540_180844# VSS cap_mim_2f0_m4m5_noshield c_width=5u c_length=5u
X1626 a_3540_180844# VSS cap_mim_2f0_m4m5_noshield c_width=5u c_length=5u
X1627 a_3540_180844# VSS cap_mim_2f0_m4m5_noshield c_width=5u c_length=5u
X1628 a_3540_180844# VSS cap_mim_2f0_m4m5_noshield c_width=5u c_length=5u
X1629 a_3540_180844# VSS cap_mim_2f0_m4m5_noshield c_width=5u c_length=5u
X1630 a_3540_180844# VSS cap_mim_2f0_m4m5_noshield c_width=5u c_length=5u
X1631 a_3540_180844# VSS cap_mim_2f0_m4m5_noshield c_width=5u c_length=5u
X1632 a_88409_69640# NB.t13 VSS VSS nfet_03v3 ad=2.12p pd=8.53u as=2.12p ps=8.53u w=8u l=2u
X1633 a_3540_180844# VSS cap_mim_2f0_m4m5_noshield c_width=5u c_length=5u
X1634 a_3540_180844# VSS cap_mim_2f0_m4m5_noshield c_width=5u c_length=5u
X1635 a_3540_180844# VSS cap_mim_2f0_m4m5_noshield c_width=5u c_length=5u
X1636 a_3540_180844# VSS cap_mim_2f0_m4m5_noshield c_width=5u c_length=5u
X1637 VCTRL.t1 VSS cap_mim_2f0_m4m5_noshield c_width=5u c_length=5u
X1638 a_3540_180844# VSS cap_mim_2f0_m4m5_noshield c_width=5u c_length=5u
X1639 a_3540_18186# a_3960_16064# VSS ppolyf_u_1k r_width=1u r_length=10u
X1640 a_30105_7822# a_19465_10700# a_30105_15880# VDD pfet_03v3 ad=0.89p pd=4.89u as=0.89p ps=4.89u w=2u l=0.28u
X1641 a_87640_80239# PB.t5 VDD VDD pfet_03v3 ad=2.12p pd=8.53u as=2.12p ps=8.53u w=8u l=2u
X1642 a_3540_180844# VSS cap_mim_2f0_m4m5_noshield c_width=5u c_length=5u
X1643 a_61465_40940# a_61347_33269# VDD VDD pfet_03v3 ad=0.89p pd=4.89u as=0.89p ps=4.89u w=2u l=0.28u
X1644 a_3540_181966.t7 VSS cap_mim_2f0_m4m5_noshield c_width=5u c_length=5u
X1645 a_3540_180844# VSS cap_mim_2f0_m4m5_noshield c_width=5u c_length=5u
X1646 a_39480_36740# a_39507_45729# VSS VSS nfet_03v3 ad=0.6675p pd=3.89u as=0.6675p ps=3.89u w=1.5u l=0.28u
X1647 a_3540_181966.t7 VSS cap_mim_2f0_m4m5_noshield c_width=5u c_length=5u
X1648 a_3540_180844# VSS cap_mim_2f0_m4m5_noshield c_width=5u c_length=5u
X1649 a_30105_36740# a_29987_37189.t5 a_29960_36740# VSS nfet_03v3 ad=0.6675p pd=3.89u as=0.6675p ps=3.89u w=1.5u l=0.28u
X1650 a_3540_180844# VSS cap_mim_2f0_m4m5_noshield c_width=5u c_length=5u
X1651 a_3540_180844# VSS cap_mim_2f0_m4m5_noshield c_width=5u c_length=5u
X1652 a_29987_37189.t1 a_57987_8209# VDD VDD pfet_03v3 ad=0.89p pd=4.89u as=0.89p ps=4.89u w=2u l=0.28u
X1653 a_3540_180844# VSS cap_mim_2f0_m4m5_noshield c_width=5u c_length=5u
X1654 a_3540_180844# VSS cap_mim_2f0_m4m5_noshield c_width=5u c_length=5u
X1655 a_3540_180844# VSS cap_mim_2f0_m4m5_noshield c_width=5u c_length=5u
X1656 a_3540_180844# VSS cap_mim_2f0_m4m5_noshield c_width=5u c_length=5u
X1657 a_3540_180844# VSS cap_mim_2f0_m4m5_noshield c_width=5u c_length=5u
X1658 a_3540_180844# VSS cap_mim_2f0_m4m5_noshield c_width=5u c_length=5u
X1659 a_3540_180844# VSS cap_mim_2f0_m4m5_noshield c_width=5u c_length=5u
X1660 a_3540_180844# VSS cap_mim_2f0_m4m5_noshield c_width=5u c_length=5u
X1661 a_3540_180844# VSS cap_mim_2f0_m4m5_noshield c_width=5u c_length=5u
X1662 a_3540_180844# VSS cap_mim_2f0_m4m5_noshield c_width=5u c_length=5u
X1663 a_3540_181966.t7 VSS cap_mim_2f0_m4m5_noshield c_width=5u c_length=5u
X1664 a_3540_180844# VSS cap_mim_2f0_m4m5_noshield c_width=5u c_length=5u
X1665 a_3540_180844# VSS cap_mim_2f0_m4m5_noshield c_width=5u c_length=5u
X1666 a_3540_180844# VSS cap_mim_2f0_m4m5_noshield c_width=5u c_length=5u
X1667 VCTRL.t1 VSS cap_mim_2f0_m4m5_noshield c_width=5u c_length=5u
X1668 a_3540_180844# VSS cap_mim_2f0_m4m5_noshield c_width=5u c_length=5u
X1669 a_3540_180844# VSS cap_mim_2f0_m4m5_noshield c_width=5u c_length=5u
X1670 a_3540_180844# VSS cap_mim_2f0_m4m5_noshield c_width=5u c_length=5u
X1671 a_3540_180844# VSS cap_mim_2f0_m4m5_noshield c_width=5u c_length=5u
X1672 a_3540_180844# VSS cap_mim_2f0_m4m5_noshield c_width=5u c_length=5u
X1673 a_3540_180844# VSS cap_mim_2f0_m4m5_noshield c_width=5u c_length=5u
X1674 a_3540_180844# VSS cap_mim_2f0_m4m5_noshield c_width=5u c_length=5u
X1675 a_3540_180844# VSS cap_mim_2f0_m4m5_noshield c_width=5u c_length=5u
X1676 a_45667_83109# a_15987_66729.t12 VDD VDD pfet_03v3 ad=0.89p pd=4.89u as=0.89p ps=4.89u w=2u l=0.28u
X1677 a_3540_180844# VSS cap_mim_2f0_m4m5_noshield c_width=5u c_length=5u
X1678 a_8147_83109# REFCK.t5 VDD VDD pfet_03v3 ad=0.89p pd=4.89u as=0.89p ps=4.89u w=2u l=0.28u
X1679 a_3540_180844# VSS cap_mim_2f0_m4m5_noshield c_width=5u c_length=5u
X1680 a_3540_180844# VSS cap_mim_2f0_m4m5_noshield c_width=5u c_length=5u
X1681 a_3540_180844# VSS cap_mim_2f0_m4m5_noshield c_width=5u c_length=5u
X1682 a_3540_180844# VSS cap_mim_2f0_m4m5_noshield c_width=5u c_length=5u
X1683 VCTRL.t1 VSS cap_mim_2f0_m4m5_noshield c_width=5u c_length=5u
X1684 VDD PB.t24 a_89421_74820# VDD pfet_03v3 ad=2.12p pd=8.53u as=2.12p ps=8.53u w=8u l=2u
X1685 a_44105_7822# a_43987_8209# VSS VSS nfet_03v3 ad=0.445p pd=2.89u as=0.445p ps=2.89u w=1u l=0.28u
X1686 a_3540_180844# VSS cap_mim_2f0_m4m5_noshield c_width=5u c_length=5u
X1687 a_3540_180844# VSS cap_mim_2f0_m4m5_noshield c_width=5u c_length=5u
X1688 a_3540_181966.t7 VSS cap_mim_2f0_m4m5_noshield c_width=5u c_length=5u
X1689 a_3540_180844# VSS cap_mim_2f0_m4m5_noshield c_width=5u c_length=5u
X1690 a_3540_180844# VSS cap_mim_2f0_m4m5_noshield c_width=5u c_length=5u
X1691 a_3540_180844# VSS cap_mim_2f0_m4m5_noshield c_width=5u c_length=5u
X1692 a_3540_180844# VSS cap_mim_2f0_m4m5_noshield c_width=5u c_length=5u
X1693 a_3540_180844# VSS cap_mim_2f0_m4m5_noshield c_width=5u c_length=5u
X1694 a_3540_180844# VSS cap_mim_2f0_m4m5_noshield c_width=5u c_length=5u
X1695 a_3540_180844# VSS cap_mim_2f0_m4m5_noshield c_width=5u c_length=5u
X1696 a_3540_180844# VSS cap_mim_2f0_m4m5_noshield c_width=5u c_length=5u
X1697 VCTRL.t1 VSS cap_mim_2f0_m4m5_noshield c_width=5u c_length=5u
X1698 a_43987_8209# a_31785_19940# a_43960_11680# VSS nfet_03v3 ad=0.6675p pd=3.89u as=0.6675p ps=3.89u w=1.5u l=0.28u
X1699 a_3540_180844# VSS cap_mim_2f0_m4m5_noshield c_width=5u c_length=5u
X1700 a_3540_180844# VSS cap_mim_2f0_m4m5_noshield c_width=5u c_length=5u
X1701 a_3540_180844# VSS cap_mim_2f0_m4m5_noshield c_width=5u c_length=5u
X1702 a_3540_180844# VSS cap_mim_2f0_m4m5_noshield c_width=5u c_length=5u
X1703 a_3540_180844# VSS cap_mim_2f0_m4m5_noshield c_width=5u c_length=5u
X1704 a_3540_180844# VSS cap_mim_2f0_m4m5_noshield c_width=5u c_length=5u
X1705 a_3540_180844# VSS cap_mim_2f0_m4m5_noshield c_width=5u c_length=5u
X1706 a_3540_180844# VSS cap_mim_2f0_m4m5_noshield c_width=5u c_length=5u
X1707 a_3540_180844# VSS cap_mim_2f0_m4m5_noshield c_width=5u c_length=5u
X1708 LO a_17667_11569# cap_mim_2f0_m4m5_noshield c_width=5u c_length=5u
X1709 a_6025_105682# a_5907_106069.t2 VSS VSS nfet_03v3 ad=0.445p pd=2.89u as=0.445p ps=2.89u w=1u l=0.28u
X1710 a_3540_180844# VSS cap_mim_2f0_m4m5_noshield c_width=5u c_length=5u
X1711 a_3540_180844# VSS cap_mim_2f0_m4m5_noshield c_width=5u c_length=5u
X1712 a_3540_180844# VSS cap_mim_2f0_m4m5_noshield c_width=5u c_length=5u
X1713 a_3540_180844# VSS cap_mim_2f0_m4m5_noshield c_width=5u c_length=5u
X1714 a_3540_180844# VSS cap_mim_2f0_m4m5_noshield c_width=5u c_length=5u
X1715 a_3540_180844# VSS cap_mim_2f0_m4m5_noshield c_width=5u c_length=5u
X1716 a_3540_180844# VSS cap_mim_2f0_m4m5_noshield c_width=5u c_length=5u
X1717 a_3540_180844# VSS cap_mim_2f0_m4m5_noshield c_width=5u c_length=5u
X1718 a_3540_180844# VSS cap_mim_2f0_m4m5_noshield c_width=5u c_length=5u
X1719 a_3540_180844# VSS cap_mim_2f0_m4m5_noshield c_width=5u c_length=5u
X1720 a_3540_180844# VSS cap_mim_2f0_m4m5_noshield c_width=5u c_length=5u
X1721 a_3540_181966.t7 VSS cap_mim_2f0_m4m5_noshield c_width=5u c_length=5u
X1722 a_3540_180844# VSS cap_mim_2f0_m4m5_noshield c_width=5u c_length=5u
X1723 a_3540_180844# VSS cap_mim_2f0_m4m5_noshield c_width=5u c_length=5u
X1724 FS a_73225_30440# VDD VDD pfet_03v3 ad=0.795p pd=3.53u as=0.795p ps=3.53u w=3u l=0.28u
X1725 a_3540_180844# VSS cap_mim_2f0_m4m5_noshield c_width=5u c_length=5u
X1726 a_3540_180844# VSS cap_mim_2f0_m4m5_noshield c_width=5u c_length=5u
X1727 a_3540_180844# VSS cap_mim_2f0_m4m5_noshield c_width=5u c_length=5u
X1728 a_3540_180844# VSS cap_mim_2f0_m4m5_noshield c_width=5u c_length=5u
X1729 a_3540_180844# VSS cap_mim_2f0_m4m5_noshield c_width=5u c_length=5u
X1730 a_3540_180844# VSS cap_mim_2f0_m4m5_noshield c_width=5u c_length=5u
X1731 a_8265_82520.t0 a_9827_83109# VDD VDD pfet_03v3 ad=0.89p pd=4.89u as=0.89p ps=4.89u w=2u l=0.28u
X1732 a_3540_180844# VSS cap_mim_2f0_m4m5_noshield c_width=5u c_length=5u
X1733 a_3540_180844# VSS cap_mim_2f0_m4m5_noshield c_width=5u c_length=5u
X1734 a_3540_180844# VSS cap_mim_2f0_m4m5_noshield c_width=5u c_length=5u
X1735 a_3540_180844# VSS cap_mim_2f0_m4m5_noshield c_width=5u c_length=5u
X1736 a_51800_61800# FB.t5 a_51945_66000# VSS nfet_03v3 ad=1.335p pd=6.89u as=1.335p ps=6.89u w=3u l=0.28u
X1737 a_3540_180844# VSS cap_mim_2f0_m4m5_noshield c_width=5u c_length=5u
X1738 a_3540_181966.t7 VSS cap_mim_2f0_m4m5_noshield c_width=5u c_length=5u
X1739 a_3540_180844# VSS cap_mim_2f0_m4m5_noshield c_width=5u c_length=5u
X1740 a_3540_180844# VSS cap_mim_2f0_m4m5_noshield c_width=5u c_length=5u
X1741 a_3540_180844# VSS cap_mim_2f0_m4m5_noshield c_width=5u c_length=5u
X1742 VCTRL.t1 VSS cap_mim_2f0_m4m5_noshield c_width=5u c_length=5u
X1743 a_3540_180844# VSS cap_mim_2f0_m4m5_noshield c_width=5u c_length=5u
X1744 a_3540_180844# VSS cap_mim_2f0_m4m5_noshield c_width=5u c_length=5u
X1745 a_3540_181966.t7 VSS cap_mim_2f0_m4m5_noshield c_width=5u c_length=5u
X1746 a_4380_18186# a_3960_16064# VSS ppolyf_u_1k r_width=1u r_length=10u
X1747 a_3540_180844# VSS cap_mim_2f0_m4m5_noshield c_width=5u c_length=5u
X1748 a_3540_180844# VSS cap_mim_2f0_m4m5_noshield c_width=5u c_length=5u
X1749 a_88109_80239# VSS cap_mim_2f0_m4m5_noshield c_width=5u c_length=5u
X1750 a_3540_180844# VSS cap_mim_2f0_m4m5_noshield c_width=5u c_length=5u
X1751 a_3540_180844# VSS cap_mim_2f0_m4m5_noshield c_width=5u c_length=5u
X1752 a_3540_180844# VSS cap_mim_2f0_m4m5_noshield c_width=5u c_length=5u
X1753 a_3540_180844# VSS cap_mim_2f0_m4m5_noshield c_width=5u c_length=5u
X1754 a_3540_180844# VSS cap_mim_2f0_m4m5_noshield c_width=5u c_length=5u
X1755 a_3540_180844# VSS cap_mim_2f0_m4m5_noshield c_width=5u c_length=5u
X1756 a_3540_180844# VSS cap_mim_2f0_m4m5_noshield c_width=5u c_length=5u
X1757 a_3540_180844# VSS cap_mim_2f0_m4m5_noshield c_width=5u c_length=5u
X1758 a_88109_80239# VSS cap_mim_2f0_m4m5_noshield c_width=5u c_length=5u
X1759 a_3540_180844# VSS cap_mim_2f0_m4m5_noshield c_width=5u c_length=5u
X1760 a_3540_180844# VSS cap_mim_2f0_m4m5_noshield c_width=5u c_length=5u
X1761 a_3540_180844# VSS cap_mim_2f0_m4m5_noshield c_width=5u c_length=5u
X1762 a_3540_180844# VSS cap_mim_2f0_m4m5_noshield c_width=5u c_length=5u
X1763 a_3540_181966.t7 VSS cap_mim_2f0_m4m5_noshield c_width=5u c_length=5u
X1764 a_3540_180844# VSS cap_mim_2f0_m4m5_noshield c_width=5u c_length=5u
X1765 VSS NB.t4 a_88409_69640# VSS nfet_03v3 ad=2.12p pd=8.53u as=2.12p ps=8.53u w=8u l=2u
X1766 a_3540_180844# VSS cap_mim_2f0_m4m5_noshield c_width=5u c_length=5u
X1767 a_3540_16064# a_3667_12409# VDD VDD pfet_03v3 ad=1.78p pd=8.89u as=1.78p ps=8.89u w=4u l=0.28u
X1768 a_3540_180844# VSS cap_mim_2f0_m4m5_noshield c_width=5u c_length=5u
X1769 a_3540_180844# VSS cap_mim_2f0_m4m5_noshield c_width=5u c_length=5u
X1770 VCTRL.t1 VSS cap_mim_2f0_m4m5_noshield c_width=5u c_length=5u
X1771 a_3540_180844# VSS cap_mim_2f0_m4m5_noshield c_width=5u c_length=5u
X1772 a_3540_180844# VSS cap_mim_2f0_m4m5_noshield c_width=5u c_length=5u
X1773 a_3540_180844# VSS cap_mim_2f0_m4m5_noshield c_width=5u c_length=5u
X1774 REFIN a_3667_12409# cap_mim_2f0_m4m5_noshield c_width=5u c_length=5u
X1775 a_3540_180844# VSS cap_mim_2f0_m4m5_noshield c_width=5u c_length=5u
X1776 a_3540_180844# VSS cap_mim_2f0_m4m5_noshield c_width=5u c_length=5u
X1777 a_3540_180844# VSS cap_mim_2f0_m4m5_noshield c_width=5u c_length=5u
X1778 a_3540_180844# VSS cap_mim_2f0_m4m5_noshield c_width=5u c_length=5u
X1779 a_3540_180844# VSS cap_mim_2f0_m4m5_noshield c_width=5u c_length=5u
X1780 a_3540_180844# VSS cap_mim_2f0_m4m5_noshield c_width=5u c_length=5u
X1781 a_3540_180844# VSS cap_mim_2f0_m4m5_noshield c_width=5u c_length=5u
X1782 a_3540_180844# VSS cap_mim_2f0_m4m5_noshield c_width=5u c_length=5u
X1783 VSS NB.t16 a_88409_69640# VSS nfet_03v3 ad=2.12p pd=8.53u as=2.12p ps=8.53u w=8u l=2u
X1784 a_3540_180844# VSS cap_mim_2f0_m4m5_noshield c_width=5u c_length=5u
X1785 a_3540_180844# VSS cap_mim_2f0_m4m5_noshield c_width=5u c_length=5u
X1786 a_3540_180844# VSS cap_mim_2f0_m4m5_noshield c_width=5u c_length=5u
X1787 a_3540_180844# VSS cap_mim_2f0_m4m5_noshield c_width=5u c_length=5u
X1788 a_3540_180844# VSS cap_mim_2f0_m4m5_noshield c_width=5u c_length=5u
X1789 a_3540_180844# VSS cap_mim_2f0_m4m5_noshield c_width=5u c_length=5u
X1790 a_3540_180844# VSS cap_mim_2f0_m4m5_noshield c_width=5u c_length=5u
X1791 a_3540_180844# VSS cap_mim_2f0_m4m5_noshield c_width=5u c_length=5u
X1792 a_3540_180844# VSS cap_mim_2f0_m4m5_noshield c_width=5u c_length=5u
X1793 a_3540_180844# VSS cap_mim_2f0_m4m5_noshield c_width=5u c_length=5u
X1794 a_3540_180844# VSS cap_mim_2f0_m4m5_noshield c_width=5u c_length=5u
X1795 a_3540_180844# VSS cap_mim_2f0_m4m5_noshield c_width=5u c_length=5u
X1796 a_3540_180844# VSS cap_mim_2f0_m4m5_noshield c_width=5u c_length=5u
X1797 a_3540_180844# VSS cap_mim_2f0_m4m5_noshield c_width=5u c_length=5u
X1798 a_3540_180844# VSS cap_mim_2f0_m4m5_noshield c_width=5u c_length=5u
X1799 a_3540_180844# VSS cap_mim_2f0_m4m5_noshield c_width=5u c_length=5u
X1800 a_3540_180844# VSS cap_mim_2f0_m4m5_noshield c_width=5u c_length=5u
X1801 a_3540_180844# VSS cap_mim_2f0_m4m5_noshield c_width=5u c_length=5u
X1802 VDD PB.t10 a_89421_74820# VDD pfet_03v3 ad=2.12p pd=8.53u as=2.12p ps=8.53u w=8u l=2u
X1803 a_3540_180844# VSS cap_mim_2f0_m4m5_noshield c_width=5u c_length=5u
X1804 a_3540_180844# VSS cap_mim_2f0_m4m5_noshield c_width=5u c_length=5u
X1805 a_3540_180844# VSS cap_mim_2f0_m4m5_noshield c_width=5u c_length=5u
X1806 a_3540_180844# VSS cap_mim_2f0_m4m5_noshield c_width=5u c_length=5u
X1807 a_99409_69879# a_99409_69879# VDD VDD pfet_03v3 ad=1.06p pd=4.53u as=1.78p ps=8.89u w=4u l=1u
X1808 a_3540_180844# VSS cap_mim_2f0_m4m5_noshield c_width=5u c_length=5u
X1809 a_3540_180844# VSS cap_mim_2f0_m4m5_noshield c_width=5u c_length=5u
X1810 a_3540_180844# VSS cap_mim_2f0_m4m5_noshield c_width=5u c_length=5u
X1811 a_3540_180844# VSS cap_mim_2f0_m4m5_noshield c_width=5u c_length=5u
X1812 a_3540_181966.t7 VSS cap_mim_2f0_m4m5_noshield c_width=5u c_length=5u
X1813 a_3540_181966.t7 VSS cap_mim_2f0_m4m5_noshield c_width=5u c_length=5u
X1814 a_49145_36740# a_31785_45000# VDD VDD pfet_03v3 ad=1.78p pd=8.89u as=1.78p ps=8.89u w=4u l=0.28u
X1815 a_3540_181966.t7 VSS cap_mim_2f0_m4m5_noshield c_width=5u c_length=5u
X1816 a_3540_180844# VSS cap_mim_2f0_m4m5_noshield c_width=5u c_length=5u
X1817 a_3540_180844# VSS cap_mim_2f0_m4m5_noshield c_width=5u c_length=5u
X1818 a_3540_180844# VSS cap_mim_2f0_m4m5_noshield c_width=5u c_length=5u
X1819 a_3540_180844# VSS cap_mim_2f0_m4m5_noshield c_width=5u c_length=5u
X1820 a_3540_180844# VSS cap_mim_2f0_m4m5_noshield c_width=5u c_length=5u
X1821 a_3540_181966.t7 VSS cap_mim_2f0_m4m5_noshield c_width=5u c_length=5u
X1822 a_3540_180844# VSS cap_mim_2f0_m4m5_noshield c_width=5u c_length=5u
X1823 a_43987_8209# a_43987_20669# VDD VDD pfet_03v3 ad=1.335p pd=6.89u as=1.335p ps=6.89u w=3u l=0.28u
X1824 a_3540_180844# VSS cap_mim_2f0_m4m5_noshield c_width=5u c_length=5u
X1825 a_3540_180844# VSS cap_mim_2f0_m4m5_noshield c_width=5u c_length=5u
X1826 a_3540_180844# VSS cap_mim_2f0_m4m5_noshield c_width=5u c_length=5u
X1827 a_3540_180844# VSS cap_mim_2f0_m4m5_noshield c_width=5u c_length=5u
X1828 a_3540_180844# VSS cap_mim_2f0_m4m5_noshield c_width=5u c_length=5u
X1829 a_3540_180844# VSS cap_mim_2f0_m4m5_noshield c_width=5u c_length=5u
X1830 a_3540_180844# VSS cap_mim_2f0_m4m5_noshield c_width=5u c_length=5u
X1831 a_3540_180844# VSS cap_mim_2f0_m4m5_noshield c_width=5u c_length=5u
X1832 a_3540_180844# VSS cap_mim_2f0_m4m5_noshield c_width=5u c_length=5u
X1833 a_99409_69879# a_3540_181966.t10 a_92457_69640# VSS nfet_03v3 ad=1.06p pd=4.53u as=1.78p ps=8.89u w=4u l=1u
X1834 a_31640_7480# a_19465_10700# VSS VSS nfet_03v3 ad=0.6675p pd=3.89u as=0.6675p ps=3.89u w=1.5u l=0.28u
X1835 a_3540_180844# VSS cap_mim_2f0_m4m5_noshield c_width=5u c_length=5u
X1836 a_3540_180844# VSS cap_mim_2f0_m4m5_noshield c_width=5u c_length=5u
X1837 a_3540_180844# VSS cap_mim_2f0_m4m5_noshield c_width=5u c_length=5u
X1838 a_3540_180844# VSS cap_mim_2f0_m4m5_noshield c_width=5u c_length=5u
X1839 a_3540_180844# VSS cap_mim_2f0_m4m5_noshield c_width=5u c_length=5u
X1840 a_3540_181966.t7 VSS cap_mim_2f0_m4m5_noshield c_width=5u c_length=5u
X1841 a_3540_180844# VSS cap_mim_2f0_m4m5_noshield c_width=5u c_length=5u
X1842 a_3540_180844# VSS cap_mim_2f0_m4m5_noshield c_width=5u c_length=5u
X1843 a_3540_180844# VSS cap_mim_2f0_m4m5_noshield c_width=5u c_length=5u
X1844 a_3540_180844# VSS cap_mim_2f0_m4m5_noshield c_width=5u c_length=5u
X1845 a_3540_180844# VSS cap_mim_2f0_m4m5_noshield c_width=5u c_length=5u
X1846 a_3540_180844# VSS cap_mim_2f0_m4m5_noshield c_width=5u c_length=5u
X1847 a_3540_180844# VSS cap_mim_2f0_m4m5_noshield c_width=5u c_length=5u
X1848 a_3540_180844# VSS cap_mim_2f0_m4m5_noshield c_width=5u c_length=5u
X1849 a_3540_180844# VSS cap_mim_2f0_m4m5_noshield c_width=5u c_length=5u
X1850 a_3540_180844# VSS cap_mim_2f0_m4m5_noshield c_width=5u c_length=5u
X1851 a_3540_180844# VSS cap_mim_2f0_m4m5_noshield c_width=5u c_length=5u
X1852 a_3540_180844# VSS cap_mim_2f0_m4m5_noshield c_width=5u c_length=5u
X1853 a_3540_180844# VSS cap_mim_2f0_m4m5_noshield c_width=5u c_length=5u
X1854 a_3540_180844# VSS cap_mim_2f0_m4m5_noshield c_width=5u c_length=5u
X1855 a_3540_180844# VSS cap_mim_2f0_m4m5_noshield c_width=5u c_length=5u
X1856 a_3540_180844# VSS cap_mim_2f0_m4m5_noshield c_width=5u c_length=5u
X1857 a_3540_180844# VSS cap_mim_2f0_m4m5_noshield c_width=5u c_length=5u
X1858 a_3540_180844# VSS cap_mim_2f0_m4m5_noshield c_width=5u c_length=5u
X1859 a_3540_180844# VSS cap_mim_2f0_m4m5_noshield c_width=5u c_length=5u
X1860 a_3540_180844# VSS cap_mim_2f0_m4m5_noshield c_width=5u c_length=5u
X1861 a_3540_180844# VSS cap_mim_2f0_m4m5_noshield c_width=5u c_length=5u
X1862 a_3540_180844# VSS cap_mim_2f0_m4m5_noshield c_width=5u c_length=5u
X1863 a_3540_180844# VSS cap_mim_2f0_m4m5_noshield c_width=5u c_length=5u
X1864 a_3540_181966.t8 VSS cap_mim_2f0_m4m5_noshield c_width=5u c_length=5u
X1865 a_3540_180844# VSS cap_mim_2f0_m4m5_noshield c_width=5u c_length=5u
X1866 a_3540_180844# VSS cap_mim_2f0_m4m5_noshield c_width=5u c_length=5u
X1867 a_3540_180844# VSS cap_mim_2f0_m4m5_noshield c_width=5u c_length=5u
X1868 a_3540_180844# VSS cap_mim_2f0_m4m5_noshield c_width=5u c_length=5u
X1869 a_3540_180844# VSS cap_mim_2f0_m4m5_noshield c_width=5u c_length=5u
X1870 a_3540_180844# VSS cap_mim_2f0_m4m5_noshield c_width=5u c_length=5u
X1871 a_3540_180844# VSS cap_mim_2f0_m4m5_noshield c_width=5u c_length=5u
X1872 a_3540_181966.t7 VSS cap_mim_2f0_m4m5_noshield c_width=5u c_length=5u
X1873 a_3540_180844# VSS cap_mim_2f0_m4m5_noshield c_width=5u c_length=5u
X1874 a_3540_180844# VSS cap_mim_2f0_m4m5_noshield c_width=5u c_length=5u
X1875 a_3540_180844# VSS cap_mim_2f0_m4m5_noshield c_width=5u c_length=5u
X1876 a_3540_181966.t7 VSS cap_mim_2f0_m4m5_noshield c_width=5u c_length=5u
X1877 a_3540_180844# VSS cap_mim_2f0_m4m5_noshield c_width=5u c_length=5u
X1878 a_19465_10700# a_17540_15224# VSS VSS nfet_03v3 ad=1.78p pd=8.89u as=1.78p ps=8.89u w=4u l=0.28u
X1879 a_88109_80239# VSS cap_mim_2f0_m4m5_noshield c_width=5u c_length=5u
X1880 a_3540_180844# VSS cap_mim_2f0_m4m5_noshield c_width=5u c_length=5u
X1881 a_3540_180844# VSS cap_mim_2f0_m4m5_noshield c_width=5u c_length=5u
X1882 a_3540_180844# VSS cap_mim_2f0_m4m5_noshield c_width=5u c_length=5u
X1883 a_3540_180844# VSS cap_mim_2f0_m4m5_noshield c_width=5u c_length=5u
X1884 a_3540_180844# VSS cap_mim_2f0_m4m5_noshield c_width=5u c_length=5u
X1885 a_3540_180844# VSS cap_mim_2f0_m4m5_noshield c_width=5u c_length=5u
X1886 a_3540_180844# VSS cap_mim_2f0_m4m5_noshield c_width=5u c_length=5u
X1887 a_3540_180844# VSS cap_mim_2f0_m4m5_noshield c_width=5u c_length=5u
X1888 a_3540_180844# VSS cap_mim_2f0_m4m5_noshield c_width=5u c_length=5u
X1889 a_3540_180844# VSS cap_mim_2f0_m4m5_noshield c_width=5u c_length=5u
X1890 a_3540_180844# VSS cap_mim_2f0_m4m5_noshield c_width=5u c_length=5u
X1891 a_3540_180844# VSS cap_mim_2f0_m4m5_noshield c_width=5u c_length=5u
X1892 a_3540_180844# VSS cap_mim_2f0_m4m5_noshield c_width=5u c_length=5u
X1893 a_3540_180844# VSS cap_mim_2f0_m4m5_noshield c_width=5u c_length=5u
X1894 a_89421_74820# a_92189_81289# a_89880_80239# VDD pfet_03v3 ad=1.59p pd=6.53u as=1.59p ps=6.53u w=6u l=0.28u
X1895 a_3540_180844# VSS cap_mim_2f0_m4m5_noshield c_width=5u c_length=5u
X1896 a_3540_180844# VSS cap_mim_2f0_m4m5_noshield c_width=5u c_length=5u
X1897 a_8147_83109# a_8265_61800# a_15960_61800# VSS nfet_03v3 ad=1.335p pd=6.89u as=1.335p ps=6.89u w=3u l=0.28u
X1898 a_3540_180844# VSS cap_mim_2f0_m4m5_noshield c_width=5u c_length=5u
X1899 a_3540_180844# VSS cap_mim_2f0_m4m5_noshield c_width=5u c_length=5u
X1900 a_3540_180844# VSS cap_mim_2f0_m4m5_noshield c_width=5u c_length=5u
X1901 a_3540_180844# VSS cap_mim_2f0_m4m5_noshield c_width=5u c_length=5u
X1902 a_3540_180844# VSS cap_mim_2f0_m4m5_noshield c_width=5u c_length=5u
X1903 a_3540_180844# VSS cap_mim_2f0_m4m5_noshield c_width=5u c_length=5u
X1904 a_3540_180844# VSS cap_mim_2f0_m4m5_noshield c_width=5u c_length=5u
X1905 a_3540_180844# VSS cap_mim_2f0_m4m5_noshield c_width=5u c_length=5u
X1906 a_3540_180844# VSS cap_mim_2f0_m4m5_noshield c_width=5u c_length=5u
X1907 a_3540_180844# VSS cap_mim_2f0_m4m5_noshield c_width=5u c_length=5u
X1908 a_3540_180844# VSS cap_mim_2f0_m4m5_noshield c_width=5u c_length=5u
X1909 a_3540_180844# VSS cap_mim_2f0_m4m5_noshield c_width=5u c_length=5u
X1910 a_3540_180844# VSS cap_mim_2f0_m4m5_noshield c_width=5u c_length=5u
X1911 a_3540_180844# VSS cap_mim_2f0_m4m5_noshield c_width=5u c_length=5u
X1912 a_3540_180844# VSS cap_mim_2f0_m4m5_noshield c_width=5u c_length=5u
X1913 a_3540_180844# VSS cap_mim_2f0_m4m5_noshield c_width=5u c_length=5u
X1914 a_3540_180844# VSS cap_mim_2f0_m4m5_noshield c_width=5u c_length=5u
X1915 a_3540_180844# VSS cap_mim_2f0_m4m5_noshield c_width=5u c_length=5u
X1916 a_3540_180844# VSS cap_mim_2f0_m4m5_noshield c_width=5u c_length=5u
X1917 a_3540_180844# VSS cap_mim_2f0_m4m5_noshield c_width=5u c_length=5u
X1918 a_3540_180844# VSS cap_mim_2f0_m4m5_noshield c_width=5u c_length=5u
X1919 a_3540_180844# VSS cap_mim_2f0_m4m5_noshield c_width=5u c_length=5u
X1920 a_3540_180844# VSS cap_mim_2f0_m4m5_noshield c_width=5u c_length=5u
X1921 a_3540_180844# VSS cap_mim_2f0_m4m5_noshield c_width=5u c_length=5u
X1922 a_3540_180844# VSS cap_mim_2f0_m4m5_noshield c_width=5u c_length=5u
X1923 a_3540_180844# VSS cap_mim_2f0_m4m5_noshield c_width=5u c_length=5u
X1924 a_3540_181966.t7 VSS cap_mim_2f0_m4m5_noshield c_width=5u c_length=5u
X1925 a_3540_181966.t7 VSS cap_mim_2f0_m4m5_noshield c_width=5u c_length=5u
X1926 a_3540_180844# VSS cap_mim_2f0_m4m5_noshield c_width=5u c_length=5u
X1927 REFIN a_3667_12409# cap_mim_2f0_m4m5_noshield c_width=5u c_length=5u
X1928 a_3540_180844# VSS cap_mim_2f0_m4m5_noshield c_width=5u c_length=5u
X1929 a_3540_181966.t8 VSS cap_mim_2f0_m4m5_noshield c_width=5u c_length=5u
X1930 a_3540_180844# VSS cap_mim_2f0_m4m5_noshield c_width=5u c_length=5u
X1931 a_3540_180844# VSS cap_mim_2f0_m4m5_noshield c_width=5u c_length=5u
X1932 a_3540_181966.t7 VSS cap_mim_2f0_m4m5_noshield c_width=5u c_length=5u
X1933 a_3540_180844# VSS cap_mim_2f0_m4m5_noshield c_width=5u c_length=5u
X1934 a_3540_180844# VSS cap_mim_2f0_m4m5_noshield c_width=5u c_length=5u
X1935 a_3540_180844# VSS cap_mim_2f0_m4m5_noshield c_width=5u c_length=5u
X1936 a_3540_180844# VSS cap_mim_2f0_m4m5_noshield c_width=5u c_length=5u
X1937 a_3540_180844# VSS cap_mim_2f0_m4m5_noshield c_width=5u c_length=5u
X1938 a_3540_180844# VSS cap_mim_2f0_m4m5_noshield c_width=5u c_length=5u
X1939 a_3540_181966.t7 VSS cap_mim_2f0_m4m5_noshield c_width=5u c_length=5u
X1940 a_3540_180844# VSS cap_mim_2f0_m4m5_noshield c_width=5u c_length=5u
X1941 a_3540_180844# VSS cap_mim_2f0_m4m5_noshield c_width=5u c_length=5u
X1942 a_3540_180844# VSS cap_mim_2f0_m4m5_noshield c_width=5u c_length=5u
X1943 a_3540_181966.t7 VSS cap_mim_2f0_m4m5_noshield c_width=5u c_length=5u
X1944 a_3540_180844# VSS cap_mim_2f0_m4m5_noshield c_width=5u c_length=5u
X1945 a_88109_80239# VSS cap_mim_2f0_m4m5_noshield c_width=5u c_length=5u
X1946 a_3540_180844# VSS cap_mim_2f0_m4m5_noshield c_width=5u c_length=5u
X1947 a_3540_181966.t7 VSS cap_mim_2f0_m4m5_noshield c_width=5u c_length=5u
X1948 a_3540_180844# VSS cap_mim_2f0_m4m5_noshield c_width=5u c_length=5u
X1949 a_3540_180844# VSS cap_mim_2f0_m4m5_noshield c_width=5u c_length=5u
X1950 a_3540_180844# VSS cap_mim_2f0_m4m5_noshield c_width=5u c_length=5u
X1951 a_3540_180844# VSS cap_mim_2f0_m4m5_noshield c_width=5u c_length=5u
X1952 a_88109_80239# VSS cap_mim_2f0_m4m5_noshield c_width=5u c_length=5u
X1953 a_3540_180844# VSS cap_mim_2f0_m4m5_noshield c_width=5u c_length=5u
X1954 a_3540_180844# VSS cap_mim_2f0_m4m5_noshield c_width=5u c_length=5u
X1955 a_3540_180844# VSS cap_mim_2f0_m4m5_noshield c_width=5u c_length=5u
X1956 a_3540_180844# VSS cap_mim_2f0_m4m5_noshield c_width=5u c_length=5u
X1957 a_3540_180844# VSS cap_mim_2f0_m4m5_noshield c_width=5u c_length=5u
X1958 a_44105_7822# a_31785_19940# a_44105_15880# VDD pfet_03v3 ad=0.89p pd=4.89u as=0.89p ps=4.89u w=2u l=0.28u
X1959 a_88109_80239# VSS cap_mim_2f0_m4m5_noshield c_width=5u c_length=5u
X1960 a_3540_180844# VSS cap_mim_2f0_m4m5_noshield c_width=5u c_length=5u
X1961 a_3540_180844# VSS cap_mim_2f0_m4m5_noshield c_width=5u c_length=5u
X1962 a_3540_180844# VSS cap_mim_2f0_m4m5_noshield c_width=5u c_length=5u
X1963 a_73225_30440# FB.t3 VDD VDD pfet_03v3 ad=1.78p pd=8.89u as=1.78p ps=8.89u w=4u l=0.28u
X1964 a_3540_180844# VSS cap_mim_2f0_m4m5_noshield c_width=5u c_length=5u
X1965 a_3540_180844# VSS cap_mim_2f0_m4m5_noshield c_width=5u c_length=5u
X1966 a_3540_180844# VSS cap_mim_2f0_m4m5_noshield c_width=5u c_length=5u
X1967 a_3540_181966.t7 VSS cap_mim_2f0_m4m5_noshield c_width=5u c_length=5u
X1968 a_3540_180844# VSS cap_mim_2f0_m4m5_noshield c_width=5u c_length=5u
X1969 a_3540_180844# VSS cap_mim_2f0_m4m5_noshield c_width=5u c_length=5u
X1970 a_3540_180844# VSS cap_mim_2f0_m4m5_noshield c_width=5u c_length=5u
X1971 a_3540_180844# VSS cap_mim_2f0_m4m5_noshield c_width=5u c_length=5u
X1972 a_3540_180844# VSS cap_mim_2f0_m4m5_noshield c_width=5u c_length=5u
X1973 a_3540_180844# VSS cap_mim_2f0_m4m5_noshield c_width=5u c_length=5u
X1974 a_31785_45000# a_30105_36740# VSS VSS nfet_03v3 ad=0.445p pd=2.89u as=0.445p ps=2.89u w=1u l=0.28u
X1975 a_3540_180844# VSS cap_mim_2f0_m4m5_noshield c_width=5u c_length=5u
X1976 a_3540_180844# VSS cap_mim_2f0_m4m5_noshield c_width=5u c_length=5u
X1977 a_3540_180844# VSS cap_mim_2f0_m4m5_noshield c_width=5u c_length=5u
X1978 a_3540_180844# VSS cap_mim_2f0_m4m5_noshield c_width=5u c_length=5u
X1979 a_3540_180844# VSS cap_mim_2f0_m4m5_noshield c_width=5u c_length=5u
X1980 a_3540_180844# VSS cap_mim_2f0_m4m5_noshield c_width=5u c_length=5u
X1981 a_3540_180844# VSS cap_mim_2f0_m4m5_noshield c_width=5u c_length=5u
X1982 a_3540_180844# VSS cap_mim_2f0_m4m5_noshield c_width=5u c_length=5u
X1983 a_3540_180844# VSS cap_mim_2f0_m4m5_noshield c_width=5u c_length=5u
X1984 a_3540_180844# VSS cap_mim_2f0_m4m5_noshield c_width=5u c_length=5u
X1985 a_3540_180844# VSS cap_mim_2f0_m4m5_noshield c_width=5u c_length=5u
X1986 a_3540_180844# VSS cap_mim_2f0_m4m5_noshield c_width=5u c_length=5u
X1987 a_3540_180844# VSS cap_mim_2f0_m4m5_noshield c_width=5u c_length=5u
X1988 a_88109_80239# VSS cap_mim_2f0_m4m5_noshield c_width=5u c_length=5u
X1989 a_3540_180844# VSS cap_mim_2f0_m4m5_noshield c_width=5u c_length=5u
X1990 a_3540_180844# VSS cap_mim_2f0_m4m5_noshield c_width=5u c_length=5u
X1991 a_3540_180844# VSS cap_mim_2f0_m4m5_noshield c_width=5u c_length=5u
X1992 a_3540_181966.t7 VSS cap_mim_2f0_m4m5_noshield c_width=5u c_length=5u
X1993 a_3540_180844# VSS cap_mim_2f0_m4m5_noshield c_width=5u c_length=5u
X1994 a_3540_180844# VSS cap_mim_2f0_m4m5_noshield c_width=5u c_length=5u
X1995 a_3540_180844# VSS cap_mim_2f0_m4m5_noshield c_width=5u c_length=5u
X1996 a_3540_180844# VSS cap_mim_2f0_m4m5_noshield c_width=5u c_length=5u
X1997 a_3540_180844# VSS cap_mim_2f0_m4m5_noshield c_width=5u c_length=5u
X1998 a_3540_180844# VSS cap_mim_2f0_m4m5_noshield c_width=5u c_length=5u
X1999 a_43987_83109# FB.t7 VDD VDD pfet_03v3 ad=0.89p pd=4.89u as=0.89p ps=4.89u w=2u l=0.28u
X2000 a_3540_180844# VSS cap_mim_2f0_m4m5_noshield c_width=5u c_length=5u
X2001 a_3540_180844# VSS cap_mim_2f0_m4m5_noshield c_width=5u c_length=5u
X2002 a_3540_180844# VSS cap_mim_2f0_m4m5_noshield c_width=5u c_length=5u
X2003 a_3540_180844# VSS cap_mim_2f0_m4m5_noshield c_width=5u c_length=5u
X2004 a_3540_180844# VSS cap_mim_2f0_m4m5_noshield c_width=5u c_length=5u
X2005 VDD PB.t26 a_87640_80239# VDD pfet_03v3 ad=2.12p pd=8.53u as=2.12p ps=8.53u w=8u l=2u
X2006 a_3540_180844# VSS cap_mim_2f0_m4m5_noshield c_width=5u c_length=5u
X2007 a_3540_180844# VSS cap_mim_2f0_m4m5_noshield c_width=5u c_length=5u
X2008 a_3540_180844# VSS cap_mim_2f0_m4m5_noshield c_width=5u c_length=5u
X2009 a_3540_180844# VSS cap_mim_2f0_m4m5_noshield c_width=5u c_length=5u
X2010 a_3540_181966.t7 VSS cap_mim_2f0_m4m5_noshield c_width=5u c_length=5u
X2011 a_3540_180844# VSS cap_mim_2f0_m4m5_noshield c_width=5u c_length=5u
X2012 a_3540_180844# VSS cap_mim_2f0_m4m5_noshield c_width=5u c_length=5u
X2013 a_3540_180844# VSS cap_mim_2f0_m4m5_noshield c_width=5u c_length=5u
X2014 LO a_17667_11569# cap_mim_2f0_m4m5_noshield c_width=5u c_length=5u
X2015 a_3540_180844# VSS cap_mim_2f0_m4m5_noshield c_width=5u c_length=5u
X2016 a_57987_8209# a_45785_19940# a_57960_11680# VSS nfet_03v3 ad=0.6675p pd=3.89u as=0.6675p ps=3.89u w=1.5u l=0.28u
X2017 a_3540_180844# VSS cap_mim_2f0_m4m5_noshield c_width=5u c_length=5u
X2018 a_3540_180844# VSS cap_mim_2f0_m4m5_noshield c_width=5u c_length=5u
X2019 a_3540_180844# VSS cap_mim_2f0_m4m5_noshield c_width=5u c_length=5u
X2020 a_3540_180844# VSS cap_mim_2f0_m4m5_noshield c_width=5u c_length=5u
X2021 a_3540_180844# VSS cap_mim_2f0_m4m5_noshield c_width=5u c_length=5u
X2022 a_3540_181966.t7 VSS cap_mim_2f0_m4m5_noshield c_width=5u c_length=5u
X2023 a_3540_180844# VSS cap_mim_2f0_m4m5_noshield c_width=5u c_length=5u
X2024 a_89421_69640# NB.t11 VSS VSS nfet_03v3 ad=2.12p pd=8.53u as=2.12p ps=8.53u w=8u l=2u
X2025 a_3540_180844# VSS cap_mim_2f0_m4m5_noshield c_width=5u c_length=5u
X2026 a_3540_180844# VSS cap_mim_2f0_m4m5_noshield c_width=5u c_length=5u
X2027 a_89421_74820# a_92189_81289# a_89880_80239# VDD pfet_03v3 ad=2.67p pd=12.89u as=1.59p ps=6.53u w=6u l=0.28u
X2028 a_3540_180844# VSS cap_mim_2f0_m4m5_noshield c_width=5u c_length=5u
X2029 a_3540_180844# VSS cap_mim_2f0_m4m5_noshield c_width=5u c_length=5u
X2030 a_89421_74820# PB.t3 VDD VDD pfet_03v3 ad=2.12p pd=8.53u as=2.12p ps=8.53u w=8u l=2u
X2031 a_3540_180844# VSS cap_mim_2f0_m4m5_noshield c_width=5u c_length=5u
X2032 a_3540_180844# VSS cap_mim_2f0_m4m5_noshield c_width=5u c_length=5u
X2033 a_3540_180844# VSS cap_mim_2f0_m4m5_noshield c_width=5u c_length=5u
X2034 a_3540_180844# VSS cap_mim_2f0_m4m5_noshield c_width=5u c_length=5u
X2035 a_3540_180844# VSS cap_mim_2f0_m4m5_noshield c_width=5u c_length=5u
X2036 a_3540_180844# VSS cap_mim_2f0_m4m5_noshield c_width=5u c_length=5u
X2037 REFIN a_3667_12409# cap_mim_2f0_m4m5_noshield c_width=5u c_length=5u
X2038 a_3540_180844# VSS cap_mim_2f0_m4m5_noshield c_width=5u c_length=5u
X2039 a_8580_18186# a_9000_16064# VSS ppolyf_u_1k r_width=1u r_length=10u
X2040 a_3540_180844# VSS cap_mim_2f0_m4m5_noshield c_width=5u c_length=5u
X2041 a_3540_180844# VSS cap_mim_2f0_m4m5_noshield c_width=5u c_length=5u
X2042 a_3540_180844# VSS cap_mim_2f0_m4m5_noshield c_width=5u c_length=5u
X2043 a_3540_180844# VSS cap_mim_2f0_m4m5_noshield c_width=5u c_length=5u
X2044 a_3540_180844# VSS cap_mim_2f0_m4m5_noshield c_width=5u c_length=5u
X2045 a_3540_180844# VSS cap_mim_2f0_m4m5_noshield c_width=5u c_length=5u
X2046 a_3540_180844# VSS cap_mim_2f0_m4m5_noshield c_width=5u c_length=5u
X2047 a_3540_180844# VSS cap_mim_2f0_m4m5_noshield c_width=5u c_length=5u
X2048 a_3540_180844# VSS cap_mim_2f0_m4m5_noshield c_width=5u c_length=5u
X2049 a_3540_180844# VSS cap_mim_2f0_m4m5_noshield c_width=5u c_length=5u
X2050 a_3540_180844# VSS cap_mim_2f0_m4m5_noshield c_width=5u c_length=5u
X2051 a_39625_32882# a_31785_45000# VSS VSS nfet_03v3 ad=0.445p pd=2.89u as=0.445p ps=2.89u w=1u l=0.28u
X2052 a_3540_180844# VSS cap_mim_2f0_m4m5_noshield c_width=5u c_length=5u
X2053 a_3540_180844# VSS cap_mim_2f0_m4m5_noshield c_width=5u c_length=5u
X2054 a_3540_180844# VSS cap_mim_2f0_m4m5_noshield c_width=5u c_length=5u
X2055 a_43987_62389# a_53507_83249# a_67480_61800# VSS nfet_03v3 ad=0.89p pd=4.89u as=0.89p ps=4.89u w=2u l=0.28u
X2056 a_3540_180844# VSS cap_mim_2f0_m4m5_noshield c_width=5u c_length=5u
X2057 a_3540_180844# VSS cap_mim_2f0_m4m5_noshield c_width=5u c_length=5u
X2058 a_3540_180844# VSS cap_mim_2f0_m4m5_noshield c_width=5u c_length=5u
X2059 a_3540_180844# VSS cap_mim_2f0_m4m5_noshield c_width=5u c_length=5u
X2060 a_3540_180844# VSS cap_mim_2f0_m4m5_noshield c_width=5u c_length=5u
X2061 a_3540_180844# VSS cap_mim_2f0_m4m5_noshield c_width=5u c_length=5u
X2062 a_3540_180844# VSS cap_mim_2f0_m4m5_noshield c_width=5u c_length=5u
X2063 a_3540_180844# VSS cap_mim_2f0_m4m5_noshield c_width=5u c_length=5u
X2064 a_3540_180844# VSS cap_mim_2f0_m4m5_noshield c_width=5u c_length=5u
X2065 a_57987_20669# a_58105_7822# a_59640_7480# VSS nfet_03v3 ad=0.6675p pd=3.89u as=0.6675p ps=3.89u w=1.5u l=0.28u
X2066 a_3540_181966.t7 VSS cap_mim_2f0_m4m5_noshield c_width=5u c_length=5u
X2067 VDD PB.t22 a_87640_80239# VDD pfet_03v3 ad=2.12p pd=8.53u as=2.12p ps=8.53u w=8u l=2u
X2068 a_3540_180844# VSS cap_mim_2f0_m4m5_noshield c_width=5u c_length=5u
X2069 a_3540_180844# VSS cap_mim_2f0_m4m5_noshield c_width=5u c_length=5u
X2070 a_3540_180844# VSS cap_mim_2f0_m4m5_noshield c_width=5u c_length=5u
X2071 a_3540_180844# VSS cap_mim_2f0_m4m5_noshield c_width=5u c_length=5u
X2072 a_3540_180844# VSS cap_mim_2f0_m4m5_noshield c_width=5u c_length=5u
X2073 a_3540_180844# VSS cap_mim_2f0_m4m5_noshield c_width=5u c_length=5u
X2074 a_3540_181966.t7 VSS cap_mim_2f0_m4m5_noshield c_width=5u c_length=5u
X2075 a_3540_180844# VSS cap_mim_2f0_m4m5_noshield c_width=5u c_length=5u
X2076 a_3540_180844# VSS cap_mim_2f0_m4m5_noshield c_width=5u c_length=5u
X2077 a_3540_180844# VSS cap_mim_2f0_m4m5_noshield c_width=5u c_length=5u
X2078 a_3540_180844# VSS cap_mim_2f0_m4m5_noshield c_width=5u c_length=5u
X2079 a_3540_180844# VSS cap_mim_2f0_m4m5_noshield c_width=5u c_length=5u
X2080 a_3540_180844# VSS cap_mim_2f0_m4m5_noshield c_width=5u c_length=5u
X2081 a_3540_180844# VSS cap_mim_2f0_m4m5_noshield c_width=5u c_length=5u
X2082 a_3540_180844# VSS cap_mim_2f0_m4m5_noshield c_width=5u c_length=5u
X2083 a_3540_181966.t4 VCTRL.t0 VSS ppolyf_u_1k r_width=2u r_length=2u
X2084 a_3540_180844# VSS cap_mim_2f0_m4m5_noshield c_width=5u c_length=5u
X2085 a_3540_180844# VSS cap_mim_2f0_m4m5_noshield c_width=5u c_length=5u
X2086 a_3540_180844# VSS cap_mim_2f0_m4m5_noshield c_width=5u c_length=5u
X2087 a_3540_180844# VSS cap_mim_2f0_m4m5_noshield c_width=5u c_length=5u
X2088 a_3540_180844# VSS cap_mim_2f0_m4m5_noshield c_width=5u c_length=5u
X2089 a_3540_180844# VSS cap_mim_2f0_m4m5_noshield c_width=5u c_length=5u
X2090 a_3540_181966.t7 VSS cap_mim_2f0_m4m5_noshield c_width=5u c_length=5u
X2091 a_3540_180844# VSS cap_mim_2f0_m4m5_noshield c_width=5u c_length=5u
X2092 a_3540_180844# VSS cap_mim_2f0_m4m5_noshield c_width=5u c_length=5u
X2093 a_3540_180844# VSS cap_mim_2f0_m4m5_noshield c_width=5u c_length=5u
X2094 a_3540_180844# VSS cap_mim_2f0_m4m5_noshield c_width=5u c_length=5u
X2095 a_3540_180844# VSS cap_mim_2f0_m4m5_noshield c_width=5u c_length=5u
X2096 a_3540_180844# VSS cap_mim_2f0_m4m5_noshield c_width=5u c_length=5u
X2097 a_88109_80239# VSS cap_mim_2f0_m4m5_noshield c_width=5u c_length=5u
X2098 a_3540_180844# VSS cap_mim_2f0_m4m5_noshield c_width=5u c_length=5u
X2099 a_3540_180844# VSS cap_mim_2f0_m4m5_noshield c_width=5u c_length=5u
X2100 a_63000_32540# a_31785_45000# VSS VSS nfet_03v3 ad=0.6675p pd=3.89u as=0.6675p ps=3.89u w=1.5u l=0.28u
X2101 a_3540_180844# VSS cap_mim_2f0_m4m5_noshield c_width=5u c_length=5u
X2102 a_3540_181966.t7 VSS cap_mim_2f0_m4m5_noshield c_width=5u c_length=5u
X2103 a_3540_180844# VSS cap_mim_2f0_m4m5_noshield c_width=5u c_length=5u
X2104 a_3540_180844# VSS cap_mim_2f0_m4m5_noshield c_width=5u c_length=5u
X2105 a_3540_180844# VSS cap_mim_2f0_m4m5_noshield c_width=5u c_length=5u
X2106 a_3540_180844# VSS cap_mim_2f0_m4m5_noshield c_width=5u c_length=5u
X2107 a_3540_180844# VSS cap_mim_2f0_m4m5_noshield c_width=5u c_length=5u
X2108 a_3540_180844# VSS cap_mim_2f0_m4m5_noshield c_width=5u c_length=5u
X2109 a_3540_180844# VSS cap_mim_2f0_m4m5_noshield c_width=5u c_length=5u
X2110 a_3540_180844# VSS cap_mim_2f0_m4m5_noshield c_width=5u c_length=5u
X2111 a_3540_180844# VSS cap_mim_2f0_m4m5_noshield c_width=5u c_length=5u
X2112 a_3540_180844# VSS cap_mim_2f0_m4m5_noshield c_width=5u c_length=5u
X2113 a_3540_180844# VSS cap_mim_2f0_m4m5_noshield c_width=5u c_length=5u
X2114 a_3540_180844# VSS cap_mim_2f0_m4m5_noshield c_width=5u c_length=5u
X2115 a_3540_180844# VSS cap_mim_2f0_m4m5_noshield c_width=5u c_length=5u
X2116 a_36825_105682.t1 a_36707_106069.t10 VDD VDD pfet_03v3 ad=0.89p pd=4.89u as=0.89p ps=4.89u w=2u l=0.28u
X2117 a_3540_180844# VSS cap_mim_2f0_m4m5_noshield c_width=5u c_length=5u
X2118 a_3540_180844# VSS cap_mim_2f0_m4m5_noshield c_width=5u c_length=5u
X2119 a_3540_180844# VSS cap_mim_2f0_m4m5_noshield c_width=5u c_length=5u
X2120 a_3540_181966.t7 VSS cap_mim_2f0_m4m5_noshield c_width=5u c_length=5u
X2121 a_3540_180844# VSS cap_mim_2f0_m4m5_noshield c_width=5u c_length=5u
X2122 a_3540_180844# VSS cap_mim_2f0_m4m5_noshield c_width=5u c_length=5u
X2123 a_5907_106069.t1 a_8265_82520.t4 VDD VDD pfet_03v3 ad=0.89p pd=4.89u as=0.89p ps=4.89u w=2u l=0.28u
X2124 a_3540_180844# VSS cap_mim_2f0_m4m5_noshield c_width=5u c_length=5u
X2125 a_3540_180844# VSS cap_mim_2f0_m4m5_noshield c_width=5u c_length=5u
X2126 a_3540_180844# VSS cap_mim_2f0_m4m5_noshield c_width=5u c_length=5u
X2127 a_3540_180844# VSS cap_mim_2f0_m4m5_noshield c_width=5u c_length=5u
X2128 a_3540_180844# VSS cap_mim_2f0_m4m5_noshield c_width=5u c_length=5u
X2129 a_3540_180844# VSS cap_mim_2f0_m4m5_noshield c_width=5u c_length=5u
X2130 a_3540_180844# VSS cap_mim_2f0_m4m5_noshield c_width=5u c_length=5u
X2131 a_3540_180844# VSS cap_mim_2f0_m4m5_noshield c_width=5u c_length=5u
X2132 a_30105_15880# a_29987_8209# VDD VDD pfet_03v3 ad=0.89p pd=4.89u as=0.89p ps=4.89u w=2u l=0.28u
X2133 a_3540_180844# VSS cap_mim_2f0_m4m5_noshield c_width=5u c_length=5u
X2134 a_3540_180844# VSS cap_mim_2f0_m4m5_noshield c_width=5u c_length=5u
X2135 a_3540_180844# VSS cap_mim_2f0_m4m5_noshield c_width=5u c_length=5u
X2136 a_3540_180844# VSS cap_mim_2f0_m4m5_noshield c_width=5u c_length=5u
X2137 a_3540_180844# VSS cap_mim_2f0_m4m5_noshield c_width=5u c_length=5u
X2138 a_3540_180844# VSS cap_mim_2f0_m4m5_noshield c_width=5u c_length=5u
X2139 a_3540_181966.t7 VSS cap_mim_2f0_m4m5_noshield c_width=5u c_length=5u
X2140 a_31640_61800# a_15987_66729.t3 VSS VSS nfet_03v3 ad=0.89p pd=4.89u as=0.89p ps=4.89u w=2u l=0.28u
X2141 a_3540_180844# VSS cap_mim_2f0_m4m5_noshield c_width=5u c_length=5u
X2142 a_3540_181966.t7 VSS cap_mim_2f0_m4m5_noshield c_width=5u c_length=5u
X2143 a_3540_180844# VSS cap_mim_2f0_m4m5_noshield c_width=5u c_length=5u
X2144 a_3540_180844# VSS cap_mim_2f0_m4m5_noshield c_width=5u c_length=5u
X2145 a_3540_180844# VSS cap_mim_2f0_m4m5_noshield c_width=5u c_length=5u
X2146 a_3540_180844# VSS cap_mim_2f0_m4m5_noshield c_width=5u c_length=5u
X2147 a_57987_8209# a_57987_20669# VDD VDD pfet_03v3 ad=1.335p pd=6.89u as=1.335p ps=6.89u w=3u l=0.28u
X2148 a_3540_180844# VSS cap_mim_2f0_m4m5_noshield c_width=5u c_length=5u
X2149 a_3540_180844# VSS cap_mim_2f0_m4m5_noshield c_width=5u c_length=5u
X2150 a_3540_180844# VSS cap_mim_2f0_m4m5_noshield c_width=5u c_length=5u
X2151 a_3540_181966.t7 VSS cap_mim_2f0_m4m5_noshield c_width=5u c_length=5u
X2152 a_3540_180844# VSS cap_mim_2f0_m4m5_noshield c_width=5u c_length=5u
X2153 a_3540_180844# VSS cap_mim_2f0_m4m5_noshield c_width=5u c_length=5u
X2154 VSS NB.t2 a_89421_69640# VSS nfet_03v3 ad=2.12p pd=8.53u as=2.12p ps=8.53u w=8u l=2u
X2155 a_3540_180844# VSS cap_mim_2f0_m4m5_noshield c_width=5u c_length=5u
X2156 a_3540_180844# VSS cap_mim_2f0_m4m5_noshield c_width=5u c_length=5u
X2157 a_3540_180844# VSS cap_mim_2f0_m4m5_noshield c_width=5u c_length=5u
X2158 a_3540_180844# VSS cap_mim_2f0_m4m5_noshield c_width=5u c_length=5u
X2159 a_3540_180844# VSS cap_mim_2f0_m4m5_noshield c_width=5u c_length=5u
X2160 a_3540_180844# VSS cap_mim_2f0_m4m5_noshield c_width=5u c_length=5u
X2161 a_3540_180844# VSS cap_mim_2f0_m4m5_noshield c_width=5u c_length=5u
X2162 a_3540_180844# VSS cap_mim_2f0_m4m5_noshield c_width=5u c_length=5u
X2163 a_3540_180844# VSS cap_mim_2f0_m4m5_noshield c_width=5u c_length=5u
X2164 a_59640_7480# a_45785_19940# VSS VSS nfet_03v3 ad=0.6675p pd=3.89u as=0.6675p ps=3.89u w=1.5u l=0.28u
X2165 a_3540_180844# VSS cap_mim_2f0_m4m5_noshield c_width=5u c_length=5u
X2166 a_3540_180844# VSS cap_mim_2f0_m4m5_noshield c_width=5u c_length=5u
X2167 a_3540_180844# VSS cap_mim_2f0_m4m5_noshield c_width=5u c_length=5u
X2168 a_3540_180844# VSS cap_mim_2f0_m4m5_noshield c_width=5u c_length=5u
X2169 a_3540_180844# VSS cap_mim_2f0_m4m5_noshield c_width=5u c_length=5u
X2170 a_3540_180844# VSS cap_mim_2f0_m4m5_noshield c_width=5u c_length=5u
X2171 VSS NB.t14 a_89421_69640# VSS nfet_03v3 ad=2.12p pd=8.53u as=2.12p ps=8.53u w=8u l=2u
X2172 a_3540_180844# VSS cap_mim_2f0_m4m5_noshield c_width=5u c_length=5u
X2173 a_3540_180844# VSS cap_mim_2f0_m4m5_noshield c_width=5u c_length=5u
X2174 a_3540_180844# VSS cap_mim_2f0_m4m5_noshield c_width=5u c_length=5u
X2175 a_3540_180844# VSS cap_mim_2f0_m4m5_noshield c_width=5u c_length=5u
X2176 a_3540_180844# VSS cap_mim_2f0_m4m5_noshield c_width=5u c_length=5u
X2177 a_8147_83109# a_8265_61800# VDD VDD pfet_03v3 ad=0.89p pd=4.89u as=0.89p ps=4.89u w=2u l=0.28u
X2178 a_3540_180844# VSS cap_mim_2f0_m4m5_noshield c_width=5u c_length=5u
X2179 a_3540_181966.t7 VSS cap_mim_2f0_m4m5_noshield c_width=5u c_length=5u
X2180 a_3540_181966.t7 VSS cap_mim_2f0_m4m5_noshield c_width=5u c_length=5u
X2181 a_3540_181966.t7 VSS cap_mim_2f0_m4m5_noshield c_width=5u c_length=5u
X2182 a_3540_180844# VSS cap_mim_2f0_m4m5_noshield c_width=5u c_length=5u
X2183 a_3540_180844# VSS cap_mim_2f0_m4m5_noshield c_width=5u c_length=5u
X2184 a_3540_180844# VSS cap_mim_2f0_m4m5_noshield c_width=5u c_length=5u
X2185 a_3540_180844# VSS cap_mim_2f0_m4m5_noshield c_width=5u c_length=5u
X2186 a_3540_180844# VSS cap_mim_2f0_m4m5_noshield c_width=5u c_length=5u
X2187 a_3540_180844# VSS cap_mim_2f0_m4m5_noshield c_width=5u c_length=5u
X2188 a_3540_180844# VSS cap_mim_2f0_m4m5_noshield c_width=5u c_length=5u
X2189 a_3540_180844# VSS cap_mim_2f0_m4m5_noshield c_width=5u c_length=5u
X2190 a_3540_180844# VSS cap_mim_2f0_m4m5_noshield c_width=5u c_length=5u
X2191 a_3540_180844# VSS cap_mim_2f0_m4m5_noshield c_width=5u c_length=5u
X2192 a_3540_180844# VSS cap_mim_2f0_m4m5_noshield c_width=5u c_length=5u
X2193 a_3540_180844# VSS cap_mim_2f0_m4m5_noshield c_width=5u c_length=5u
X2194 VDD PB.t8 a_87640_80239# VDD pfet_03v3 ad=2.12p pd=8.53u as=2.12p ps=8.53u w=8u l=2u
X2195 a_43987_62389# a_53507_83249# VDD VDD pfet_03v3 ad=0.89p pd=4.89u as=0.89p ps=4.89u w=2u l=0.28u
X2196 a_51945_86720# a_15987_66729.t10 VSS VSS nfet_03v3 ad=1.335p pd=6.89u as=1.335p ps=6.89u w=3u l=0.28u
X2197 a_3540_180844# VSS cap_mim_2f0_m4m5_noshield c_width=5u c_length=5u
X2198 a_3540_180844# VSS cap_mim_2f0_m4m5_noshield c_width=5u c_length=5u
X2199 a_3540_180844# VSS cap_mim_2f0_m4m5_noshield c_width=5u c_length=5u
X2200 a_3540_180844# VSS cap_mim_2f0_m4m5_noshield c_width=5u c_length=5u
X2201 a_3540_180844# VSS cap_mim_2f0_m4m5_noshield c_width=5u c_length=5u
X2202 a_3540_180844# VSS cap_mim_2f0_m4m5_noshield c_width=5u c_length=5u
X2203 a_3540_180844# VSS cap_mim_2f0_m4m5_noshield c_width=5u c_length=5u
X2204 a_3540_180844# VSS cap_mim_2f0_m4m5_noshield c_width=5u c_length=5u
X2205 a_3540_180844# VSS cap_mim_2f0_m4m5_noshield c_width=5u c_length=5u
X2206 a_3540_180844# VSS cap_mim_2f0_m4m5_noshield c_width=5u c_length=5u
X2207 a_3540_180844# VSS cap_mim_2f0_m4m5_noshield c_width=5u c_length=5u
X2208 a_3540_180844# VSS cap_mim_2f0_m4m5_noshield c_width=5u c_length=5u
X2209 a_3540_180844# VSS cap_mim_2f0_m4m5_noshield c_width=5u c_length=5u
X2210 a_3540_180844# VSS cap_mim_2f0_m4m5_noshield c_width=5u c_length=5u
X2211 a_61347_33269# a_31785_45000# a_61320_36740# VSS nfet_03v3 ad=0.6675p pd=3.89u as=0.6675p ps=3.89u w=1.5u l=0.28u
X2212 a_3540_180844# VSS cap_mim_2f0_m4m5_noshield c_width=5u c_length=5u
X2213 a_3540_180844# VSS cap_mim_2f0_m4m5_noshield c_width=5u c_length=5u
X2214 a_3540_180844# VSS cap_mim_2f0_m4m5_noshield c_width=5u c_length=5u
X2215 a_3540_180844# VSS cap_mim_2f0_m4m5_noshield c_width=5u c_length=5u
X2216 a_3540_180844# VSS cap_mim_2f0_m4m5_noshield c_width=5u c_length=5u
X2217 a_3540_180844# VSS cap_mim_2f0_m4m5_noshield c_width=5u c_length=5u
X2218 a_3540_180844# VSS cap_mim_2f0_m4m5_noshield c_width=5u c_length=5u
X2219 a_3540_180844# VSS cap_mim_2f0_m4m5_noshield c_width=5u c_length=5u
X2220 a_11100_18186# a_10680_16064# VSS ppolyf_u_1k r_width=1u r_length=10u
X2221 a_3540_180844# VSS cap_mim_2f0_m4m5_noshield c_width=5u c_length=5u
X2222 a_3540_180844# VSS cap_mim_2f0_m4m5_noshield c_width=5u c_length=5u
X2223 a_3540_180844# VSS cap_mim_2f0_m4m5_noshield c_width=5u c_length=5u
X2224 a_8147_83109# a_15987_66729.t9 VDD VDD pfet_03v3 ad=0.89p pd=4.89u as=0.89p ps=4.89u w=2u l=0.28u
X2225 FB.t1 a_61347_33269# VDD VDD pfet_03v3 ad=0.89p pd=4.89u as=0.89p ps=4.89u w=2u l=0.28u
X2226 a_3540_180844# VSS cap_mim_2f0_m4m5_noshield c_width=5u c_length=5u
X2227 a_61347_45729# a_31785_45000# VDD VDD pfet_03v3 ad=0.89p pd=4.89u as=0.89p ps=4.89u w=2u l=0.28u
X2228 a_3540_180844# VSS cap_mim_2f0_m4m5_noshield c_width=5u c_length=5u
X2229 a_3540_180844# VSS cap_mim_2f0_m4m5_noshield c_width=5u c_length=5u
X2230 a_3540_180844# VSS cap_mim_2f0_m4m5_noshield c_width=5u c_length=5u
X2231 a_3540_180844# VSS cap_mim_2f0_m4m5_noshield c_width=5u c_length=5u
X2232 a_3540_180844# VSS cap_mim_2f0_m4m5_noshield c_width=5u c_length=5u
X2233 a_3540_180844# VSS cap_mim_2f0_m4m5_noshield c_width=5u c_length=5u
X2234 a_3540_180844# VSS cap_mim_2f0_m4m5_noshield c_width=5u c_length=5u
X2235 a_3540_180844# VSS cap_mim_2f0_m4m5_noshield c_width=5u c_length=5u
X2236 a_3540_180844# VSS cap_mim_2f0_m4m5_noshield c_width=5u c_length=5u
X2237 a_3540_180844# VSS cap_mim_2f0_m4m5_noshield c_width=5u c_length=5u
X2238 a_3540_180844# VSS cap_mim_2f0_m4m5_noshield c_width=5u c_length=5u
X2239 a_3540_181966.t7 VSS cap_mim_2f0_m4m5_noshield c_width=5u c_length=5u
X2240 a_3540_180844# VSS cap_mim_2f0_m4m5_noshield c_width=5u c_length=5u
X2241 a_3540_180844# VSS cap_mim_2f0_m4m5_noshield c_width=5u c_length=5u
X2242 a_43960_82520# a_45667_83109# VSS VSS nfet_03v3 ad=0.89p pd=4.89u as=0.89p ps=4.89u w=2u l=0.28u
X2243 a_3540_180844# VSS cap_mim_2f0_m4m5_noshield c_width=5u c_length=5u
X2244 a_3540_180844# VSS cap_mim_2f0_m4m5_noshield c_width=5u c_length=5u
X2245 a_3540_181966.t7 VSS cap_mim_2f0_m4m5_noshield c_width=5u c_length=5u
X2246 a_3540_180844# VSS cap_mim_2f0_m4m5_noshield c_width=5u c_length=5u
X2247 a_3540_180844# VSS cap_mim_2f0_m4m5_noshield c_width=5u c_length=5u
X2248 a_3540_180844# VSS cap_mim_2f0_m4m5_noshield c_width=5u c_length=5u
X2249 a_3540_180844# VSS cap_mim_2f0_m4m5_noshield c_width=5u c_length=5u
X2250 a_3540_180844# VSS cap_mim_2f0_m4m5_noshield c_width=5u c_length=5u
X2251 a_3540_180844# VSS cap_mim_2f0_m4m5_noshield c_width=5u c_length=5u
X2252 a_3540_180844# VSS cap_mim_2f0_m4m5_noshield c_width=5u c_length=5u
X2253 a_3540_180844# VSS cap_mim_2f0_m4m5_noshield c_width=5u c_length=5u
X2254 a_3540_180844# VSS cap_mim_2f0_m4m5_noshield c_width=5u c_length=5u
X2255 a_3540_180844# VSS cap_mim_2f0_m4m5_noshield c_width=5u c_length=5u
X2256 a_3540_180844# VSS cap_mim_2f0_m4m5_noshield c_width=5u c_length=5u
X2257 a_3540_180844# VSS cap_mim_2f0_m4m5_noshield c_width=5u c_length=5u
X2258 a_3540_180844# VSS cap_mim_2f0_m4m5_noshield c_width=5u c_length=5u
X2259 a_3540_180844# VSS cap_mim_2f0_m4m5_noshield c_width=5u c_length=5u
X2260 a_3540_180844# VSS cap_mim_2f0_m4m5_noshield c_width=5u c_length=5u
X2261 a_3540_180844# VSS cap_mim_2f0_m4m5_noshield c_width=5u c_length=5u
X2262 a_3540_180844# VSS cap_mim_2f0_m4m5_noshield c_width=5u c_length=5u
X2263 a_3540_181966.t6 VSS cap_mim_2f0_m4m5_noshield c_width=5u c_length=5u
X2264 a_3540_180844# VSS cap_mim_2f0_m4m5_noshield c_width=5u c_length=5u
X2265 a_3540_181966.t7 VSS cap_mim_2f0_m4m5_noshield c_width=5u c_length=5u
X2266 a_3540_180844# VSS cap_mim_2f0_m4m5_noshield c_width=5u c_length=5u
X2267 a_3540_180844# VSS cap_mim_2f0_m4m5_noshield c_width=5u c_length=5u
X2268 a_3540_180844# VSS cap_mim_2f0_m4m5_noshield c_width=5u c_length=5u
X2269 a_3540_180844# VSS cap_mim_2f0_m4m5_noshield c_width=5u c_length=5u
X2270 a_8147_62389# a_15987_66729.t6 VDD VDD pfet_03v3 ad=0.89p pd=4.89u as=0.89p ps=4.89u w=2u l=0.28u
X2271 a_3540_180844# VSS cap_mim_2f0_m4m5_noshield c_width=5u c_length=5u
X2272 VDD a_73225_30440# FS VDD pfet_03v3 ad=1.335p pd=6.89u as=0.795p ps=3.53u w=3u l=0.28u
X2273 a_3540_180844# VSS cap_mim_2f0_m4m5_noshield c_width=5u c_length=5u
X2274 a_3540_180844# VSS cap_mim_2f0_m4m5_noshield c_width=5u c_length=5u
X2275 a_3540_180844# VSS cap_mim_2f0_m4m5_noshield c_width=5u c_length=5u
X2276 a_3540_180844# VSS cap_mim_2f0_m4m5_noshield c_width=5u c_length=5u
X2277 a_3540_180844# VSS cap_mim_2f0_m4m5_noshield c_width=5u c_length=5u
X2278 a_3540_181966.t7 VSS cap_mim_2f0_m4m5_noshield c_width=5u c_length=5u
X2279 a_3540_180844# VSS cap_mim_2f0_m4m5_noshield c_width=5u c_length=5u
X2280 a_3540_180844# VSS cap_mim_2f0_m4m5_noshield c_width=5u c_length=5u
X2281 a_3540_180844# VSS cap_mim_2f0_m4m5_noshield c_width=5u c_length=5u
X2282 a_3540_180844# VSS cap_mim_2f0_m4m5_noshield c_width=5u c_length=5u
X2283 a_3540_180844# VSS cap_mim_2f0_m4m5_noshield c_width=5u c_length=5u
X2284 a_3540_180844# VSS cap_mim_2f0_m4m5_noshield c_width=5u c_length=5u
X2285 a_3540_180844# VSS cap_mim_2f0_m4m5_noshield c_width=5u c_length=5u
X2286 a_3540_180844# VSS cap_mim_2f0_m4m5_noshield c_width=5u c_length=5u
X2287 a_3540_180844# VSS cap_mim_2f0_m4m5_noshield c_width=5u c_length=5u
X2288 a_3540_180844# VSS cap_mim_2f0_m4m5_noshield c_width=5u c_length=5u
X2289 a_88109_80239# VSS cap_mim_2f0_m4m5_noshield c_width=5u c_length=5u
X2290 a_3540_180844# VSS cap_mim_2f0_m4m5_noshield c_width=5u c_length=5u
X2291 a_3540_180844# VSS cap_mim_2f0_m4m5_noshield c_width=5u c_length=5u
X2292 a_3540_180844# VSS cap_mim_2f0_m4m5_noshield c_width=5u c_length=5u
X2293 a_58105_7822# a_45785_19940# a_58105_15880# VDD pfet_03v3 ad=0.89p pd=4.89u as=0.89p ps=4.89u w=2u l=0.28u
X2294 a_3540_180844# VSS cap_mim_2f0_m4m5_noshield c_width=5u c_length=5u
X2295 a_3540_180844# VSS cap_mim_2f0_m4m5_noshield c_width=5u c_length=5u
X2296 a_3540_180844# VSS cap_mim_2f0_m4m5_noshield c_width=5u c_length=5u
X2297 a_3540_180844# VSS cap_mim_2f0_m4m5_noshield c_width=5u c_length=5u
X2298 a_3540_180844# VSS cap_mim_2f0_m4m5_noshield c_width=5u c_length=5u
X2299 a_3540_180844# VSS cap_mim_2f0_m4m5_noshield c_width=5u c_length=5u
X2300 a_3540_180844# VSS cap_mim_2f0_m4m5_noshield c_width=5u c_length=5u
X2301 a_3540_180844# VSS cap_mim_2f0_m4m5_noshield c_width=5u c_length=5u
X2302 a_3540_180844# VSS cap_mim_2f0_m4m5_noshield c_width=5u c_length=5u
X2303 a_3540_180844# VSS cap_mim_2f0_m4m5_noshield c_width=5u c_length=5u
X2304 a_3540_180844# VSS cap_mim_2f0_m4m5_noshield c_width=5u c_length=5u
X2305 a_3540_180844# VSS cap_mim_2f0_m4m5_noshield c_width=5u c_length=5u
X2306 a_3540_180844# VSS cap_mim_2f0_m4m5_noshield c_width=5u c_length=5u
X2307 a_3540_180844# VSS cap_mim_2f0_m4m5_noshield c_width=5u c_length=5u
X2308 a_3540_180844# VSS cap_mim_2f0_m4m5_noshield c_width=5u c_length=5u
X2309 a_3540_180844# VSS cap_mim_2f0_m4m5_noshield c_width=5u c_length=5u
X2310 a_3540_180844# VSS cap_mim_2f0_m4m5_noshield c_width=5u c_length=5u
X2311 a_3540_181966.t7 VSS cap_mim_2f0_m4m5_noshield c_width=5u c_length=5u
X2312 a_3540_181966.t7 VSS cap_mim_2f0_m4m5_noshield c_width=5u c_length=5u
X2313 a_3540_180844# VSS cap_mim_2f0_m4m5_noshield c_width=5u c_length=5u
X2314 a_3540_181966.t7 VSS cap_mim_2f0_m4m5_noshield c_width=5u c_length=5u
X2315 FS a_73225_30440# VDD VDD pfet_03v3 ad=0.795p pd=3.53u as=1.335p ps=6.89u w=3u l=0.28u
X2316 a_3540_180844# VSS cap_mim_2f0_m4m5_noshield c_width=5u c_length=5u
X2317 a_3540_180844# VSS cap_mim_2f0_m4m5_noshield c_width=5u c_length=5u
X2318 a_3540_180844# VSS cap_mim_2f0_m4m5_noshield c_width=5u c_length=5u
X2319 a_3540_180844# VSS cap_mim_2f0_m4m5_noshield c_width=5u c_length=5u
X2320 a_3540_180844# VSS cap_mim_2f0_m4m5_noshield c_width=5u c_length=5u
X2321 a_3540_180844# VSS cap_mim_2f0_m4m5_noshield c_width=5u c_length=5u
X2322 a_3540_180844# VSS cap_mim_2f0_m4m5_noshield c_width=5u c_length=5u
X2323 a_3540_181966.t7 VSS cap_mim_2f0_m4m5_noshield c_width=5u c_length=5u
X2324 a_3540_180844# VSS cap_mim_2f0_m4m5_noshield c_width=5u c_length=5u
X2325 a_3540_180844# VSS cap_mim_2f0_m4m5_noshield c_width=5u c_length=5u
X2326 a_3540_180844# VSS cap_mim_2f0_m4m5_noshield c_width=5u c_length=5u
X2327 a_3540_180844# VSS cap_mim_2f0_m4m5_noshield c_width=5u c_length=5u
X2328 a_3540_180844# VSS cap_mim_2f0_m4m5_noshield c_width=5u c_length=5u
X2329 a_3540_180844# VSS cap_mim_2f0_m4m5_noshield c_width=5u c_length=5u
X2330 a_3540_180844# VSS cap_mim_2f0_m4m5_noshield c_width=5u c_length=5u
X2331 a_3540_180844# VSS cap_mim_2f0_m4m5_noshield c_width=5u c_length=5u
X2332 VDD a_99409_69879# a_88109_80239# VDD pfet_03v3 ad=1.78p pd=8.89u as=1.06p ps=4.53u w=4u l=1u
X2333 a_3540_180844# VSS cap_mim_2f0_m4m5_noshield c_width=5u c_length=5u
X2334 a_3540_180844# VSS cap_mim_2f0_m4m5_noshield c_width=5u c_length=5u
X2335 a_3540_181966.t6 VSS cap_mim_2f0_m4m5_noshield c_width=5u c_length=5u
X2336 a_3540_181966.t7 VSS cap_mim_2f0_m4m5_noshield c_width=5u c_length=5u
X2337 a_3540_181966.t7 VSS cap_mim_2f0_m4m5_noshield c_width=5u c_length=5u
X2338 a_3540_180844# VSS cap_mim_2f0_m4m5_noshield c_width=5u c_length=5u
X2339 a_3540_180844# VSS cap_mim_2f0_m4m5_noshield c_width=5u c_length=5u
X2340 a_3540_180844# VSS cap_mim_2f0_m4m5_noshield c_width=5u c_length=5u
X2341 a_3540_180844# VSS cap_mim_2f0_m4m5_noshield c_width=5u c_length=5u
X2342 a_3540_180844# VSS cap_mim_2f0_m4m5_noshield c_width=5u c_length=5u
X2343 a_3540_180844# VSS cap_mim_2f0_m4m5_noshield c_width=5u c_length=5u
X2344 a_18345_105682# a_12185_105682# VDD VDD pfet_03v3 ad=0.89p pd=4.89u as=0.89p ps=4.89u w=2u l=0.28u
X2345 a_3540_180844# VSS cap_mim_2f0_m4m5_noshield c_width=5u c_length=5u
X2346 a_3540_180844# VSS cap_mim_2f0_m4m5_noshield c_width=5u c_length=5u
X2347 a_3540_180844# VSS cap_mim_2f0_m4m5_noshield c_width=5u c_length=5u
X2348 a_3540_180844# VSS cap_mim_2f0_m4m5_noshield c_width=5u c_length=5u
X2349 REFCK.t0 a_3540_16064# VSS VSS nfet_03v3 ad=0.89p pd=4.89u as=0.89p ps=4.89u w=2u l=0.28u
X2350 a_3540_180844# VSS cap_mim_2f0_m4m5_noshield c_width=5u c_length=5u
X2351 a_3540_180844# VSS cap_mim_2f0_m4m5_noshield c_width=5u c_length=5u
X2352 a_3540_180844# VSS cap_mim_2f0_m4m5_noshield c_width=5u c_length=5u
X2353 a_3540_180844# VSS cap_mim_2f0_m4m5_noshield c_width=5u c_length=5u
X2354 a_3540_180844# VSS cap_mim_2f0_m4m5_noshield c_width=5u c_length=5u
X2355 a_3540_180844# VSS cap_mim_2f0_m4m5_noshield c_width=5u c_length=5u
X2356 a_3540_180844# VSS cap_mim_2f0_m4m5_noshield c_width=5u c_length=5u
X2357 a_3540_180844# VSS cap_mim_2f0_m4m5_noshield c_width=5u c_length=5u
X2358 a_3540_180844# VSS cap_mim_2f0_m4m5_noshield c_width=5u c_length=5u
X2359 a_3540_180844# VSS cap_mim_2f0_m4m5_noshield c_width=5u c_length=5u
X2360 a_3540_180844# VSS cap_mim_2f0_m4m5_noshield c_width=5u c_length=5u
X2361 a_3540_180844# VSS cap_mim_2f0_m4m5_noshield c_width=5u c_length=5u
X2362 a_3540_180844# VSS cap_mim_2f0_m4m5_noshield c_width=5u c_length=5u
X2363 REFIN a_3667_12409# cap_mim_2f0_m4m5_noshield c_width=5u c_length=5u
X2364 a_3540_180844# VSS cap_mim_2f0_m4m5_noshield c_width=5u c_length=5u
X2365 a_3540_180844# VSS cap_mim_2f0_m4m5_noshield c_width=5u c_length=5u
X2366 a_3540_180844# VSS cap_mim_2f0_m4m5_noshield c_width=5u c_length=5u
X2367 a_3540_181966.t7 VSS cap_mim_2f0_m4m5_noshield c_width=5u c_length=5u
X2368 a_88109_80239# VSS cap_mim_2f0_m4m5_noshield c_width=5u c_length=5u
X2369 a_3540_180844# VSS cap_mim_2f0_m4m5_noshield c_width=5u c_length=5u
X2370 a_3540_181966.t7 VSS cap_mim_2f0_m4m5_noshield c_width=5u c_length=5u
X2371 a_3540_180844# VSS cap_mim_2f0_m4m5_noshield c_width=5u c_length=5u
X2372 a_3540_180844# VSS cap_mim_2f0_m4m5_noshield c_width=5u c_length=5u
X2373 a_36707_106069.t0 a_45667_83109# VDD VDD pfet_03v3 ad=0.89p pd=4.89u as=0.89p ps=4.89u w=2u l=0.28u
X2374 a_3540_180844# VSS cap_mim_2f0_m4m5_noshield c_width=5u c_length=5u
X2375 a_3540_180844# VSS cap_mim_2f0_m4m5_noshield c_width=5u c_length=5u
X2376 a_3540_180844# VSS cap_mim_2f0_m4m5_noshield c_width=5u c_length=5u
X2377 a_3540_180844# VSS cap_mim_2f0_m4m5_noshield c_width=5u c_length=5u
X2378 a_3540_180844# VSS cap_mim_2f0_m4m5_noshield c_width=5u c_length=5u
X2379 a_3540_180844# VSS cap_mim_2f0_m4m5_noshield c_width=5u c_length=5u
X2380 a_3540_181966.t7 VSS cap_mim_2f0_m4m5_noshield c_width=5u c_length=5u
X2381 a_3540_180844# VSS cap_mim_2f0_m4m5_noshield c_width=5u c_length=5u
X2382 a_3540_180844# VSS cap_mim_2f0_m4m5_noshield c_width=5u c_length=5u
X2383 a_3540_180844# VSS cap_mim_2f0_m4m5_noshield c_width=5u c_length=5u
X2384 a_3540_180844# VSS cap_mim_2f0_m4m5_noshield c_width=5u c_length=5u
X2385 a_3540_180844# VSS cap_mim_2f0_m4m5_noshield c_width=5u c_length=5u
X2386 a_3540_180844# VSS cap_mim_2f0_m4m5_noshield c_width=5u c_length=5u
X2387 a_3540_180844# VSS cap_mim_2f0_m4m5_noshield c_width=5u c_length=5u
X2388 a_3540_180844# VSS cap_mim_2f0_m4m5_noshield c_width=5u c_length=5u
X2389 a_3540_181966.t7 VSS cap_mim_2f0_m4m5_noshield c_width=5u c_length=5u
X2390 a_3540_180844# VSS cap_mim_2f0_m4m5_noshield c_width=5u c_length=5u
X2391 a_3540_180844# VSS cap_mim_2f0_m4m5_noshield c_width=5u c_length=5u
X2392 a_3540_180844# VSS cap_mim_2f0_m4m5_noshield c_width=5u c_length=5u
X2393 a_3540_180844# VSS cap_mim_2f0_m4m5_noshield c_width=5u c_length=5u
X2394 a_3540_180844# VSS cap_mim_2f0_m4m5_noshield c_width=5u c_length=5u
X2395 a_3540_180844# VSS cap_mim_2f0_m4m5_noshield c_width=5u c_length=5u
X2396 a_3540_180844# VSS cap_mim_2f0_m4m5_noshield c_width=5u c_length=5u
X2397 a_3540_180844# VSS cap_mim_2f0_m4m5_noshield c_width=5u c_length=5u
X2398 a_3540_180844# VSS cap_mim_2f0_m4m5_noshield c_width=5u c_length=5u
X2399 a_3540_180844# VSS cap_mim_2f0_m4m5_noshield c_width=5u c_length=5u
X2400 a_3540_180844# VSS cap_mim_2f0_m4m5_noshield c_width=5u c_length=5u
X2401 a_3540_180844# VSS cap_mim_2f0_m4m5_noshield c_width=5u c_length=5u
X2402 a_3540_180844# VSS cap_mim_2f0_m4m5_noshield c_width=5u c_length=5u
X2403 a_3540_180844# VSS cap_mim_2f0_m4m5_noshield c_width=5u c_length=5u
X2404 a_3540_180844# VSS cap_mim_2f0_m4m5_noshield c_width=5u c_length=5u
X2405 a_3540_180844# VSS cap_mim_2f0_m4m5_noshield c_width=5u c_length=5u
X2406 a_3540_180844# VSS cap_mim_2f0_m4m5_noshield c_width=5u c_length=5u
X2407 VCTRL.t1 VSS cap_mim_2f0_m4m5_noshield c_width=5u c_length=5u
X2408 a_3540_180844# VSS cap_mim_2f0_m4m5_noshield c_width=5u c_length=5u
X2409 a_3540_180844# VSS cap_mim_2f0_m4m5_noshield c_width=5u c_length=5u
X2410 a_3540_180844# VSS cap_mim_2f0_m4m5_noshield c_width=5u c_length=5u
X2411 a_3540_180844# VSS cap_mim_2f0_m4m5_noshield c_width=5u c_length=5u
X2412 a_3540_180844# VSS cap_mim_2f0_m4m5_noshield c_width=5u c_length=5u
X2413 a_3540_180844# VSS cap_mim_2f0_m4m5_noshield c_width=5u c_length=5u
X2414 a_3540_180844# VSS cap_mim_2f0_m4m5_noshield c_width=5u c_length=5u
X2415 a_3540_180844# VSS cap_mim_2f0_m4m5_noshield c_width=5u c_length=5u
X2416 a_3540_180844# VSS cap_mim_2f0_m4m5_noshield c_width=5u c_length=5u
X2417 a_3540_180844# VSS cap_mim_2f0_m4m5_noshield c_width=5u c_length=5u
X2418 a_3540_180844# VSS cap_mim_2f0_m4m5_noshield c_width=5u c_length=5u
X2419 a_3540_180844# VSS cap_mim_2f0_m4m5_noshield c_width=5u c_length=5u
X2420 a_3540_180844# VSS cap_mim_2f0_m4m5_noshield c_width=5u c_length=5u
X2421 a_92457_69640# NB.t9 VSS VSS nfet_03v3 ad=2.12p pd=8.53u as=2.12p ps=8.53u w=8u l=2u
X2422 a_3540_180844# VSS cap_mim_2f0_m4m5_noshield c_width=5u c_length=5u
X2423 a_3540_180844# VSS cap_mim_2f0_m4m5_noshield c_width=5u c_length=5u
X2424 a_3540_180844# VSS cap_mim_2f0_m4m5_noshield c_width=5u c_length=5u
X2425 a_3540_180844# VSS cap_mim_2f0_m4m5_noshield c_width=5u c_length=5u
X2426 a_3540_180844# VSS cap_mim_2f0_m4m5_noshield c_width=5u c_length=5u
X2427 a_3540_180844# VSS cap_mim_2f0_m4m5_noshield c_width=5u c_length=5u
X2428 a_87640_80239# PB.t1 VDD VDD pfet_03v3 ad=2.12p pd=8.53u as=2.12p ps=8.53u w=8u l=2u
X2429 a_3540_180844# VSS cap_mim_2f0_m4m5_noshield c_width=5u c_length=5u
X2430 a_3540_180844# VSS cap_mim_2f0_m4m5_noshield c_width=5u c_length=5u
X2431 a_3540_180844# VSS cap_mim_2f0_m4m5_noshield c_width=5u c_length=5u
X2432 VCTRL.t1 VSS cap_mim_2f0_m4m5_noshield c_width=5u c_length=5u
X2433 a_3540_180844# VSS cap_mim_2f0_m4m5_noshield c_width=5u c_length=5u
X2434 a_3540_180844# VSS cap_mim_2f0_m4m5_noshield c_width=5u c_length=5u
X2435 a_3540_180844# VSS cap_mim_2f0_m4m5_noshield c_width=5u c_length=5u
X2436 a_3540_180844# VSS cap_mim_2f0_m4m5_noshield c_width=5u c_length=5u
X2437 a_3540_180844# VSS cap_mim_2f0_m4m5_noshield c_width=5u c_length=5u
X2438 a_88109_80239# VSS cap_mim_2f0_m4m5_noshield c_width=5u c_length=5u
X2439 a_3540_180844# VSS cap_mim_2f0_m4m5_noshield c_width=5u c_length=5u
X2440 a_3540_181966.t7 VSS cap_mim_2f0_m4m5_noshield c_width=5u c_length=5u
X2441 a_3540_180844# VSS cap_mim_2f0_m4m5_noshield c_width=5u c_length=5u
X2442 a_3540_180844# VSS cap_mim_2f0_m4m5_noshield c_width=5u c_length=5u
X2443 a_3540_180844# VSS cap_mim_2f0_m4m5_noshield c_width=5u c_length=5u
X2444 a_3540_180844# VSS cap_mim_2f0_m4m5_noshield c_width=5u c_length=5u
X2445 a_3540_180844# VSS cap_mim_2f0_m4m5_noshield c_width=5u c_length=5u
X2446 a_3540_180844# VSS cap_mim_2f0_m4m5_noshield c_width=5u c_length=5u
X2447 a_3540_180844# VSS cap_mim_2f0_m4m5_noshield c_width=5u c_length=5u
X2448 a_3540_180844# VSS cap_mim_2f0_m4m5_noshield c_width=5u c_length=5u
X2449 a_3540_180844# VSS cap_mim_2f0_m4m5_noshield c_width=5u c_length=5u
X2450 a_88109_80239# VSS cap_mim_2f0_m4m5_noshield c_width=5u c_length=5u
X2451 a_3540_180844# VSS cap_mim_2f0_m4m5_noshield c_width=5u c_length=5u
X2452 a_3540_180844# VSS cap_mim_2f0_m4m5_noshield c_width=5u c_length=5u
X2453 a_3540_180844# VSS cap_mim_2f0_m4m5_noshield c_width=5u c_length=5u
X2454 a_3540_180844# VSS cap_mim_2f0_m4m5_noshield c_width=5u c_length=5u
X2455 a_3540_180844# VSS cap_mim_2f0_m4m5_noshield c_width=5u c_length=5u
X2456 a_3540_180844# VSS cap_mim_2f0_m4m5_noshield c_width=5u c_length=5u
X2457 a_3540_180844# VSS cap_mim_2f0_m4m5_noshield c_width=5u c_length=5u
X2458 a_89880_80239# a_92189_81289# a_89421_74820# VDD pfet_03v3 ad=1.59p pd=6.53u as=1.59p ps=6.53u w=6u l=0.28u
X2459 a_3540_180844# VSS cap_mim_2f0_m4m5_noshield c_width=5u c_length=5u
X2460 a_3540_180844# VSS cap_mim_2f0_m4m5_noshield c_width=5u c_length=5u
X2461 a_3540_180844# VSS cap_mim_2f0_m4m5_noshield c_width=5u c_length=5u
X2462 a_3540_181966.t7 VSS cap_mim_2f0_m4m5_noshield c_width=5u c_length=5u
X2463 a_3540_180844# VSS cap_mim_2f0_m4m5_noshield c_width=5u c_length=5u
X2464 a_3540_180844# VSS cap_mim_2f0_m4m5_noshield c_width=5u c_length=5u
X2465 a_89421_74820# PB.t15 VDD VDD pfet_03v3 ad=2.12p pd=8.53u as=2.12p ps=8.53u w=8u l=2u
X2466 a_3540_180844# VSS cap_mim_2f0_m4m5_noshield c_width=5u c_length=5u
X2467 a_3540_180844# VSS cap_mim_2f0_m4m5_noshield c_width=5u c_length=5u
X2468 a_3540_180844# VSS cap_mim_2f0_m4m5_noshield c_width=5u c_length=5u
X2469 a_3540_180844# VSS cap_mim_2f0_m4m5_noshield c_width=5u c_length=5u
X2470 a_3540_180844# VSS cap_mim_2f0_m4m5_noshield c_width=5u c_length=5u
X2471 a_3540_180844# VSS cap_mim_2f0_m4m5_noshield c_width=5u c_length=5u
X2472 VDD PB.t20 a_89421_74820# VDD pfet_03v3 ad=2.12p pd=8.53u as=2.12p ps=8.53u w=8u l=2u
X2473 a_44105_15880# a_43987_8209# VDD VDD pfet_03v3 ad=0.89p pd=4.89u as=0.89p ps=4.89u w=2u l=0.28u
X2474 a_3540_180844# VSS cap_mim_2f0_m4m5_noshield c_width=5u c_length=5u
X2475 a_3540_180844# VSS cap_mim_2f0_m4m5_noshield c_width=5u c_length=5u
X2476 a_30105_32882# a_29987_33269# VSS VSS nfet_03v3 ad=0.445p pd=2.89u as=0.445p ps=2.89u w=1u l=0.28u
X2477 a_3540_180844# VSS cap_mim_2f0_m4m5_noshield c_width=5u c_length=5u
X2478 a_3540_180844# VSS cap_mim_2f0_m4m5_noshield c_width=5u c_length=5u
X2479 a_3540_180844# VSS cap_mim_2f0_m4m5_noshield c_width=5u c_length=5u
X2480 a_3540_180844# VSS cap_mim_2f0_m4m5_noshield c_width=5u c_length=5u
X2481 a_3540_180844# VSS cap_mim_2f0_m4m5_noshield c_width=5u c_length=5u
X2482 a_3540_180844# VSS cap_mim_2f0_m4m5_noshield c_width=5u c_length=5u
X2483 a_3540_180844# VSS cap_mim_2f0_m4m5_noshield c_width=5u c_length=5u
X2484 a_3540_180844# VSS cap_mim_2f0_m4m5_noshield c_width=5u c_length=5u
X2485 a_3540_180844# VSS cap_mim_2f0_m4m5_noshield c_width=5u c_length=5u
X2486 VCTRL.t1 VSS cap_mim_2f0_m4m5_noshield c_width=5u c_length=5u
X2487 a_3540_180844# VSS cap_mim_2f0_m4m5_noshield c_width=5u c_length=5u
X2488 a_9420_18186# a_9000_16064# VSS ppolyf_u_1k r_width=1u r_length=10u
X2489 a_88409_69640# NB.t5 VSS VSS nfet_03v3 ad=2.12p pd=8.53u as=2.12p ps=8.53u w=8u l=2u
X2490 a_3540_180844# VSS cap_mim_2f0_m4m5_noshield c_width=5u c_length=5u
X2491 a_3540_180844# VSS cap_mim_2f0_m4m5_noshield c_width=5u c_length=5u
X2492 a_3540_180844# VSS cap_mim_2f0_m4m5_noshield c_width=5u c_length=5u
X2493 a_3540_180844# VSS cap_mim_2f0_m4m5_noshield c_width=5u c_length=5u
X2494 a_3540_180844# VSS cap_mim_2f0_m4m5_noshield c_width=5u c_length=5u
X2495 a_3540_180844# VSS cap_mim_2f0_m4m5_noshield c_width=5u c_length=5u
X2496 a_3540_180844# VSS cap_mim_2f0_m4m5_noshield c_width=5u c_length=5u
X2497 a_3540_180844# VSS cap_mim_2f0_m4m5_noshield c_width=5u c_length=5u
X2498 a_3540_180844# VSS cap_mim_2f0_m4m5_noshield c_width=5u c_length=5u
X2499 a_3540_180844# VSS cap_mim_2f0_m4m5_noshield c_width=5u c_length=5u
X2500 a_3540_180844# VSS cap_mim_2f0_m4m5_noshield c_width=5u c_length=5u
X2501 a_3540_180844# VSS cap_mim_2f0_m4m5_noshield c_width=5u c_length=5u
X2502 a_3540_180844# VSS cap_mim_2f0_m4m5_noshield c_width=5u c_length=5u
X2503 a_3540_180844# VSS cap_mim_2f0_m4m5_noshield c_width=5u c_length=5u
X2504 a_3540_180844# VSS cap_mim_2f0_m4m5_noshield c_width=5u c_length=5u
X2505 a_3540_180844# VSS cap_mim_2f0_m4m5_noshield c_width=5u c_length=5u
X2506 a_3540_180844# VSS cap_mim_2f0_m4m5_noshield c_width=5u c_length=5u
X2507 a_3540_180844# VSS cap_mim_2f0_m4m5_noshield c_width=5u c_length=5u
X2508 a_3540_181966.t7 VSS cap_mim_2f0_m4m5_noshield c_width=5u c_length=5u
X2509 a_3540_180844# VSS cap_mim_2f0_m4m5_noshield c_width=5u c_length=5u
X2510 a_3540_181966.t7 VSS cap_mim_2f0_m4m5_noshield c_width=5u c_length=5u
X2511 a_3540_180844# VSS cap_mim_2f0_m4m5_noshield c_width=5u c_length=5u
X2512 a_3540_180844# VSS cap_mim_2f0_m4m5_noshield c_width=5u c_length=5u
X2513 VCTRL.t1 VSS cap_mim_2f0_m4m5_noshield c_width=5u c_length=5u
X2514 a_3540_180844# VSS cap_mim_2f0_m4m5_noshield c_width=5u c_length=5u
X2515 a_3540_180844# VSS cap_mim_2f0_m4m5_noshield c_width=5u c_length=5u
X2516 a_3540_180844# VSS cap_mim_2f0_m4m5_noshield c_width=5u c_length=5u
X2517 a_3540_180844# VSS cap_mim_2f0_m4m5_noshield c_width=5u c_length=5u
X2518 a_3540_180844# VSS cap_mim_2f0_m4m5_noshield c_width=5u c_length=5u
X2519 a_3540_180844# VSS cap_mim_2f0_m4m5_noshield c_width=5u c_length=5u
X2520 a_31640_32540# a_29987_37189.t3 VSS VSS nfet_03v3 ad=0.6675p pd=3.89u as=0.6675p ps=3.89u w=1.5u l=0.28u
X2521 a_3540_181966.t7 VSS cap_mim_2f0_m4m5_noshield c_width=5u c_length=5u
X2522 a_3540_180844# VSS cap_mim_2f0_m4m5_noshield c_width=5u c_length=5u
X2523 a_3540_180844# VSS cap_mim_2f0_m4m5_noshield c_width=5u c_length=5u
X2524 a_3540_180844# VSS cap_mim_2f0_m4m5_noshield c_width=5u c_length=5u
X2525 a_3540_180844# VSS cap_mim_2f0_m4m5_noshield c_width=5u c_length=5u
X2526 a_3540_180844# VSS cap_mim_2f0_m4m5_noshield c_width=5u c_length=5u
X2527 a_3540_180844# VSS cap_mim_2f0_m4m5_noshield c_width=5u c_length=5u
X2528 a_3540_180844# VSS cap_mim_2f0_m4m5_noshield c_width=5u c_length=5u
X2529 a_3540_180844# VSS cap_mim_2f0_m4m5_noshield c_width=5u c_length=5u
X2530 a_3540_180844# VSS cap_mim_2f0_m4m5_noshield c_width=5u c_length=5u
X2531 a_77560_59700# a_36707_106069.t3 VSS VSS nfet_03v3 ad=0.89p pd=4.89u as=0.89p ps=4.89u w=2u l=0.28u
X2532 a_3540_180844# VSS cap_mim_2f0_m4m5_noshield c_width=5u c_length=5u
X2533 a_3540_180844# VSS cap_mim_2f0_m4m5_noshield c_width=5u c_length=5u
X2534 a_3540_180844# VSS cap_mim_2f0_m4m5_noshield c_width=5u c_length=5u
X2535 a_3540_180844# VSS cap_mim_2f0_m4m5_noshield c_width=5u c_length=5u
X2536 a_3540_180844# VSS cap_mim_2f0_m4m5_noshield c_width=5u c_length=5u
X2537 a_92189_81289# ICP2.t3 VDD VDD pfet_03v3 ad=0.89p pd=4.89u as=0.89p ps=4.89u w=2u l=0.28u
X2538 a_3540_180844# VSS cap_mim_2f0_m4m5_noshield c_width=5u c_length=5u
X2539 a_3540_180844# VSS cap_mim_2f0_m4m5_noshield c_width=5u c_length=5u
X2540 a_3540_180844# VSS cap_mim_2f0_m4m5_noshield c_width=5u c_length=5u
X2541 a_3540_180844# VSS cap_mim_2f0_m4m5_noshield c_width=5u c_length=5u
X2542 a_3540_180844# VSS cap_mim_2f0_m4m5_noshield c_width=5u c_length=5u
X2543 VCTRL.t1 VSS cap_mim_2f0_m4m5_noshield c_width=5u c_length=5u
X2544 a_3540_180844# VSS cap_mim_2f0_m4m5_noshield c_width=5u c_length=5u
X2545 a_3540_180844# VSS cap_mim_2f0_m4m5_noshield c_width=5u c_length=5u
X2546 a_3540_180844# VSS cap_mim_2f0_m4m5_noshield c_width=5u c_length=5u
X2547 a_73225_30440# FB.t2 VSS VSS nfet_03v3 ad=0.89p pd=4.89u as=0.89p ps=4.89u w=2u l=0.28u
X2548 a_3540_180844# VSS cap_mim_2f0_m4m5_noshield c_width=5u c_length=5u
X2549 a_3540_180844# VSS cap_mim_2f0_m4m5_noshield c_width=5u c_length=5u
X2550 a_3540_180844# VSS cap_mim_2f0_m4m5_noshield c_width=5u c_length=5u
X2551 a_3540_180844# VSS cap_mim_2f0_m4m5_noshield c_width=5u c_length=5u
X2552 a_3540_180844# VSS cap_mim_2f0_m4m5_noshield c_width=5u c_length=5u
X2553 a_3540_180844# VSS cap_mim_2f0_m4m5_noshield c_width=5u c_length=5u
X2554 a_3540_180844# VSS cap_mim_2f0_m4m5_noshield c_width=5u c_length=5u
X2555 a_3540_180844# VSS cap_mim_2f0_m4m5_noshield c_width=5u c_length=5u
X2556 a_3540_180844# VSS cap_mim_2f0_m4m5_noshield c_width=5u c_length=5u
X2557 a_3540_180844# VSS cap_mim_2f0_m4m5_noshield c_width=5u c_length=5u
X2558 a_3540_180844# VSS cap_mim_2f0_m4m5_noshield c_width=5u c_length=5u
X2559 a_29987_33269# a_41305_45000# a_49145_36740# VDD pfet_03v3 ad=1.78p pd=8.89u as=1.78p ps=8.89u w=4u l=0.28u
X2560 a_3540_180844# VSS cap_mim_2f0_m4m5_noshield c_width=5u c_length=5u
X2561 a_3540_180844# VSS cap_mim_2f0_m4m5_noshield c_width=5u c_length=5u
X2562 a_3540_180844# VSS cap_mim_2f0_m4m5_noshield c_width=5u c_length=5u
X2563 a_3540_180844# VSS cap_mim_2f0_m4m5_noshield c_width=5u c_length=5u
X2564 a_3540_180844# VSS cap_mim_2f0_m4m5_noshield c_width=5u c_length=5u
X2565 a_3540_181966.t7 VSS cap_mim_2f0_m4m5_noshield c_width=5u c_length=5u
X2566 a_3540_180844# VSS cap_mim_2f0_m4m5_noshield c_width=5u c_length=5u
X2567 a_3540_180844# VSS cap_mim_2f0_m4m5_noshield c_width=5u c_length=5u
X2568 a_29987_33269# a_31785_45000# VSS VSS nfet_03v3 ad=0.445p pd=2.89u as=0.445p ps=2.89u w=1u l=0.28u
X2569 a_3540_181966.t7 VSS cap_mim_2f0_m4m5_noshield c_width=5u c_length=5u
X2570 a_3540_180844# VSS cap_mim_2f0_m4m5_noshield c_width=5u c_length=5u
X2571 a_3540_180844# VSS cap_mim_2f0_m4m5_noshield c_width=5u c_length=5u
X2572 a_3540_180844# VSS cap_mim_2f0_m4m5_noshield c_width=5u c_length=5u
X2573 a_43987_83109# a_44105_61800# a_51800_61800# VSS nfet_03v3 ad=1.335p pd=6.89u as=1.335p ps=6.89u w=3u l=0.28u
X2574 a_3540_181966.t7 VSS cap_mim_2f0_m4m5_noshield c_width=5u c_length=5u
X2575 a_3540_180844# VSS cap_mim_2f0_m4m5_noshield c_width=5u c_length=5u
X2576 a_3540_180844# VSS cap_mim_2f0_m4m5_noshield c_width=5u c_length=5u
X2577 a_3540_180844# VSS cap_mim_2f0_m4m5_noshield c_width=5u c_length=5u
X2578 a_3540_180844# VSS cap_mim_2f0_m4m5_noshield c_width=5u c_length=5u
X2579 a_3540_180844# VSS cap_mim_2f0_m4m5_noshield c_width=5u c_length=5u
X2580 a_3540_180844# VSS cap_mim_2f0_m4m5_noshield c_width=5u c_length=5u
X2581 a_3540_180844# VSS cap_mim_2f0_m4m5_noshield c_width=5u c_length=5u
X2582 a_3540_180844# VSS cap_mim_2f0_m4m5_noshield c_width=5u c_length=5u
X2583 a_3540_180844# VSS cap_mim_2f0_m4m5_noshield c_width=5u c_length=5u
X2584 a_3540_180844# VSS cap_mim_2f0_m4m5_noshield c_width=5u c_length=5u
X2585 a_3540_181966.t7 VSS cap_mim_2f0_m4m5_noshield c_width=5u c_length=5u
X2586 a_3540_180844# VSS cap_mim_2f0_m4m5_noshield c_width=5u c_length=5u
X2587 a_3540_180844# VSS cap_mim_2f0_m4m5_noshield c_width=5u c_length=5u
X2588 a_3540_180844# VSS cap_mim_2f0_m4m5_noshield c_width=5u c_length=5u
X2589 a_3540_181966.t7 VSS cap_mim_2f0_m4m5_noshield c_width=5u c_length=5u
X2590 a_3540_180844# VSS cap_mim_2f0_m4m5_noshield c_width=5u c_length=5u
X2591 a_3540_180844# VSS cap_mim_2f0_m4m5_noshield c_width=5u c_length=5u
X2592 a_3540_181966.t7 VSS cap_mim_2f0_m4m5_noshield c_width=5u c_length=5u
X2593 a_3540_180844# VSS cap_mim_2f0_m4m5_noshield c_width=5u c_length=5u
X2594 a_3540_180844# VSS cap_mim_2f0_m4m5_noshield c_width=5u c_length=5u
X2595 a_3540_180844# VSS cap_mim_2f0_m4m5_noshield c_width=5u c_length=5u
X2596 a_3540_180844# VSS cap_mim_2f0_m4m5_noshield c_width=5u c_length=5u
X2597 a_3540_180844# VSS cap_mim_2f0_m4m5_noshield c_width=5u c_length=5u
X2598 a_3540_180844# VSS cap_mim_2f0_m4m5_noshield c_width=5u c_length=5u
X2599 VCTRL.t1 VSS cap_mim_2f0_m4m5_noshield c_width=5u c_length=5u
X2600 a_3540_180844# VSS cap_mim_2f0_m4m5_noshield c_width=5u c_length=5u
X2601 a_3540_180844# VSS cap_mim_2f0_m4m5_noshield c_width=5u c_length=5u
X2602 a_3540_180844# VSS cap_mim_2f0_m4m5_noshield c_width=5u c_length=5u
X2603 a_3540_180844# VSS cap_mim_2f0_m4m5_noshield c_width=5u c_length=5u
X2604 a_3540_180844# VSS cap_mim_2f0_m4m5_noshield c_width=5u c_length=5u
X2605 a_3540_180844# VSS cap_mim_2f0_m4m5_noshield c_width=5u c_length=5u
X2606 a_3540_180844# VSS cap_mim_2f0_m4m5_noshield c_width=5u c_length=5u
X2607 a_3540_180844# VSS cap_mim_2f0_m4m5_noshield c_width=5u c_length=5u
X2608 a_3540_180844# VSS cap_mim_2f0_m4m5_noshield c_width=5u c_length=5u
X2609 a_3540_180844# VSS cap_mim_2f0_m4m5_noshield c_width=5u c_length=5u
X2610 a_3540_180844# VSS cap_mim_2f0_m4m5_noshield c_width=5u c_length=5u
X2611 a_61347_45729# a_61465_32882# a_63000_32540# VSS nfet_03v3 ad=0.6675p pd=3.89u as=0.6675p ps=3.89u w=1.5u l=0.28u
X2612 a_3540_180844# VSS cap_mim_2f0_m4m5_noshield c_width=5u c_length=5u
X2613 a_3540_180844# VSS cap_mim_2f0_m4m5_noshield c_width=5u c_length=5u
X2614 a_3540_181966.t7 VSS cap_mim_2f0_m4m5_noshield c_width=5u c_length=5u
X2615 a_3540_180844# VSS cap_mim_2f0_m4m5_noshield c_width=5u c_length=5u
X2616 a_3540_180844# VSS cap_mim_2f0_m4m5_noshield c_width=5u c_length=5u
X2617 a_3540_180844# VSS cap_mim_2f0_m4m5_noshield c_width=5u c_length=5u
X2618 VCTRL.t1 VSS cap_mim_2f0_m4m5_noshield c_width=5u c_length=5u
X2619 a_3540_180844# VSS cap_mim_2f0_m4m5_noshield c_width=5u c_length=5u
X2620 a_88033_80029# a_30665_105682.t7 VDD VDD pfet_03v3 ad=0.89p pd=4.89u as=0.89p ps=4.89u w=2u l=0.28u
X2621 a_3540_180844# VSS cap_mim_2f0_m4m5_noshield c_width=5u c_length=5u
X2622 a_3540_180844# VSS cap_mim_2f0_m4m5_noshield c_width=5u c_length=5u
X2623 REFIN a_3667_12409# cap_mim_2f0_m4m5_noshield c_width=5u c_length=5u
X2624 a_3540_180844# VSS cap_mim_2f0_m4m5_noshield c_width=5u c_length=5u
X2625 a_3540_180844# VSS cap_mim_2f0_m4m5_noshield c_width=5u c_length=5u
X2626 a_3540_180844# VSS cap_mim_2f0_m4m5_noshield c_width=5u c_length=5u
X2627 a_3540_180844# VSS cap_mim_2f0_m4m5_noshield c_width=5u c_length=5u
X2628 a_3540_180844# VSS cap_mim_2f0_m4m5_noshield c_width=5u c_length=5u
X2629 a_3540_180844# VSS cap_mim_2f0_m4m5_noshield c_width=5u c_length=5u
X2630 a_3540_180844# VSS cap_mim_2f0_m4m5_noshield c_width=5u c_length=5u
X2631 a_3540_180844# VSS cap_mim_2f0_m4m5_noshield c_width=5u c_length=5u
X2632 a_3540_180844# VSS cap_mim_2f0_m4m5_noshield c_width=5u c_length=5u
X2633 a_3540_180844# VSS cap_mim_2f0_m4m5_noshield c_width=5u c_length=5u
X2634 a_3540_180844# VSS cap_mim_2f0_m4m5_noshield c_width=5u c_length=5u
X2635 a_3540_180844# VSS cap_mim_2f0_m4m5_noshield c_width=5u c_length=5u
X2636 a_3540_180844# VSS cap_mim_2f0_m4m5_noshield c_width=5u c_length=5u
X2637 a_3540_180844# VSS cap_mim_2f0_m4m5_noshield c_width=5u c_length=5u
X2638 a_3540_181966.t7 VSS cap_mim_2f0_m4m5_noshield c_width=5u c_length=5u
X2639 a_3540_180844# VSS cap_mim_2f0_m4m5_noshield c_width=5u c_length=5u
X2640 a_3540_180844# VSS cap_mim_2f0_m4m5_noshield c_width=5u c_length=5u
X2641 a_3540_180844# VSS cap_mim_2f0_m4m5_noshield c_width=5u c_length=5u
X2642 a_3540_180844# VSS cap_mim_2f0_m4m5_noshield c_width=5u c_length=5u
X2643 a_3540_180844# VSS cap_mim_2f0_m4m5_noshield c_width=5u c_length=5u
X2644 a_3540_180844# VSS cap_mim_2f0_m4m5_noshield c_width=5u c_length=5u
X2645 a_29987_45729# a_29987_37189.t8 VDD VDD pfet_03v3 ad=0.89p pd=4.89u as=0.89p ps=4.89u w=2u l=0.28u
X2646 a_3540_180844# VSS cap_mim_2f0_m4m5_noshield c_width=5u c_length=5u
X2647 a_3540_180844# VSS cap_mim_2f0_m4m5_noshield c_width=5u c_length=5u
X2648 a_3540_180844# VSS cap_mim_2f0_m4m5_noshield c_width=5u c_length=5u
X2649 a_3540_180844# VSS cap_mim_2f0_m4m5_noshield c_width=5u c_length=5u
X2650 a_3540_180844# VSS cap_mim_2f0_m4m5_noshield c_width=5u c_length=5u
X2651 a_3540_180844# VSS cap_mim_2f0_m4m5_noshield c_width=5u c_length=5u
X2652 a_3540_181966.t7 VSS cap_mim_2f0_m4m5_noshield c_width=5u c_length=5u
X2653 a_88109_80239# VSS cap_mim_2f0_m4m5_noshield c_width=5u c_length=5u
X2654 a_3540_180844# VSS cap_mim_2f0_m4m5_noshield c_width=5u c_length=5u
X2655 a_3540_180844# VSS cap_mim_2f0_m4m5_noshield c_width=5u c_length=5u
X2656 a_3540_180844# VSS cap_mim_2f0_m4m5_noshield c_width=5u c_length=5u
X2657 VCTRL.t1 VSS cap_mim_2f0_m4m5_noshield c_width=5u c_length=5u
X2658 a_3540_180844# VSS cap_mim_2f0_m4m5_noshield c_width=5u c_length=5u
X2659 a_3540_180844# VSS cap_mim_2f0_m4m5_noshield c_width=5u c_length=5u
X2660 a_3540_181966.t7 VSS cap_mim_2f0_m4m5_noshield c_width=5u c_length=5u
X2661 a_3540_180844# VSS cap_mim_2f0_m4m5_noshield c_width=5u c_length=5u
X2662 a_11100_18186# a_3667_12409# VSS ppolyf_u_1k r_width=1u r_length=10u
X2663 a_3540_180844# VSS cap_mim_2f0_m4m5_noshield c_width=5u c_length=5u
X2664 a_3540_180844# VSS cap_mim_2f0_m4m5_noshield c_width=5u c_length=5u
X2665 a_3540_180844# VSS cap_mim_2f0_m4m5_noshield c_width=5u c_length=5u
X2666 a_3540_180844# VSS cap_mim_2f0_m4m5_noshield c_width=5u c_length=5u
X2667 a_3540_180844# VSS cap_mim_2f0_m4m5_noshield c_width=5u c_length=5u
X2668 a_87640_80239# a_30665_105682.t4 a_3540_181966.t1 VDD pfet_03v3 ad=1.06p pd=4.53u as=1.06p ps=4.53u w=4u l=0.28u
X2669 a_3540_180844# VSS cap_mim_2f0_m4m5_noshield c_width=5u c_length=5u
X2670 a_3540_180844# VSS cap_mim_2f0_m4m5_noshield c_width=5u c_length=5u
X2671 a_3540_180844# VSS cap_mim_2f0_m4m5_noshield c_width=5u c_length=5u
X2672 a_8120_61800# a_8147_83109# VSS VSS nfet_03v3 ad=0.89p pd=4.89u as=0.89p ps=4.89u w=2u l=0.28u
X2673 a_3540_180844# VSS cap_mim_2f0_m4m5_noshield c_width=5u c_length=5u
X2674 a_3540_180844# VSS cap_mim_2f0_m4m5_noshield c_width=5u c_length=5u
X2675 a_3540_180844# VSS cap_mim_2f0_m4m5_noshield c_width=5u c_length=5u
X2676 VCTRL.t1 VSS cap_mim_2f0_m4m5_noshield c_width=5u c_length=5u
X2677 a_3540_180844# VSS cap_mim_2f0_m4m5_noshield c_width=5u c_length=5u
X2678 a_3540_180844# VSS cap_mim_2f0_m4m5_noshield c_width=5u c_length=5u
X2679 a_3540_180844# VSS cap_mim_2f0_m4m5_noshield c_width=5u c_length=5u
X2680 a_3540_181966.t7 VSS cap_mim_2f0_m4m5_noshield c_width=5u c_length=5u
X2681 a_3540_180844# VSS cap_mim_2f0_m4m5_noshield c_width=5u c_length=5u
X2682 a_3540_180844# VSS cap_mim_2f0_m4m5_noshield c_width=5u c_length=5u
X2683 a_3540_180844# VSS cap_mim_2f0_m4m5_noshield c_width=5u c_length=5u
X2684 a_3540_180844# VSS cap_mim_2f0_m4m5_noshield c_width=5u c_length=5u
X2685 a_3540_180844# VSS cap_mim_2f0_m4m5_noshield c_width=5u c_length=5u
X2686 a_3540_180844# VSS cap_mim_2f0_m4m5_noshield c_width=5u c_length=5u
X2687 a_3540_181966.t7 VSS cap_mim_2f0_m4m5_noshield c_width=5u c_length=5u
X2688 a_3540_181966.t7 VSS cap_mim_2f0_m4m5_noshield c_width=5u c_length=5u
X2689 a_3540_180844# VSS cap_mim_2f0_m4m5_noshield c_width=5u c_length=5u
X2690 a_3540_180844# VSS cap_mim_2f0_m4m5_noshield c_width=5u c_length=5u
X2691 a_3540_180844# VSS cap_mim_2f0_m4m5_noshield c_width=5u c_length=5u
X2692 a_3540_180844# VSS cap_mim_2f0_m4m5_noshield c_width=5u c_length=5u
X2693 a_3540_181966.t7 VSS cap_mim_2f0_m4m5_noshield c_width=5u c_length=5u
X2694 a_3540_180844# VSS cap_mim_2f0_m4m5_noshield c_width=5u c_length=5u
X2695 a_3540_180844# VSS cap_mim_2f0_m4m5_noshield c_width=5u c_length=5u
X2696 a_3540_180844# VSS cap_mim_2f0_m4m5_noshield c_width=5u c_length=5u
X2697 a_3540_180844# VSS cap_mim_2f0_m4m5_noshield c_width=5u c_length=5u
X2698 a_3540_180844# VSS cap_mim_2f0_m4m5_noshield c_width=5u c_length=5u
X2699 a_3540_180844# VSS cap_mim_2f0_m4m5_noshield c_width=5u c_length=5u
X2700 a_3540_180844# VSS cap_mim_2f0_m4m5_noshield c_width=5u c_length=5u
X2701 a_3540_180844# VSS cap_mim_2f0_m4m5_noshield c_width=5u c_length=5u
X2702 a_3540_180844# VSS cap_mim_2f0_m4m5_noshield c_width=5u c_length=5u
X2703 a_3540_180844# VSS cap_mim_2f0_m4m5_noshield c_width=5u c_length=5u
X2704 LO a_17667_11569# cap_mim_2f0_m4m5_noshield c_width=5u c_length=5u
X2705 a_3540_180844# VSS cap_mim_2f0_m4m5_noshield c_width=5u c_length=5u
X2706 a_3540_180844# VSS cap_mim_2f0_m4m5_noshield c_width=5u c_length=5u
X2707 a_3540_180844# VSS cap_mim_2f0_m4m5_noshield c_width=5u c_length=5u
X2708 a_3540_180844# VSS cap_mim_2f0_m4m5_noshield c_width=5u c_length=5u
X2709 a_3540_180844# VSS cap_mim_2f0_m4m5_noshield c_width=5u c_length=5u
X2710 a_3540_180844# VSS cap_mim_2f0_m4m5_noshield c_width=5u c_length=5u
X2711 a_3540_180844# VSS cap_mim_2f0_m4m5_noshield c_width=5u c_length=5u
X2712 a_3540_180844# VSS cap_mim_2f0_m4m5_noshield c_width=5u c_length=5u
X2713 a_3540_181966.t7 VSS cap_mim_2f0_m4m5_noshield c_width=5u c_length=5u
X2714 a_3540_180844# VSS cap_mim_2f0_m4m5_noshield c_width=5u c_length=5u
X2715 a_3540_180844# VSS cap_mim_2f0_m4m5_noshield c_width=5u c_length=5u
X2716 a_57987_20669# a_45785_19940# VDD VDD pfet_03v3 ad=0.89p pd=4.89u as=0.89p ps=4.89u w=2u l=0.28u
X2717 a_3540_180844# VSS cap_mim_2f0_m4m5_noshield c_width=5u c_length=5u
X2718 a_3540_180844# VSS cap_mim_2f0_m4m5_noshield c_width=5u c_length=5u
X2719 a_3540_180844# VSS cap_mim_2f0_m4m5_noshield c_width=5u c_length=5u
X2720 a_3540_180844# VSS cap_mim_2f0_m4m5_noshield c_width=5u c_length=5u
X2721 a_3540_181966.t8 VSS cap_mim_2f0_m4m5_noshield c_width=5u c_length=5u
X2722 a_3540_180844# VSS cap_mim_2f0_m4m5_noshield c_width=5u c_length=5u
X2723 a_17540_15224# a_17667_11569# VSS VSS nfet_03v3 ad=1.78p pd=8.89u as=1.78p ps=8.89u w=4u l=0.28u
X2724 a_3540_180844# VSS cap_mim_2f0_m4m5_noshield c_width=5u c_length=5u
X2725 a_3540_180844# VSS cap_mim_2f0_m4m5_noshield c_width=5u c_length=5u
X2726 a_3540_180844# VSS cap_mim_2f0_m4m5_noshield c_width=5u c_length=5u
X2727 a_3540_180844# VSS cap_mim_2f0_m4m5_noshield c_width=5u c_length=5u
X2728 a_3540_180844# VSS cap_mim_2f0_m4m5_noshield c_width=5u c_length=5u
X2729 a_3540_180844# VSS cap_mim_2f0_m4m5_noshield c_width=5u c_length=5u
X2730 a_3540_180844# VSS cap_mim_2f0_m4m5_noshield c_width=5u c_length=5u
X2731 a_3540_180844# VSS cap_mim_2f0_m4m5_noshield c_width=5u c_length=5u
X2732 a_3540_180844# VSS cap_mim_2f0_m4m5_noshield c_width=5u c_length=5u
X2733 VCTRL.t1 VSS cap_mim_2f0_m4m5_noshield c_width=5u c_length=5u
X2734 a_3540_180844# VSS cap_mim_2f0_m4m5_noshield c_width=5u c_length=5u
X2735 a_61465_32882# a_31785_45000# a_61465_40940# VDD pfet_03v3 ad=0.89p pd=4.89u as=0.89p ps=4.89u w=2u l=0.28u
X2736 a_3540_180844# VSS cap_mim_2f0_m4m5_noshield c_width=5u c_length=5u
X2737 a_3540_180844# VSS cap_mim_2f0_m4m5_noshield c_width=5u c_length=5u
X2738 a_17540_17346# a_17540_15224# VSS ppolyf_u_1k r_width=1u r_length=10u
X2739 a_3540_180844# VSS cap_mim_2f0_m4m5_noshield c_width=5u c_length=5u
X2740 a_3540_180844# VSS cap_mim_2f0_m4m5_noshield c_width=5u c_length=5u
X2741 a_23800_61800# REFCK.t2 a_23945_66000# VSS nfet_03v3 ad=1.335p pd=6.89u as=1.335p ps=6.89u w=3u l=0.28u
X2742 a_3540_180844# VSS cap_mim_2f0_m4m5_noshield c_width=5u c_length=5u
X2743 a_3540_180844# VSS cap_mim_2f0_m4m5_noshield c_width=5u c_length=5u
X2744 a_87640_80239# PB.t27 VDD VDD pfet_03v3 ad=2.12p pd=8.53u as=2.12p ps=8.53u w=8u l=2u
X2745 a_3540_180844# VSS cap_mim_2f0_m4m5_noshield c_width=5u c_length=5u
X2746 a_3540_180844# VSS cap_mim_2f0_m4m5_noshield c_width=5u c_length=5u
X2747 a_3540_180844# VSS cap_mim_2f0_m4m5_noshield c_width=5u c_length=5u
X2748 a_15987_66729.t1 a_18345_105682# VDD VDD pfet_03v3 ad=0.89p pd=4.89u as=0.89p ps=4.89u w=2u l=0.28u
X2749 a_3540_180844# VSS cap_mim_2f0_m4m5_noshield c_width=5u c_length=5u
X2750 a_3540_180844# VSS cap_mim_2f0_m4m5_noshield c_width=5u c_length=5u
X2751 a_3540_180844# VSS cap_mim_2f0_m4m5_noshield c_width=5u c_length=5u
X2752 a_36707_106069.t1 a_43987_83109# a_43960_82520# VSS nfet_03v3 ad=0.89p pd=4.89u as=0.89p ps=4.89u w=2u l=0.28u
X2753 a_3540_180844# VSS cap_mim_2f0_m4m5_noshield c_width=5u c_length=5u
X2754 a_3540_180844# VSS cap_mim_2f0_m4m5_noshield c_width=5u c_length=5u
X2755 a_88109_80239# VSS cap_mim_2f0_m4m5_noshield c_width=5u c_length=5u
X2756 a_16105_66000# a_15987_66729.t7 VSS VSS nfet_03v3 ad=1.335p pd=6.89u as=1.335p ps=6.89u w=3u l=0.28u
X2757 a_3540_180844# VSS cap_mim_2f0_m4m5_noshield c_width=5u c_length=5u
X2758 a_3540_181966.t7 VSS cap_mim_2f0_m4m5_noshield c_width=5u c_length=5u
X2759 a_3540_180844# VSS cap_mim_2f0_m4m5_noshield c_width=5u c_length=5u
X2760 a_3540_180844# VSS cap_mim_2f0_m4m5_noshield c_width=5u c_length=5u
X2761 a_3540_180844# VSS cap_mim_2f0_m4m5_noshield c_width=5u c_length=5u
X2762 a_3540_180844# VSS cap_mim_2f0_m4m5_noshield c_width=5u c_length=5u
X2763 a_3540_180844# VSS cap_mim_2f0_m4m5_noshield c_width=5u c_length=5u
X2764 a_3540_180844# VSS cap_mim_2f0_m4m5_noshield c_width=5u c_length=5u
X2765 a_3540_180844# VSS cap_mim_2f0_m4m5_noshield c_width=5u c_length=5u
X2766 a_3540_180844# VSS cap_mim_2f0_m4m5_noshield c_width=5u c_length=5u
X2767 a_3540_180844# VSS cap_mim_2f0_m4m5_noshield c_width=5u c_length=5u
X2768 a_3540_180844# VSS cap_mim_2f0_m4m5_noshield c_width=5u c_length=5u
X2769 a_3540_180844# VSS cap_mim_2f0_m4m5_noshield c_width=5u c_length=5u
X2770 a_3540_180844# VSS cap_mim_2f0_m4m5_noshield c_width=5u c_length=5u
X2771 a_3540_180844# VSS cap_mim_2f0_m4m5_noshield c_width=5u c_length=5u
X2772 a_3540_180844# VSS cap_mim_2f0_m4m5_noshield c_width=5u c_length=5u
X2773 a_6900_18186# a_6480_16064# VSS ppolyf_u_1k r_width=1u r_length=10u
X2774 a_3540_180844# VSS cap_mim_2f0_m4m5_noshield c_width=5u c_length=5u
X2775 a_3540_180844# VSS cap_mim_2f0_m4m5_noshield c_width=5u c_length=5u
X2776 a_3540_180844# VSS cap_mim_2f0_m4m5_noshield c_width=5u c_length=5u
X2777 a_3540_180844# VSS cap_mim_2f0_m4m5_noshield c_width=5u c_length=5u
X2778 a_3540_180844# VSS cap_mim_2f0_m4m5_noshield c_width=5u c_length=5u
X2779 a_3540_180844# VSS cap_mim_2f0_m4m5_noshield c_width=5u c_length=5u
X2780 a_3540_180844# VSS cap_mim_2f0_m4m5_noshield c_width=5u c_length=5u
X2781 a_3540_180844# VSS cap_mim_2f0_m4m5_noshield c_width=5u c_length=5u
X2782 a_3540_180844# VSS cap_mim_2f0_m4m5_noshield c_width=5u c_length=5u
X2783 a_3540_180844# VSS cap_mim_2f0_m4m5_noshield c_width=5u c_length=5u
X2784 a_3540_180844# VSS cap_mim_2f0_m4m5_noshield c_width=5u c_length=5u
X2785 a_3540_180844# VSS cap_mim_2f0_m4m5_noshield c_width=5u c_length=5u
X2786 a_3540_180844# VSS cap_mim_2f0_m4m5_noshield c_width=5u c_length=5u
X2787 a_3540_180844# VSS cap_mim_2f0_m4m5_noshield c_width=5u c_length=5u
X2788 a_3540_180844# VSS cap_mim_2f0_m4m5_noshield c_width=5u c_length=5u
X2789 a_3540_180844# VSS cap_mim_2f0_m4m5_noshield c_width=5u c_length=5u
X2790 a_3540_181966.t8 VSS cap_mim_2f0_m4m5_noshield c_width=5u c_length=5u
X2791 a_3540_180844# VSS cap_mim_2f0_m4m5_noshield c_width=5u c_length=5u
X2792 a_3540_180844# VSS cap_mim_2f0_m4m5_noshield c_width=5u c_length=5u
X2793 a_3540_180844# VSS cap_mim_2f0_m4m5_noshield c_width=5u c_length=5u
X2794 a_8265_61800# a_8147_83109# VDD VDD pfet_03v3 ad=0.89p pd=4.89u as=0.89p ps=4.89u w=2u l=0.28u
X2795 a_3540_180844# VSS cap_mim_2f0_m4m5_noshield c_width=5u c_length=5u
X2796 a_88109_80239# VSS cap_mim_2f0_m4m5_noshield c_width=5u c_length=5u
X2797 a_3540_180844# VSS cap_mim_2f0_m4m5_noshield c_width=5u c_length=5u
X2798 a_3540_180844# VSS cap_mim_2f0_m4m5_noshield c_width=5u c_length=5u
X2799 a_3540_180844# VSS cap_mim_2f0_m4m5_noshield c_width=5u c_length=5u
X2800 a_58105_15880# a_57987_8209# VDD VDD pfet_03v3 ad=0.89p pd=4.89u as=0.89p ps=4.89u w=2u l=0.28u
X2801 a_30105_7822# a_29987_8209# VSS VSS nfet_03v3 ad=0.445p pd=2.89u as=0.445p ps=2.89u w=1u l=0.28u
X2802 a_3540_181966.t7 VSS cap_mim_2f0_m4m5_noshield c_width=5u c_length=5u
X2803 a_3540_180844# VSS cap_mim_2f0_m4m5_noshield c_width=5u c_length=5u
X2804 a_3540_180844# VSS cap_mim_2f0_m4m5_noshield c_width=5u c_length=5u
X2805 a_3540_180844# VSS cap_mim_2f0_m4m5_noshield c_width=5u c_length=5u
X2806 VSS NB.t0 a_88409_69640# VSS nfet_03v3 ad=3.56p pd=16.89u as=2.12p ps=8.53u w=8u l=2u
X2807 a_3540_180844# VSS cap_mim_2f0_m4m5_noshield c_width=5u c_length=5u
X2808 a_3540_180844# VSS cap_mim_2f0_m4m5_noshield c_width=5u c_length=5u
X2809 a_3540_181966.t7 VSS cap_mim_2f0_m4m5_noshield c_width=5u c_length=5u
X2810 a_41305_45000# a_39625_36740# VSS VSS nfet_03v3 ad=0.445p pd=2.89u as=0.445p ps=2.89u w=1u l=0.28u
X2811 a_3540_180844# VSS cap_mim_2f0_m4m5_noshield c_width=5u c_length=5u
X2812 a_3540_180844# VSS cap_mim_2f0_m4m5_noshield c_width=5u c_length=5u
X2813 a_88109_80239# VSS cap_mim_2f0_m4m5_noshield c_width=5u c_length=5u
X2814 a_3540_180844# VSS cap_mim_2f0_m4m5_noshield c_width=5u c_length=5u
X2815 a_3540_180844# VSS cap_mim_2f0_m4m5_noshield c_width=5u c_length=5u
X2816 a_3540_180844# VSS cap_mim_2f0_m4m5_noshield c_width=5u c_length=5u
X2817 a_89421_69640# NB.t7 VSS VSS nfet_03v3 ad=2.12p pd=8.53u as=2.12p ps=8.53u w=8u l=2u
X2818 a_3540_180844# VSS cap_mim_2f0_m4m5_noshield c_width=5u c_length=5u
X2819 a_3540_180844# VSS cap_mim_2f0_m4m5_noshield c_width=5u c_length=5u
X2820 a_3540_180844# VSS cap_mim_2f0_m4m5_noshield c_width=5u c_length=5u
X2821 a_3540_180844# VSS cap_mim_2f0_m4m5_noshield c_width=5u c_length=5u
X2822 a_88109_80239# VSS cap_mim_2f0_m4m5_noshield c_width=5u c_length=5u
X2823 a_3540_180844# VSS cap_mim_2f0_m4m5_noshield c_width=5u c_length=5u
X2824 a_3540_180844# VSS cap_mim_2f0_m4m5_noshield c_width=5u c_length=5u
X2825 a_3540_180844# VSS cap_mim_2f0_m4m5_noshield c_width=5u c_length=5u
X2826 a_3540_180844# VSS cap_mim_2f0_m4m5_noshield c_width=5u c_length=5u
X2827 a_3540_180844# VSS cap_mim_2f0_m4m5_noshield c_width=5u c_length=5u
X2828 a_3540_180844# VSS cap_mim_2f0_m4m5_noshield c_width=5u c_length=5u
X2829 a_3540_180844# VSS cap_mim_2f0_m4m5_noshield c_width=5u c_length=5u
X2830 a_3540_180844# VSS cap_mim_2f0_m4m5_noshield c_width=5u c_length=5u
X2831 a_3540_180844# VSS cap_mim_2f0_m4m5_noshield c_width=5u c_length=5u
X2832 a_3540_180844# VSS cap_mim_2f0_m4m5_noshield c_width=5u c_length=5u
X2833 a_3540_180844# VSS cap_mim_2f0_m4m5_noshield c_width=5u c_length=5u
X2834 a_43987_83109# a_44105_61800# VDD VDD pfet_03v3 ad=0.89p pd=4.89u as=0.89p ps=4.89u w=2u l=0.28u
X2835 a_3540_180844# VSS cap_mim_2f0_m4m5_noshield c_width=5u c_length=5u
X2836 a_3540_180844# VSS cap_mim_2f0_m4m5_noshield c_width=5u c_length=5u
X2837 a_3540_180844# VSS cap_mim_2f0_m4m5_noshield c_width=5u c_length=5u
X2838 a_3540_180844# VSS cap_mim_2f0_m4m5_noshield c_width=5u c_length=5u
X2839 a_3540_180844# VSS cap_mim_2f0_m4m5_noshield c_width=5u c_length=5u
X2840 a_3540_180844# VSS cap_mim_2f0_m4m5_noshield c_width=5u c_length=5u
X2841 a_3540_180844# VSS cap_mim_2f0_m4m5_noshield c_width=5u c_length=5u
X2842 a_3540_180844# VSS cap_mim_2f0_m4m5_noshield c_width=5u c_length=5u
X2843 a_88109_80239# VSS cap_mim_2f0_m4m5_noshield c_width=5u c_length=5u
X2844 a_3540_180844# VSS cap_mim_2f0_m4m5_noshield c_width=5u c_length=5u
X2845 a_3540_180844# VSS cap_mim_2f0_m4m5_noshield c_width=5u c_length=5u
X2846 a_3540_180844# VSS cap_mim_2f0_m4m5_noshield c_width=5u c_length=5u
X2847 a_3540_180844# VSS cap_mim_2f0_m4m5_noshield c_width=5u c_length=5u
X2848 a_3540_180844# VSS cap_mim_2f0_m4m5_noshield c_width=5u c_length=5u
X2849 a_3540_180844# VSS cap_mim_2f0_m4m5_noshield c_width=5u c_length=5u
X2850 a_3540_180844# VSS cap_mim_2f0_m4m5_noshield c_width=5u c_length=5u
X2851 a_3540_180844# VSS cap_mim_2f0_m4m5_noshield c_width=5u c_length=5u
X2852 a_3540_180844# VSS cap_mim_2f0_m4m5_noshield c_width=5u c_length=5u
X2853 a_3540_180844# VSS cap_mim_2f0_m4m5_noshield c_width=5u c_length=5u
X2854 a_3540_181966.t7 VSS cap_mim_2f0_m4m5_noshield c_width=5u c_length=5u
X2855 a_3540_180844# VSS cap_mim_2f0_m4m5_noshield c_width=5u c_length=5u
X2856 a_3540_180844# VSS cap_mim_2f0_m4m5_noshield c_width=5u c_length=5u
X2857 a_3540_180844# VSS cap_mim_2f0_m4m5_noshield c_width=5u c_length=5u
X2858 a_3540_180844# VSS cap_mim_2f0_m4m5_noshield c_width=5u c_length=5u
X2859 a_3540_180844# VSS cap_mim_2f0_m4m5_noshield c_width=5u c_length=5u
X2860 a_88109_80239# a_99409_69879# VDD VDD pfet_03v3 ad=1.06p pd=4.53u as=1.06p ps=4.53u w=4u l=1u
X2861 a_87640_80239# PB.t13 VDD VDD pfet_03v3 ad=2.12p pd=8.53u as=2.12p ps=8.53u w=8u l=2u
X2862 a_3540_180844# VSS cap_mim_2f0_m4m5_noshield c_width=5u c_length=5u
X2863 a_3540_180844# VSS cap_mim_2f0_m4m5_noshield c_width=5u c_length=5u
X2864 a_3540_180844# VSS cap_mim_2f0_m4m5_noshield c_width=5u c_length=5u
X2865 a_3540_180844# VSS cap_mim_2f0_m4m5_noshield c_width=5u c_length=5u
X2866 a_3540_180844# VSS cap_mim_2f0_m4m5_noshield c_width=5u c_length=5u
X2867 a_3540_180844# VSS cap_mim_2f0_m4m5_noshield c_width=5u c_length=5u
X2868 a_3540_180844# VSS cap_mim_2f0_m4m5_noshield c_width=5u c_length=5u
X2869 a_3540_180844# VSS cap_mim_2f0_m4m5_noshield c_width=5u c_length=5u
X2870 VDD PB.t18 a_87640_80239# VDD pfet_03v3 ad=2.12p pd=8.53u as=2.12p ps=8.53u w=8u l=2u
X2871 a_3540_180844# VSS cap_mim_2f0_m4m5_noshield c_width=5u c_length=5u
X2872 a_3540_180844# VSS cap_mim_2f0_m4m5_noshield c_width=5u c_length=5u
X2873 a_3540_180844# VSS cap_mim_2f0_m4m5_noshield c_width=5u c_length=5u
X2874 a_3540_180844# VSS cap_mim_2f0_m4m5_noshield c_width=5u c_length=5u
X2875 a_3540_180844# VSS cap_mim_2f0_m4m5_noshield c_width=5u c_length=5u
X2876 a_3540_180844# VSS cap_mim_2f0_m4m5_noshield c_width=5u c_length=5u
X2877 a_3540_181966.t7 VSS cap_mim_2f0_m4m5_noshield c_width=5u c_length=5u
X2878 a_3540_180844# VSS cap_mim_2f0_m4m5_noshield c_width=5u c_length=5u
X2879 a_36825_105682.t0 a_36707_106069.t9 VSS VSS nfet_03v3 ad=0.445p pd=2.89u as=0.445p ps=2.89u w=1u l=0.28u
X2880 a_36707_106069.t2 a_43987_83109# VDD VDD pfet_03v3 ad=0.89p pd=4.89u as=0.89p ps=4.89u w=2u l=0.28u
X2881 a_3540_180844# VSS cap_mim_2f0_m4m5_noshield c_width=5u c_length=5u
X2882 a_3540_181966.t7 VSS cap_mim_2f0_m4m5_noshield c_width=5u c_length=5u
X2883 a_3540_180844# VSS cap_mim_2f0_m4m5_noshield c_width=5u c_length=5u
X2884 a_3540_181966.t7 VSS cap_mim_2f0_m4m5_noshield c_width=5u c_length=5u
X2885 a_3540_181966.t3 a_36707_106069.t5 a_105420_69640# VSS nfet_03v3 ad=0.89p pd=4.89u as=0.89p ps=4.89u w=2u l=0.28u
X2886 a_6900_18186# a_7320_16064# VSS ppolyf_u_1k r_width=1u r_length=10u
X2887 a_89421_69640# NB.t3 VSS VSS nfet_03v3 ad=2.12p pd=8.53u as=2.12p ps=8.53u w=8u l=2u
X2888 a_3540_180844# VSS cap_mim_2f0_m4m5_noshield c_width=5u c_length=5u
X2889 a_43987_83109# a_15987_66729.t8 VDD VDD pfet_03v3 ad=0.89p pd=4.89u as=0.89p ps=4.89u w=2u l=0.28u
X2890 VDD PB.t30 a_87640_80239# VDD pfet_03v3 ad=2.12p pd=8.53u as=2.12p ps=8.53u w=8u l=2u
X2891 a_88109_80239# a_88109_80239# a_92457_69640# VSS nfet_03v3 ad=1.06p pd=4.53u as=1.06p ps=4.53u w=4u l=1u
X2892 a_3540_180844# VSS cap_mim_2f0_m4m5_noshield c_width=5u c_length=5u
X2893 a_3540_180844# VSS cap_mim_2f0_m4m5_noshield c_width=5u c_length=5u
X2894 a_3540_180844# VSS cap_mim_2f0_m4m5_noshield c_width=5u c_length=5u
X2895 a_3540_180844# VSS cap_mim_2f0_m4m5_noshield c_width=5u c_length=5u
X2896 a_3540_180844# VSS cap_mim_2f0_m4m5_noshield c_width=5u c_length=5u
X2897 a_3540_180844# VSS cap_mim_2f0_m4m5_noshield c_width=5u c_length=5u
X2898 a_3540_180844# VSS cap_mim_2f0_m4m5_noshield c_width=5u c_length=5u
X2899 a_3540_180844# VSS cap_mim_2f0_m4m5_noshield c_width=5u c_length=5u
X2900 a_3540_180844# VSS cap_mim_2f0_m4m5_noshield c_width=5u c_length=5u
X2901 a_3540_180844# VSS cap_mim_2f0_m4m5_noshield c_width=5u c_length=5u
X2902 a_88109_80239# a_88033_80029# a_87640_80239# VDD pfet_03v3 ad=1.06p pd=4.53u as=1.06p ps=4.53u w=4u l=0.28u
X2903 a_3540_180844# VSS cap_mim_2f0_m4m5_noshield c_width=5u c_length=5u
X2904 a_3540_180844# VSS cap_mim_2f0_m4m5_noshield c_width=5u c_length=5u
X2905 a_3540_180844# VSS cap_mim_2f0_m4m5_noshield c_width=5u c_length=5u
X2906 a_3540_180844# VSS cap_mim_2f0_m4m5_noshield c_width=5u c_length=5u
X2907 a_3540_180844# VSS cap_mim_2f0_m4m5_noshield c_width=5u c_length=5u
X2908 a_3540_180844# VSS cap_mim_2f0_m4m5_noshield c_width=5u c_length=5u
X2909 a_89421_69640# NB.t15 VSS VSS nfet_03v3 ad=2.12p pd=8.53u as=2.12p ps=8.53u w=8u l=2u
X2910 a_3540_180844# VSS cap_mim_2f0_m4m5_noshield c_width=5u c_length=5u
X2911 a_3540_180844# VSS cap_mim_2f0_m4m5_noshield c_width=5u c_length=5u
X2912 a_3540_180844# VSS cap_mim_2f0_m4m5_noshield c_width=5u c_length=5u
X2913 a_3540_180844# VSS cap_mim_2f0_m4m5_noshield c_width=5u c_length=5u
X2914 a_3540_180844# VSS cap_mim_2f0_m4m5_noshield c_width=5u c_length=5u
X2915 a_29987_37189.t0 a_57987_8209# VSS VSS nfet_03v3 ad=0.445p pd=2.89u as=0.445p ps=2.89u w=1u l=0.28u
X2916 a_3540_180844# VSS cap_mim_2f0_m4m5_noshield c_width=5u c_length=5u
X2917 a_3540_180844# VSS cap_mim_2f0_m4m5_noshield c_width=5u c_length=5u
X2918 a_3540_180844# VSS cap_mim_2f0_m4m5_noshield c_width=5u c_length=5u
X2919 a_3540_180844# VSS cap_mim_2f0_m4m5_noshield c_width=5u c_length=5u
X2920 a_3540_180844# VSS cap_mim_2f0_m4m5_noshield c_width=5u c_length=5u
X2921 a_3540_180844# VSS cap_mim_2f0_m4m5_noshield c_width=5u c_length=5u
X2922 a_3540_180844# VSS cap_mim_2f0_m4m5_noshield c_width=5u c_length=5u
X2923 a_3540_180844# VSS cap_mim_2f0_m4m5_noshield c_width=5u c_length=5u
X2924 a_3540_180844# VSS cap_mim_2f0_m4m5_noshield c_width=5u c_length=5u
X2925 a_3540_180844# VSS cap_mim_2f0_m4m5_noshield c_width=5u c_length=5u
X2926 a_3540_180844# VSS cap_mim_2f0_m4m5_noshield c_width=5u c_length=5u
C0 a_30254_32822# a_30105_32882# 0.01511f
C1 a_30105_7822# a_30254_7762# 0.01511f
C2 VDD a_69044_65800# 0.36374f
C3 VDD a_19614_21000# 1.08855f
C4 a_29960_11680# a_19465_10700# 0.05307f
C5 a_99409_69879# a_105860_74760# 0.03335f
C6 a_39625_32882# a_39625_40940# 0.30783f
C7 a_29987_33269# a_39625_32882# 0.04359f
C8 VDD a_53774_70140# 0.35048f
C9 a_8147_62389# a_31934_61740# 0.01991f
C10 a_89421_69640# ICP2 0.11283f
C11 a_43987_8209# a_44254_11620# 0.01937f
C12 a_29987_8209# a_31524_19880# 0.01132f
C13 REFCK a_3540_16064# 0.11525f
C14 VDD a_29844_44940# 0.50082f
C15 REFCK a_5614_11760# 0.02665f
C16 a_61465_40940# a_61614_40880# 0.02481f
C17 VDD a_17667_83249# 5.15014f
C18 a_58105_7822# a_58254_7762# 0.01511f
C19 a_23684_61740# a_23800_61800# 0.02888f
C20 a_45640_7480# a_43987_20669# 0.12718f
C21 a_3667_12409# a_5640_16064# 0.0159f
C22 a_43987_62389# a_43960_61800# 0.03744f
C23 VDD a_19465_10700# 3.74033f
C24 a_31524_7420# a_31640_7480# 0.01552f
C25 a_88109_80239# REFCK 0.09301f
C26 a_41044_40880# a_39625_40940# 0.02368f
C27 a_88109_80239# a_100476_69819# 0.01722f
C28 a_8147_62389# a_33614_65800# 0.0199f
C29 a_8147_62389# a_31524_65800# 0.01206f
C30 a_8147_62389# a_31640_61800# 0.1904f
C31 VDD a_53364_70140# 0.36374f
C32 a_43987_8209# a_43960_11680# 0.2943f
C33 VDD a_30254_40880# 0.3476f
C34 a_39507_45729# a_43134_40880# 0.01993f
C35 VDD a_29987_45729# 2.04275f
C36 FB NB 0.0412f
C37 VDD a_19204_21000# 1.15375f
C38 a_104244_74760# a_99409_69879# 0.01814f
C39 a_87640_80239# REFCK 0.05367f
C40 a_19614_10640# a_19465_10700# 0.0476f
C41 a_8265_61800# a_15844_70140# 0.01059f
C42 a_49145_36740# a_41305_45000# 0.10248f
C43 a_69454_61740# a_67480_61800# 0.01988f
C44 a_18345_105682# a_24244_109480# 0.01161f
C45 a_43987_62389# a_67364_61740# 0.01292f
C46 VDD a_45785_19940# 4.78669f
C47 a_92189_81289# a_96334_87142# 0.01511f
C48 VDD a_52094_70140# 0.35048f
C49 a_8147_62389# a_31524_61740# 0.01292f
C50 VDD a_30105_40940# 0.56243f
C51 a_44254_19880# a_43987_20669# 0.01183f
C52 a_57987_8209# a_58254_11620# 0.01937f
C53 a_89421_69640# a_105420_69640# 0.50056f
C54 a_61320_36740# a_61465_32882# 0.08298f
C55 FB a_73225_30440# 0.21025f
C56 a_45640_7480# a_31785_19940# 0.11857f
C57 a_41454_44940# a_39625_36740# 0.01095f
C58 a_43960_82520# a_43844_82460# 0.01998f
C59 a_17524_21000# a_17540_15224# 0.02955f
C60 VDD a_33614_40880# 0.35048f
C61 a_8120_61800# a_8414_61740# 0.01069f
C62 VDD a_63294_40880# 0.3412f
C63 VDD a_16105_86720# 0.25015f
C64 a_39364_36680# a_39480_36740# 0.01552f
C65 VDD NB 5.75879f
C66 VCTRL FB 0.07437f
C67 ICP2 REFCK 0.04427f
C68 a_31640_32540# a_30105_32882# 0.04364f
C69 VDD a_73374_34440# 0.60202f
C70 a_18345_105682# a_18494_109480# 0.02481f
C71 a_30105_36740# a_31785_45000# 0.29002f
C72 a_8147_62389# a_23945_66000# 0.08746f
C73 a_8147_62389# a_31934_65800# 0.0228f
C74 VDD a_29844_40880# 0.36583f
C75 a_43987_8209# a_43987_20669# 0.19885f
C76 a_57987_8209# a_57960_11680# 0.2943f
C77 a_41160_32540# a_43134_32480# 0.01542f
C78 VDD a_87460_74760# 3.38049f
C79 a_58105_7822# a_57960_11680# 0.08298f
C80 a_88033_80029# a_90174_87142# 0.01753f
C81 a_29987_8209# a_31934_19880# 0.01095f
C82 a_43987_62389# a_67774_61740# 0.01991f
C83 FB a_72964_34440# 0.0124f
C84 VDD a_45524_19880# 0.36505f
C85 a_23800_61800# a_8147_83109# 0.04282f
C86 a_41305_45000# a_39625_36740# 0.29002f
C87 VDD a_33204_40880# 0.36293f
C88 a_17667_11569# a_17540_15224# 0.93473f
C89 a_6025_105682# a_12185_105682# 0.06039f
C90 VDD a_30254_19880# 0.47195f
C91 a_29987_8209# a_29960_11680# 0.2943f
C92 a_31524_32480# a_30105_32882# 0.01247f
C93 VDD a_73225_30440# 2.56722f
C94 a_30105_36740# a_31524_44940# 0.01132f
C95 a_88109_80239# NB 0.21222f
C96 VDD a_25364_70140# 0.36374f
C97 a_16254_90860# VDD 0.35048f
C98 VDD a_57844_19880# 0.50082f
C99 VDD a_59934_74200# 0.35048f
C100 VDD VCTRL 14.6864f
C101 a_29987_8209# a_31785_19940# 0.32735f
C102 a_43987_62389# a_67480_61800# 0.1904f
C103 FB a_64974_37022# 0.01732f
C104 VDD a_44254_19880# 0.47195f
C105 a_24094_74200# a_17667_83249# 0.02134f
C106 VDD a_31934_40880# 0.3412f
C107 a_31640_7480# a_33614_7420# 0.01542f
C108 NB a_88033_80029# 0.05082f
C109 VDD a_10094_86520# 0.35048f
C110 a_17667_83249# a_25774_70140# 0.0199f
C111 a_8004_61740# a_8120_61800# 0.01998f
C112 VDD a_29987_8209# 3.76336f
C113 a_29987_33269# a_50974_32822# 0.01149f
C114 a_30105_36740# a_30254_44940# 0.03434f
C115 VDD a_72964_34440# 0.63535f
C116 VDD a_24094_70140# 0.35048f
C117 a_87640_80239# NB 0.19114f
C118 a_45934_11620# a_43960_11680# 0.01542f
C119 a_15844_90860# VDD 0.36583f
C120 a_8147_83109# a_8265_61800# 0.52099f
C121 a_43987_8209# a_31785_19940# 1.12918f
C122 a_3667_12409# a_7320_16064# 0.01831f
C123 a_53507_83249# REFCK 0.0475f
C124 VDD a_57987_20669# 2.04275f
C125 VDD a_59524_74200# 0.36583f
C126 VDD a_43987_8209# 3.76336f
C127 a_8147_62389# REFCK 0.38294f
C128 a_43987_62389# FB 0.24253f
C129 a_39507_45729# a_39480_36740# 0.07789f
C130 VDD a_29844_19880# 0.50082f
C131 REFCK a_16105_66000# 0.33634f
C132 a_29987_20669# a_29960_11680# 0.07789f
C133 a_18494_105622# a_18345_105682# 0.01511f
C134 REFCK LO 0.06494f
C135 VDD a_23684_70140# 0.36583f
C136 VDD a_64974_40880# 0.35048f
C137 a_52094_94920# VDD 0.35048f
C138 REFCK a_43987_83109# 0.04537f
C139 a_39480_36740# a_39625_36740# 0.2943f
C140 a_39480_36740# a_39625_32882# 0.08298f
C141 VDD a_45934_19880# 0.34666f
C142 a_29987_33269# a_29987_45729# 0.04359f
C143 a_8160_16064# a_7320_16064# 0.01686f
C144 a_49145_36740# a_49294_36680# 0.0476f
C145 VDD a_43844_19880# 0.50082f
C146 a_8147_62389# a_17667_83249# 1.09563f
C147 a_99409_69879# a_92457_69640# 0.47442f
C148 a_3667_12409# a_8160_16064# 0.01831f
C149 VDD a_67774_65800# 0.35048f
C150 a_63294_40880# a_31785_45000# 0.01096f
C151 a_44105_15880# a_43987_20669# 0.11343f
C152 a_89764_80179# a_89880_80239# 0.04246f
C153 a_23800_61800# a_25774_61740# 0.02878f
C154 a_43844_61740# a_44105_61800# 0.01292f
C155 a_43987_83109# a_53774_70140# 0.0199f
C156 VDD a_29987_20669# 2.04275f
C157 a_4800_16064# a_5640_16064# 0.01686f
C158 a_29987_33269# a_49294_32822# 0.01511f
C159 a_8265_61800# a_15960_61800# 0.04282f
C160 a_41044_32480# a_39625_32882# 0.01247f
C161 a_29987_45729# a_30254_44940# 0.01183f
C162 a_10094_82460# a_8120_82520# 0.01988f
C163 a_7740_18186# a_6900_18186# 0.01686f
C164 a_51684_61740# a_51800_61800# 0.02888f
C165 VDD a_64564_40880# 0.36293f
C166 a_29987_33269# a_30105_40940# 0.03318f
C167 a_43987_62389# VDD 3.95467f
C168 FS a_73225_30440# 0.57803f
C169 a_17934_61740# a_15960_61800# 0.02878f
C170 a_48884_36680# a_49294_36680# 0.0129f
C171 a_10094_65800# a_8265_61800# 0.0199f
C172 VDD a_67364_65800# 0.36293f
C173 a_99409_69879# a_89421_69640# 0.0262f
C174 a_30105_15880# a_19465_10700# 0.02344f
C175 a_4380_18186# a_5220_18186# 0.01686f
C176 VCTRL FS 0.04923f
C177 VDD REFIN 0.14209f
C178 a_9840_16064# a_10680_16064# 0.01686f
C179 a_23800_61800# a_25364_61740# 0.01102f
C180 VDD a_30105_32882# 0.71507f
C181 VDD a_36564_109480# 0.36569f
C182 a_39774_32822# a_39625_32882# 0.01511f
C183 a_8147_83109# a_9827_83109# 0.03975f
C184 a_52094_74200# VDD 0.35048f
C185 VDD a_59934_19880# 0.34666f
C186 a_8147_83109# a_16254_61740# 0.03106f
C187 a_9420_18186# a_10260_18186# 0.01686f
C188 a_17934_21000# a_17540_15224# 0.08785f
C189 a_89880_80239# a_92189_81289# 0.27215f
C190 a_53507_83249# NB 0.08089f
C191 a_44105_15880# a_31785_19940# 0.02344f
C192 a_39625_36740# a_41044_44940# 0.01132f
C193 a_23800_61800# a_24094_61740# 0.01363f
C194 a_43987_83109# a_52094_70140# 0.02583f
C195 VDD a_44105_15880# 0.56243f
C196 VDD a_31524_40880# 0.33996f
C197 a_12185_105682# a_18084_109480# 0.01161f
C198 a_8414_82460# a_8120_82520# 0.01069f
C199 a_39507_45729# a_39774_44940# 0.01183f
C200 a_15960_61800# a_17524_61740# 0.01102f
C201 a_89880_80239# a_89421_74820# 1.40018f
C202 VDD a_59524_19880# 0.36505f
C203 a_51684_74200# VDD 0.36583f
C204 a_8147_83109# a_15960_61800# 0.2f
C205 VDD a_36974_109480# 0.3476f
C206 a_11924_109480# VDD 0.36569f
C207 a_17934_21000# a_17524_21000# 0.02581f
C208 a_39625_36740# a_39774_44940# 0.03434f
C209 a_39625_32882# a_41454_40880# 0.01988f
C210 VDD a_43844_15820# 0.36583f
C211 a_31640_61800# a_31934_61740# 0.01069f
C212 VDD a_31934_15820# 0.3412f
C213 a_9840_16064# a_9000_16064# 0.01686f
C214 a_45785_19940# a_58105_15880# 0.02344f
C215 a_12185_105682# a_12334_109480# 0.02481f
C216 a_30105_7822# a_29960_11680# 0.08298f
C217 a_53507_83249# a_59934_74200# 0.02134f
C218 a_15960_61800# a_16254_61740# 0.01363f
C219 a_39507_45729# a_39625_36740# 0.16398f
C220 a_89880_80239# a_92004_79940# 0.01231f
C221 VDD a_59934_15820# 0.3412f
C222 a_39507_45729# a_39625_32882# 0.20736f
C223 VDD a_58254_19880# 0.47195f
C224 a_6174_109480# VDD 0.3476f
C225 a_99409_69879# REFCK 0.60895f
C226 a_16105_86720# a_16254_86660# 0.03434f
C227 a_92189_81289# a_96334_91000# 0.02481f
C228 a_43987_62389# a_44105_61800# 0.99066f
C229 a_99409_69879# a_100476_69819# 0.03777f
C230 a_17934_21000# a_17667_11569# 0.01944f
C231 a_16254_94920# a_9827_83109# 0.02134f
C232 a_39625_32882# a_39625_36740# 0.10249f
C233 a_61204_36680# a_61320_36740# 0.01552f
C234 a_9420_18186# a_8580_18186# 0.01686f
C235 VDD a_61465_32882# 0.71507f
C236 a_57987_20669# a_61614_15820# 0.01993f
C237 a_11100_18186# a_10260_18186# 0.01686f
C238 VDD a_33614_15820# 0.35048f
C239 VDD a_30105_7822# 0.71507f
C240 a_89880_80239# a_90660_80179# 0.04804f
C241 VDD a_58105_7822# 0.71507f
C242 VDD a_57987_8209# 3.76336f
C243 a_104244_74760# REFCK 0.01652f
C244 a_92457_69640# a_97160_69580# 0.07382f
C245 a_6025_105682# VDD 1.8164f
C246 a_88109_80239# a_107394_69580# 0.02173f
C247 a_63000_32540# a_64974_32480# 0.01542f
C248 a_57844_11620# a_57960_11680# 0.01552f
C249 a_29987_8209# a_30105_15880# 0.03318f
C250 a_3667_12409# a_4800_16064# 0.01831f
C251 a_41044_40880# a_39625_32882# 0.01039f
C252 a_43960_61800# a_45934_61740# 0.01988f
C253 a_15844_61740# a_15960_61800# 0.02888f
C254 VDD a_62884_40880# 0.33996f
C255 a_31524_61740# a_31640_61800# 0.01998f
C256 a_19465_10700# a_17540_15224# 0.15612f
C257 VDD a_33204_15820# 0.36293f
C258 VDD a_31524_15820# 0.33996f
C259 a_92189_81289# a_89421_74820# 0.28292f
C260 a_43960_61800# a_44254_61740# 0.01069f
C261 VDD a_59524_15820# 0.33996f
C262 a_51800_61800# a_53774_61740# 0.02878f
C263 a_88109_80239# a_106984_69580# 0.01174f
C264 a_44105_7822# a_45934_15820# 0.01988f
C265 VDD a_45934_86520# 0.35048f
C266 a_61347_45729# a_64974_40880# 0.01993f
C267 VDD a_61614_40880# 0.3476f
C268 a_53507_83249# a_43987_62389# 1.09563f
C269 VDD a_30254_15820# 0.3476f
C270 a_29987_33269# a_30105_32882# 0.06415f
C271 VDD a_58254_15820# 0.3476f
C272 a_51800_61800# a_53364_61740# 0.01102f
C273 a_89421_69640# a_92457_69640# 0.63962f
C274 a_57987_20669# a_58105_15880# 0.11343f
C275 VDD a_15844_70140# 0.36583f
C276 a_88109_80239# a_88409_69640# 0.73465f
C277 a_29987_20669# a_30105_15880# 0.11343f
C278 a_92004_79940# a_89421_74820# 0.06035f
C279 VDD a_45524_86520# 0.36374f
C280 REFCK a_5614_21840# 0.04954f
C281 VDD a_61465_40940# 0.56243f
C282 a_23945_66000# a_24094_65940# 0.03434f
C283 a_43987_62389# a_43987_83109# 0.295f
C284 a_17540_17346# a_17540_15224# 0.01916f
C285 a_51800_61800# a_52094_61740# 0.01363f
C286 VDD a_61614_70140# 0.35048f
C287 VDD a_8265_61800# 2.55743f
C288 a_61465_32882# a_31785_45000# 0.08603f
C289 VDD a_45524_65800# 0.36374f
C290 a_45524_15820# a_44105_7822# 0.01039f
C291 a_43987_62389# a_51945_66000# 0.04945f
C292 a_50564_36680# a_50974_36680# 0.0129f
C293 PB a_89421_74820# 6.00877f
C294 FB a_51800_61800# 0.05558f
C295 VDD a_44254_86520# 0.35048f
C296 a_8265_61800# a_8414_65800# 0.0228f
C297 a_52094_74200# a_43987_83109# 0.02134f
C298 a_108664_69580# a_105420_69640# 0.01346f
C299 a_63000_32540# a_31785_45000# 0.11857f
C300 a_51800_82520# a_45667_83109# 0.2f
C301 a_45667_83109# a_53774_90860# 0.0199f
C302 a_31934_44940# a_30105_36740# 0.01095f
C303 VDD a_107476_74760# 1.21522f
C304 VDD a_44254_65800# 0.35048f
C305 VDD a_79124_34580# 0.50376f
C306 a_8265_61800# a_8004_65800# 0.01206f
C307 VDD a_3667_12409# 1.31007f
C308 FB a_45667_83109# 0.0391f
C309 a_89880_80239# VDD 0.71315f
C310 FB a_9827_83109# 0.08495f
C311 a_29960_36740# a_31934_36680# 0.01542f
C312 a_17540_17346# a_17667_11569# 0.01916f
C313 VDD a_79534_63700# 0.35048f
C314 a_103624_69580# a_88409_69640# 0.02384f
C315 a_17667_83249# a_31640_61800# 0.02811f
C316 a_92457_69640# a_100476_69819# 0.09314f
C317 a_3667_12409# a_3540_16064# 0.18841f
C318 a_43987_62389# a_59785_66000# 0.08746f
C319 VDD a_43844_65800# 0.36293f
C320 a_18084_109480# VDD 0.36569f
C321 VDD a_8147_83109# 6.50354f
C322 a_89764_80179# VDD 0.57901f
C323 a_106984_69580# a_105420_69640# 0.0241f
C324 a_31524_32480# a_31640_32540# 0.01552f
C325 a_88109_80239# a_89880_80239# 0.94909f
C326 VDD a_79124_63700# 0.36374f
C327 a_92457_69640# a_98860_69819# 0.15397f
C328 VDD a_45667_83109# 5.19303f
C329 REFCK a_23945_66000# 0.33634f
C330 a_59934_11620# a_57960_11680# 0.01542f
C331 a_61347_45729# a_61465_32882# 0.20736f
C332 VDD a_9827_83109# 5.21394f
C333 a_61465_40940# a_31785_45000# 0.02344f
C334 a_59640_7480# a_61614_7420# 0.01542f
C335 a_12334_109480# VDD 0.3476f
C336 a_89880_80239# a_88033_80029# 0.33907f
C337 a_30105_7822# a_30105_15880# 0.30783f
C338 a_59934_65940# a_59785_66000# 0.03434f
C339 VDD a_96334_91000# 0.3476f
C340 a_63000_32540# a_61347_45729# 0.12718f
C341 a_88420_80179# VDD 0.57886f
C342 a_61465_32882# a_61347_33269# 0.12305f
C343 VDD a_77854_63700# 0.35048f
C344 a_30254_36680# a_30105_36740# 0.01937f
C345 a_17667_83249# a_23945_66000# 0.04219f
C346 a_67364_61740# a_67480_61800# 0.01998f
C347 VDD a_51684_94920# 0.36583f
C348 VDD a_15844_94920# 0.36583f
C349 a_43844_11620# a_43960_11680# 0.01552f
C350 a_12185_105682# VDD 1.8164f
C351 a_89764_80179# a_88033_80029# 0.01005f
C352 a_31524_15820# a_30105_15880# 0.02368f
C353 ICP2 a_107476_74760# 0.02966f
C354 a_44254_65800# a_44105_61800# 0.0228f
C355 VDD a_92189_81289# 2.62644f
C356 a_51945_86720# a_45667_83109# 0.04219f
C357 VDD a_10094_65800# 0.35048f
C358 a_58105_7822# a_58105_15880# 0.30783f
C359 a_57987_8209# a_58105_15880# 0.03318f
C360 a_88109_80239# a_88420_80179# 0.01832f
C361 a_29960_36740# a_30105_36740# 0.2943f
C362 VDD a_16254_94920# 0.35048f
C363 VDD a_89421_74820# 7.94446f
C364 a_92457_69640# NB 1.05068f
C365 a_51800_61800# a_44105_61800# 0.04282f
C366 a_43960_11680# a_43987_20669# 0.07789f
C367 a_67480_61800# a_67774_61740# 0.01069f
C368 a_43844_65800# a_44105_61800# 0.01206f
C369 a_30254_15820# a_30105_15880# 0.02481f
C370 VDD a_80020_34580# 0.50376f
C371 a_50974_36680# VDD 0.58576f
C372 PB FB 0.04359f
C373 a_44105_7822# a_45640_7480# 0.04364f
C374 a_53507_83249# a_61614_70140# 0.0199f
C375 a_88109_80239# a_92189_81289# 0.01882f
C376 a_87640_80239# a_88420_80179# 0.04563f
C377 VDD a_9684_65800# 0.36374f
C378 a_59524_15820# a_58105_15880# 0.02368f
C379 a_33614_61740# a_31640_61800# 0.01988f
C380 a_3667_12409# a_3524_11760# 0.01059f
C381 a_89421_69640# NB 2.8447f
C382 VDD a_92004_79940# 0.8306f
C383 a_61347_45729# a_61465_40940# 0.11343f
C384 a_41454_36680# a_39480_36740# 0.01542f
C385 a_8147_62389# a_8265_61800# 0.99066f
C386 a_88109_80239# a_89421_74820# 0.12843f
C387 REFCK a_17667_83249# 0.53089f
C388 a_50564_36680# VDD 0.58512f
C389 a_61465_40940# a_61347_33269# 0.03318f
C390 a_44105_7822# a_45524_7420# 0.01247f
C391 a_58254_15820# a_58105_15880# 0.02481f
C392 a_19465_10700# a_19614_21000# 0.08382f
C393 a_29960_36740# a_29987_45729# 0.07789f
C394 a_29987_8209# a_30254_11620# 0.01937f
C395 a_29987_45729# a_30105_36740# 0.16398f
C396 VDD PB 44.8378f
C397 VDD a_90660_80179# 0.58095f
C398 a_43960_11680# a_31785_19940# 0.05307f
C399 a_87640_80239# a_89421_74820# 4.15078f
C400 VDD a_31524_19880# 0.36505f
C401 a_61320_36740# a_31785_45000# 0.05307f
C402 a_44254_61740# a_44105_61800# 0.01991f
C403 a_19204_21000# a_19614_21000# 0.02581f
C404 ICP2 a_92189_81289# 1.23339f
C405 a_3524_21840# a_3934_21840# 0.0129f
C406 a_17934_82460# a_15960_82520# 0.02878f
C407 a_17524_82460# a_16105_86720# 0.03653f
C408 VDD a_3524_21840# 0.63535f
C409 a_88109_80239# a_90660_80179# 0.01848f
C410 a_88109_80239# PB 0.13868f
C411 a_44105_7822# a_43987_8209# 0.12305f
C412 a_45785_19940# a_59640_7480# 0.11857f
C413 a_51684_82460# a_51800_82520# 0.02888f
C414 a_51800_61800# a_43987_83109# 0.2f
C415 a_16105_66000# a_17524_61740# 0.03653f
C416 a_8147_83109# a_8147_62389# 0.295f
C417 a_3667_12409# a_10680_16064# 0.04323f
C418 a_43960_61800# a_44105_61800# 0.1904f
C419 a_53507_83249# a_45667_83109# 1.05574f
C420 a_8147_83109# a_16105_66000# 0.04219f
C421 a_43960_82520# a_45667_83109# 0.04098f
C422 a_99409_69879# a_88409_69640# 0.12321f
C423 a_19204_21000# a_19465_10700# 0.01114f
C424 REFCK NB 0.04457f
C425 a_17524_82460# a_15960_82520# 0.01102f
C426 VDD a_89764_91000# 0.36569f
C427 PB a_3540_180844# 6.47508f
C428 a_33614_11962# a_31785_19940# 0.01732f
C429 a_31785_19940# a_43987_20669# 0.21093f
C430 a_87640_80239# PB 5.69516f
C431 a_51800_61800# a_51945_66000# 0.32751f
C432 REFCK a_87460_74760# 0.01822f
C433 VDD a_43987_20669# 2.04275f
C434 a_30105_40940# a_30254_40880# 0.02481f
C435 a_43987_83109# a_45667_83109# 0.03975f
C436 a_52094_90860# a_45667_83109# 0.0257f
C437 a_16105_86720# a_17667_83249# 0.33634f
C438 a_29987_45729# a_30105_40940# 0.11343f
C439 VDD a_53774_90860# 0.35048f
C440 a_61320_36740# a_61347_45729# 0.07789f
C441 a_31785_19940# a_31934_19880# 0.02332f
C442 a_33614_40880# a_29987_45729# 0.01993f
C443 a_17524_10640# a_17934_10640# 0.0129f
C444 a_8147_62389# a_15960_61800# 0.03276f
C445 ICP2 PB 0.08816f
C446 VCTRL REFCK 0.04207f
C447 VDD FB 15.276f
C448 VDD a_5204_21840# 0.63535f
C449 a_16105_66000# a_15960_61800# 0.32751f
C450 a_17667_83249# a_15960_82520# 0.05558f
C451 VDD a_31934_19880# 0.34666f
C452 a_57987_20669# a_59934_7420# 0.01645f
C453 a_29987_33269# a_50974_36680# 0.04066f
C454 a_29960_36740# a_29844_36680# 0.01552f
C455 a_61320_36740# a_61347_33269# 0.2943f
C456 a_3667_12409# a_9000_16064# 0.01831f
C457 VDD a_53364_90860# 0.36374f
C458 a_29844_11620# a_29960_11680# 0.01552f
C459 a_51800_82520# a_51945_86720# 0.32751f
C460 a_8414_61740# a_8265_61800# 0.01991f
C461 VDD a_31785_19940# 4.78669f
C462 VDD a_3934_21840# 0.60202f
C463 VDD a_95924_91000# 0.36569f
C464 a_57987_20669# a_59640_7480# 0.12718f
C465 a_3960_16064# a_3667_12409# 0.0136f
C466 a_29987_33269# a_50564_36680# 0.02019f
C467 a_44105_15880# a_44105_7822# 0.30783f
C468 VDD a_24654_109480# 0.3476f
C469 a_29987_8209# a_19465_10700# 1.12918f
C470 a_17667_83249# a_24094_70140# 0.02583f
C471 a_43960_61800# a_43987_83109# 0.04098f
C472 a_8160_16064# a_9000_16064# 0.01686f
C473 VDD a_8414_65800# 0.35048f
C474 a_3540_16064# a_3934_21840# 0.05193f
C475 a_43987_62389# a_69454_65800# 0.0199f
C476 a_8120_61800# a_8265_61800# 0.1904f
C477 a_89421_69640# a_108664_69580# 0.02406f
C478 VDD a_3540_16064# 1.8775f
C479 a_39774_36680# a_39625_36740# 0.01937f
C480 VDD a_90174_91000# 0.3476f
C481 NB a_87460_74760# 0.01535f
C482 a_7740_18186# a_8580_18186# 0.01686f
C483 a_44105_15880# a_45524_15820# 0.02368f
C484 a_15960_82520# a_16254_82460# 0.01363f
C485 a_77444_59640# a_77560_59700# 0.01998f
C486 a_16105_86720# a_15960_82520# 0.32751f
C487 VDD a_9684_86520# 0.36374f
C488 a_88109_80239# VDD 2.80864f
C489 a_45524_7420# a_45640_7480# 0.01552f
C490 VDD a_8004_65800# 0.36293f
C491 a_43987_62389# REFCK 0.09584f
C492 a_73225_30440# a_73374_34440# 0.0476f
C493 a_8004_61740# a_8265_61800# 0.01292f
C494 FB FS 7.66747f
C495 a_97160_69580# a_88409_69640# 0.02095f
C496 a_29960_36740# a_30105_32882# 0.08298f
C497 VDD a_88033_80029# 3.28731f
C498 VDD a_51945_86720# 0.25015f
C499 ICP2 FB 0.04359f
C500 FB a_44105_61800# 0.09893f
C501 a_44105_15880# a_44254_15820# 0.02481f
C502 a_45785_19940# a_57987_20669# 0.21093f
C503 a_30105_36740# a_30105_32882# 0.10249f
C504 a_29987_20669# a_19465_10700# 0.21093f
C505 a_45785_19940# a_43987_8209# 0.32735f
C506 a_41044_32480# a_41160_32540# 0.01552f
C507 a_87640_80239# VDD 11.3049f
C508 VDD a_8414_86520# 0.35048f
C509 VDD a_51684_70140# 0.36583f
C510 a_50974_36680# a_41305_45000# 0.01196f
C511 a_6480_16064# a_5640_16064# 0.01686f
C512 a_5204_11760# a_3540_16064# 0.01304f
C513 a_61320_36740# a_63294_36680# 0.01542f
C514 a_88033_80029# a_90174_91000# 0.02481f
C515 a_51945_86720# a_52094_86660# 0.03434f
C516 VDD a_61204_70140# 0.36374f
C517 a_72964_34440# a_73374_34440# 0.0129f
C518 a_92457_69640# a_88409_69640# 0.25069f
C519 REFCK a_5220_18186# 0.02059f
C520 a_45785_19940# a_45934_19880# 0.02332f
C521 a_8147_83109# a_8120_61800# 0.04098f
C522 a_88109_80239# a_88033_80029# 0.23489f
C523 a_15844_82460# a_15960_82520# 0.02888f
C524 a_53507_83249# a_67480_61800# 0.02811f
C525 a_6060_18186# a_5220_18186# 0.01686f
C526 ICP2 a_95924_91000# 0.01161f
C527 a_29987_8209# a_30254_19880# 0.03434f
C528 a_19204_10640# a_19614_10640# 0.0129f
C529 a_87524_80179# VDD 0.58135f
C530 VDD a_8004_86520# 0.36293f
C531 VDD FS 2.07475f
C532 VDD ICP2 4.57908f
C533 VDD a_44105_61800# 2.55743f
C534 a_50564_36680# a_41305_45000# 0.01245f
C535 a_87640_80239# a_88109_80239# 0.60128f
C536 a_53507_83249# a_51800_82520# 0.05558f
C537 a_43987_8209# a_45524_19880# 0.01132f
C538 VDD a_59934_70140# 0.35048f
C539 a_63294_32480# a_61347_45729# 0.01645f
C540 a_89421_69640# a_88409_69640# 3.11374f
C541 VDD a_31785_45000# 7.34166f
C542 a_29987_45729# a_30105_32882# 0.20736f
C543 VDD a_39774_40880# 0.3476f
C544 a_87640_80239# a_88033_80029# 0.20413f
C545 VDD a_24094_74200# 0.35048f
C546 a_45785_19940# a_47614_11962# 0.01732f
C547 a_88109_80239# a_104034_69580# 0.02291f
C548 a_3934_11760# a_3540_16064# 0.02665f
C549 a_53507_83249# FB 0.4834f
C550 a_45667_83109# a_52094_82460# 0.03106f
C551 a_39507_45729# a_41454_32480# 0.01645f
C552 VDD a_25774_70140# 0.35048f
C553 a_51945_66000# a_53364_61740# 0.03653f
C554 a_23800_61800# a_23945_66000# 0.32751f
C555 a_88109_80239# ICP2 0.39471f
C556 a_43987_8209# a_44254_19880# 0.03434f
C557 a_63294_44940# FB 0.02332f
C558 VDD a_59524_70140# 0.36583f
C559 a_30105_40940# a_30105_32882# 0.30783f
C560 a_33614_32480# a_31640_32540# 0.01542f
C561 a_43987_83109# a_52094_61740# 0.03106f
C562 VDD a_31524_44940# 0.36505f
C563 a_12185_105682# a_18345_105682# 0.06039f
C564 VDD a_39625_40940# 0.56243f
C565 ICP2 a_88033_80029# 0.14639f
C566 VDD a_23684_74200# 0.36583f
C567 a_29987_33269# VDD 2.15043f
C568 a_29987_20669# a_30254_19880# 0.01183f
C569 REFCK a_5640_16064# 0.02059f
C570 FB a_43987_83109# 2.05056f
C571 a_31934_15820# a_19465_10700# 0.01096f
C572 ICP2 a_3540_180844# 6.47508f
C573 a_39507_45729# a_41160_32540# 0.12718f
C574 a_87524_80179# a_87640_80239# 0.04246f
C575 a_43960_82520# a_45934_82460# 0.01988f
C576 a_61614_61740# a_59640_61800# 0.02878f
C577 VDD a_61614_15820# 0.35048f
C578 a_44105_61800# a_51684_70140# 0.01059f
C579 a_58105_7822# a_59640_7480# 0.04364f
C580 VDD a_43844_86520# 0.36293f
C581 VDD a_30254_44940# 0.47195f
C582 a_30105_40940# a_31524_40880# 0.02368f
C583 FB a_61347_33269# 0.32735f
C584 a_53507_83249# VDD 5.14465f
C585 a_101944_69580# a_88409_69640# 0.02538f
C586 a_39625_32882# a_41160_32540# 0.04364f
C587 VDD a_30814_109480# 0.3476f
C588 a_12185_105682# a_12334_105622# 0.01511f
C589 VDD a_61204_40880# 0.36583f
C590 FB a_51945_66000# 0.33634f
C591 VDD a_39364_40880# 0.36583f
C592 a_99409_69879# PB 0.11079f
C593 a_3960_16064# a_4800_16064# 0.01686f
C594 VDD a_8147_62389# 3.95467f
C595 a_63294_44940# VDD 0.34666f
C596 a_29987_20669# a_29987_8209# 0.19885f
C597 a_30105_7822# a_19465_10700# 0.08603f
C598 a_61204_61740# a_59785_66000# 0.03653f
C599 VDD a_16105_66000# 0.25015f
C600 VDD a_61614_44940# 0.47195f
C601 a_10094_61740# a_8120_61800# 0.01988f
C602 a_45934_19880# a_43987_8209# 0.01095f
C603 a_61204_61740# a_59640_61800# 0.01102f
C604 VDD LO 0.53924f
C605 VDD a_61204_15820# 0.36293f
C606 VDD a_43987_83109# 6.50354f
C607 VDD a_61347_45729# 2.04275f
C608 a_3540_18186# a_4380_18186# 0.01686f
C609 a_52094_90860# VDD 0.35048f
C610 a_45785_19940# a_59934_15820# 0.01096f
C611 a_44105_7822# a_44254_7762# 0.01511f
C612 VDD a_30105_15880# 0.56243f
C613 a_88109_80239# a_105420_69640# 0.24814f
C614 VDD a_43134_40880# 0.35048f
C615 a_23800_61800# REFCK 0.05558f
C616 a_6480_16064# a_7320_16064# 0.01686f
C617 a_62884_44940# VDD 0.36505f
C618 a_3667_12409# a_6480_16064# 0.01831f
C619 a_31934_40880# a_30105_32882# 0.01988f
C620 VDD a_61347_33269# 3.76336f
C621 a_53507_83249# a_51945_86720# 0.33634f
C622 VDD a_51945_66000# 0.25015f
C623 VDD a_41454_44940# 0.34666f
C624 a_47614_15820# a_43987_20669# 0.01993f
C625 a_57987_8209# a_45785_19940# 1.12918f
C626 a_51684_90860# VDD 0.36583f
C627 a_6060_18186# a_6900_18186# 0.01686f
C628 a_45785_19940# a_58105_7822# 0.08603f
C629 FB a_59785_66000# 0.33634f
C630 VDD a_29844_15820# 0.36583f
C631 VDD a_42724_40880# 0.36293f
C632 VDD a_30404_109480# 0.36569f
C633 a_23800_61800# a_17667_83249# 0.2f
C634 VDD a_58105_15880# 0.56243f
C635 a_59640_61800# FB 0.05558f
C636 a_31640_7480# a_19465_10700# 0.11857f
C637 a_61465_32882# a_63294_40880# 0.01988f
C638 a_8147_83109# a_16254_74200# 0.02134f
C639 a_43987_62389# a_67774_65800# 0.0228f
C640 a_8147_83109# a_17934_70140# 0.0199f
C641 VDD a_61204_44940# 0.50082f
C642 a_3540_18186# a_3540_16064# 0.02059f
C643 a_39625_40940# a_31785_45000# 0.03318f
C644 REFCK a_8265_61800# 0.33739f
C645 VDD a_41305_45000# 3.00664f
C646 a_29987_33269# a_31785_45000# 0.19491f
C647 a_50564_36680# a_49145_36740# 0.04818f
C648 a_39625_40940# a_39774_40880# 0.02481f
C649 a_51800_82520# a_53774_82460# 0.02878f
C650 a_44105_15880# a_43987_8209# 0.03318f
C651 ICP2 a_105420_69640# 0.07806f
C652 VDD a_57844_15820# 0.36583f
C653 a_59640_7480# a_59524_7420# 0.01552f
C654 a_43987_62389# a_67364_65800# 0.01206f
C655 a_53507_83249# a_59934_70140# 0.02583f
C656 VDD a_59785_66000# 0.25015f
C657 VDD a_45934_65800# 0.35048f
C658 NB a_88409_69640# 2.9465f
C659 a_105860_74760# VDD 1.21522f
C660 a_51800_82520# a_53364_82460# 0.01102f
C661 a_17934_10640# a_17540_15224# 0.05033f
C662 a_44105_61800# a_43987_83109# 0.52099f
C663 a_3667_12409# REFCK 0.04457f
C664 VDD a_47614_15820# 0.35048f
C665 a_58254_19880# a_57987_20669# 0.01183f
C666 a_77560_59700# a_79534_59640# 0.01988f
C667 a_29987_8209# a_30105_7822# 0.12305f
C668 a_8147_83109# a_16254_70140# 0.02583f
C669 a_105420_69640# a_105714_69580# 0.01069f
C670 VDD a_24244_109480# 0.36569f
C671 a_61347_45729# a_31785_45000# 0.21093f
C672 a_8004_82460# a_8120_82520# 0.01998f
C673 a_43960_82520# a_44254_82460# 0.01069f
C674 a_17934_90860# a_9827_83109# 0.0199f
C675 a_99409_69879# VDD 3.98171f
C676 a_51800_82520# a_52094_82460# 0.01363f
C677 a_3960_16064# a_3540_16064# 0.05914f
C678 a_3667_12409# a_9840_16064# 0.01831f
C679 a_8147_83109# REFCK 2.13096f
C680 a_61347_33269# a_31785_45000# 1.12361f
C681 VDD a_47204_15820# 0.36293f
C682 a_57987_20669# a_58105_7822# 0.20736f
C683 a_57987_8209# a_57987_20669# 0.19885f
C684 VDD a_17540_15224# 2.39737f
C685 a_59524_70140# a_43987_83109# 0.01059f
C686 VDD a_18494_109480# 0.3476f
C687 a_16105_66000# a_16254_65940# 0.03434f
C688 a_31524_40880# a_30105_32882# 0.01039f
C689 a_104244_74760# VDD 3.38049f
C690 a_8147_83109# a_17667_83249# 0.16716f
C691 a_88109_80239# a_99409_69879# 0.38321f
C692 a_77560_59700# a_77854_59640# 0.01069f
C693 VDD a_17524_21000# 1.15306f
C694 a_29987_20669# a_33614_15820# 0.01993f
C695 a_29987_20669# a_30105_7822# 0.20736f
C696 a_8147_62389# a_16105_66000# 0.04945f
C697 a_41305_45000# a_31785_45000# 0.22515f
C698 a_105304_69580# a_105420_69640# 0.01998f
C699 a_53507_83249# a_43987_83109# 0.16716f
C700 a_43960_82520# a_43987_83109# 0.02811f
C701 VDD a_18345_105682# 1.8164f
C702 a_17667_83249# a_9827_83109# 1.05756f
C703 a_25364_61740# a_23945_66000# 0.03653f
C704 a_89421_74820# a_92900_79940# 0.0642f
C705 a_44105_61800# a_45934_65800# 0.0199f
C706 REFCK a_15960_61800# 0.05558f
C707 a_44105_7822# a_43960_11680# 0.08298f
C708 a_5204_21840# a_5614_21840# 0.0129f
C709 a_17524_10640# a_17667_11569# 0.01407f
C710 a_61347_45729# a_61614_44940# 0.01183f
C711 a_87640_80239# a_99409_69879# 0.05879f
C712 VDD a_49294_36680# 0.60202f
C713 VDD a_17667_11569# 1.5661f
C714 a_6025_105682# a_6174_105622# 0.01511f
C715 a_29987_20669# a_31934_7420# 0.01645f
C716 a_19204_10640# a_17540_15224# 0.01632f
C717 a_63294_44940# a_61347_33269# 0.01095f
C718 a_61347_33269# a_61614_44940# 0.03434f
C719 a_31934_11620# a_29960_11680# 0.01542f
C720 REFCK a_89421_74820# 0.05659f
C721 VDD a_41044_44940# 0.36505f
C722 a_29987_33269# a_41305_45000# 0.74032f
C723 a_57987_8209# a_59934_19880# 0.01095f
C724 a_51945_86720# a_53364_82460# 0.03653f
C725 a_61347_45729# a_61347_33269# 0.19885f
C726 a_99409_69879# ICP2 0.02629f
C727 a_43987_83109# a_51945_66000# 0.04219f
C728 VDD a_49145_36740# 0.89698f
C729 VDD a_5614_21840# 0.60202f
C730 a_39364_44940# VDD 0.50082f
C731 a_29987_20669# a_31640_7480# 0.12718f
C732 a_53507_83249# a_59934_61740# 0.03106f
C733 a_62884_44940# a_61347_33269# 0.01132f
C734 a_61347_33269# a_61614_36680# 0.01937f
C735 VDD a_39774_44940# 0.47195f
C736 VDD a_41454_40880# 0.3412f
C737 a_16254_82460# a_9827_83109# 0.03106f
C738 NB a_45667_83109# 0.11332f
C739 a_16105_86720# a_9827_83109# 0.04219f
C740 a_44105_7822# a_43987_20669# 0.20736f
C741 a_57987_8209# a_59524_19880# 0.01132f
C742 NB a_9827_83109# 0.0369f
C743 a_45785_19940# a_57960_11680# 0.05307f
C744 a_45640_7480# a_47614_7420# 0.01542f
C745 a_53507_83249# a_59785_66000# 0.04219f
C746 VDD a_48884_36680# 0.63502f
C747 a_39507_45729# VDD 2.04275f
C748 a_6025_105682# a_11924_109480# 0.01161f
C749 a_53507_83249# a_59640_61800# 0.2f
C750 a_30105_7822# a_31934_15820# 0.01988f
C751 PB REFCK 0.53983f
C752 VDD a_39625_36740# 1.7955f
C753 VDD a_39625_32882# 0.71507f
C754 a_15960_82520# a_9827_83109# 0.2f
C755 VDD a_33614_65800# 0.35048f
C756 VDD a_31524_65800# 0.36293f
C757 a_57987_8209# a_58254_19880# 0.03434f
C758 a_45934_15820# a_31785_19940# 0.01096f
C759 a_58105_7822# a_59934_15820# 0.01988f
C760 a_31934_32480# a_29987_45729# 0.01645f
C761 a_16254_90860# a_9827_83109# 0.02583f
C762 a_31934_44940# VDD 0.34666f
C763 a_6025_105682# a_6174_109480# 0.02481f
C764 VDD a_45934_15820# 0.3412f
C765 a_59640_61800# a_43987_83109# 0.04282f
C766 a_41305_45000# a_41454_44940# 0.02332f
C767 a_63000_32540# a_61465_32882# 0.04364f
C768 VDD a_41044_40880# 0.33996f
C769 VDD a_33204_65800# 0.36374f
C770 VDD a_5764_109480# 0.36569f
C771 a_44105_7822# a_31785_19940# 0.08603f
C772 a_57987_8209# a_58105_7822# 0.12305f
C773 a_33614_37022# a_31785_45000# 0.01732f
C774 a_31640_32540# a_29987_45729# 0.12718f
C775 a_24094_61740# a_17667_83249# 0.03106f
C776 a_62884_40880# a_61465_32882# 0.01039f
C777 VDD a_44105_7822# 0.71507f
C778 a_73374_30380# a_73225_30440# 0.02481f
C779 a_31524_15820# a_30105_7822# 0.01039f
C780 a_8147_83109# a_23684_70140# 0.01059f
C781 VDD a_16254_74200# 0.35048f
C782 VDD a_17934_70140# 0.35048f
C783 a_62884_32480# a_61465_32882# 0.01247f
C784 a_43844_61740# a_43960_61800# 0.01998f
C785 a_88109_80239# a_92457_69640# 0.75324f
C786 VDD a_23945_66000# 0.25015f
C787 a_49145_36740# a_31785_45000# 0.0727f
C788 VDD a_31934_65800# 0.35048f
C789 a_43987_62389# a_51800_61800# 0.03276f
C790 a_3667_12409# REFIN 6.99565f
C791 a_59524_15820# a_58105_7822# 0.01039f
C792 a_52094_94920# a_45667_83109# 0.02134f
C793 a_62884_32480# a_63000_32540# 0.01552f
C794 VDD a_45524_15820# 0.33996f
C795 VDD a_17934_21000# 1.0895f
C796 a_59640_61800# a_59934_61740# 0.01363f
C797 a_57987_20669# a_57960_11680# 0.07789f
C798 a_8120_61800# a_8147_62389# 0.03744f
C799 a_30105_7822# a_31640_7480# 0.04364f
C800 VDD a_77444_63700# 0.36293f
C801 VDD a_15844_74200# 0.36583f
C802 VDD a_17524_70140# 0.36374f
C803 a_61614_32822# a_61465_32882# 0.01511f
C804 a_88109_80239# a_89421_69640# 0.70966f
C805 a_51945_66000# a_52094_65940# 0.03434f
C806 a_48884_36680# a_31785_45000# 0.0155f
C807 a_8147_83109# a_8120_82520# 0.02811f
C808 REFCK FB 7.32182f
C809 PB NB 0.58697f
C810 a_39507_45729# a_31785_45000# 0.04457f
C811 a_59640_61800# a_59785_66000# 0.32751f
C812 a_61465_40940# a_61465_32882# 0.30783f
C813 a_29987_33269# a_49145_36740# 0.38839f
C814 VDD a_44254_15820# 0.3476f
C815 VDD a_17934_90860# 0.35048f
C816 a_39625_32882# a_31785_45000# 0.07691f
C817 a_43134_37022# a_41305_45000# 0.01732f
C818 a_30105_7822# a_31524_7420# 0.01247f
C819 a_9827_83109# a_8120_82520# 0.04098f
C820 VDD a_69454_65800# 0.35048f
C821 VDD a_92900_79940# 0.8306f
C822 VDD a_16254_70140# 0.35048f
C823 LO a_17667_11569# 2.92289f
C824 a_89421_69640# a_109236_69580# 0.02301f
C825 FB a_17667_83249# 0.08577f
C826 a_31934_44940# a_31785_45000# 0.02332f
C827 VDD a_30105_36740# 1.7955f
C828 a_39507_45729# a_39625_40940# 0.11343f
C829 a_61465_40940# a_62884_40880# 0.02368f
C830 a_59524_61740# a_59640_61800# 0.02888f
C831 a_29987_33269# a_39507_45729# 0.04359f
C832 VDD a_17524_90860# 0.36374f
C833 a_58105_7822# a_59524_7420# 0.01247f
C834 a_45934_7420# a_43987_20669# 0.01645f
C835 VDD REFCK 14.1921f
R0 NB NB.n16 197.762
R1 NB.n0 NB.t0 36.0256
R2 NB.n8 NB.t17 36.0256
R3 NB.n7 NB.n6 21.4256
R4 NB.n6 NB.n5 21.4256
R5 NB.n5 NB.n4 21.4256
R6 NB.n4 NB.n3 21.4256
R7 NB.n3 NB.n2 21.4256
R8 NB.n2 NB.n1 21.4256
R9 NB.n1 NB.n0 21.4256
R10 NB.n15 NB.n14 21.4256
R11 NB.n14 NB.n13 21.4256
R12 NB.n13 NB.n12 21.4256
R13 NB.n12 NB.n11 21.4256
R14 NB.n11 NB.n10 21.4256
R15 NB.n10 NB.n9 21.4256
R16 NB.n9 NB.n8 21.4256
R17 NB.n7 NB.t8 14.6005
R18 NB.n6 NB.t7 14.6005
R19 NB.n5 NB.t6 14.6005
R20 NB.n4 NB.t5 14.6005
R21 NB.n3 NB.t4 14.6005
R22 NB.n2 NB.t3 14.6005
R23 NB.n1 NB.t2 14.6005
R24 NB.n0 NB.t1 14.6005
R25 NB.n15 NB.t9 14.6005
R26 NB.n14 NB.t10 14.6005
R27 NB.n13 NB.t11 14.6005
R28 NB.n12 NB.t12 14.6005
R29 NB.n11 NB.t13 14.6005
R30 NB.n10 NB.t14 14.6005
R31 NB.n9 NB.t15 14.6005
R32 NB.n8 NB.t16 14.6005
R33 NB.n16 NB.n7 10.7131
R34 NB.n16 NB.n15 10.7131
R35 FB.n6 FB.n5 307.324
R36 FB.n6 FB.n2 162.463
R37 FB.n1 FB.t3 83.4615
R38 FB.n3 FB.t5 79.3953
R39 FB.n4 FB.t4 79.3953
R40 FB.n1 FB.t2 71.9829
R41 FB.n3 FB.t7 69.771
R42 FB.n4 FB.t6 69.771
R43 FB.n5 FB.n4 54.1025
R44 FB.n2 FB.n0 32.0165
R45 FB.n0 FB.t1 31.3624
R46 FB FB.n6 30.1895
R47 FB.n5 FB.n3 15.2525
R48 FB.n2 FB.n1 12.9425
R49 FB.n0 FB.t0 10.4466
R50 REFCK REFCK.n4 270.705
R51 REFCK.n4 REFCK.n3 124.794
R52 REFCK.n0 REFCK.t3 79.3953
R53 REFCK.n1 REFCK.t2 79.3953
R54 REFCK.n0 REFCK.t5 69.771
R55 REFCK.n1 REFCK.t4 69.771
R56 REFCK.n4 REFCK.n2 59.3945
R57 REFCK.n2 REFCK.n1 54.1025
R58 REFCK.n3 REFCK.t1 28.2779
R59 REFCK.n2 REFCK.n0 15.2525
R60 REFCK.n3 REFCK.t0 7.23865
R61 PB PB.n30 241.123
R62 PB.n0 PB.t0 36.0256
R63 PB.n15 PB.t31 36.0256
R64 PB.n14 PB.n13 21.4256
R65 PB.n13 PB.n12 21.4256
R66 PB.n12 PB.n11 21.4256
R67 PB.n11 PB.n10 21.4256
R68 PB.n10 PB.n9 21.4256
R69 PB.n9 PB.n8 21.4256
R70 PB.n8 PB.n7 21.4256
R71 PB.n7 PB.n6 21.4256
R72 PB.n6 PB.n5 21.4256
R73 PB.n5 PB.n4 21.4256
R74 PB.n4 PB.n3 21.4256
R75 PB.n3 PB.n2 21.4256
R76 PB.n2 PB.n1 21.4256
R77 PB.n1 PB.n0 21.4256
R78 PB.n29 PB.n28 21.4256
R79 PB.n28 PB.n27 21.4256
R80 PB.n27 PB.n26 21.4256
R81 PB.n26 PB.n25 21.4256
R82 PB.n25 PB.n24 21.4256
R83 PB.n24 PB.n23 21.4256
R84 PB.n23 PB.n22 21.4256
R85 PB.n22 PB.n21 21.4256
R86 PB.n21 PB.n20 21.4256
R87 PB.n20 PB.n19 21.4256
R88 PB.n19 PB.n18 21.4256
R89 PB.n18 PB.n17 21.4256
R90 PB.n17 PB.n16 21.4256
R91 PB.n16 PB.n15 21.4256
R92 PB.n14 PB.t15 14.6005
R93 PB.n13 PB.t14 14.6005
R94 PB.n12 PB.t13 14.6005
R95 PB.n11 PB.t12 14.6005
R96 PB.n10 PB.t11 14.6005
R97 PB.n9 PB.t10 14.6005
R98 PB.n8 PB.t9 14.6005
R99 PB.n7 PB.t8 14.6005
R100 PB.n6 PB.t7 14.6005
R101 PB.n5 PB.t6 14.6005
R102 PB.n4 PB.t5 14.6005
R103 PB.n3 PB.t4 14.6005
R104 PB.n2 PB.t3 14.6005
R105 PB.n1 PB.t2 14.6005
R106 PB.n0 PB.t1 14.6005
R107 PB.n29 PB.t16 14.6005
R108 PB.n28 PB.t17 14.6005
R109 PB.n27 PB.t18 14.6005
R110 PB.n26 PB.t19 14.6005
R111 PB.n25 PB.t20 14.6005
R112 PB.n24 PB.t21 14.6005
R113 PB.n23 PB.t22 14.6005
R114 PB.n22 PB.t23 14.6005
R115 PB.n21 PB.t24 14.6005
R116 PB.n20 PB.t25 14.6005
R117 PB.n19 PB.t26 14.6005
R118 PB.n18 PB.t27 14.6005
R119 PB.n17 PB.t28 14.6005
R120 PB.n16 PB.t29 14.6005
R121 PB.n15 PB.t30 14.6005
R122 PB.n30 PB.n14 10.7131
R123 PB.n30 PB.n29 10.7131
R124 ICP2 ICP2.n2 268.308
R125 ICP2.n1 ICP2.t3 76.6929
R126 ICP2.n2 ICP2.n0 66.2709
R127 ICP2.n0 ICP2.t1 56.5065
R128 ICP2.n0 ICP2.t0 56.5065
R129 ICP2.n1 ICP2.t2 48.3305
R130 ICP2.n2 ICP2.n1 14.4125
R131 VCTRL VCTRL.n0 227.115
R132 VCTRL.n0 VCTRL.t0 183.583
R133 VCTRL.n0 VCTRL.t1 47.8277
R134 a_29987_37189.t0 a_29987_37189.n6 154.225
R135 a_29987_37189.n0 a_29987_37189.t5 66.3798
R136 a_29987_37189.n3 a_29987_37189.t4 66.3798
R137 a_29987_37189.n1 a_29987_37189.t8 62.8869
R138 a_29987_37189.n4 a_29987_37189.t6 62.8869
R139 a_29987_37189.n1 a_29987_37189.t9 62.1159
R140 a_29987_37189.n4 a_29987_37189.t7 62.1159
R141 a_29987_37189.n0 a_29987_37189.t3 61.9308
R142 a_29987_37189.n3 a_29987_37189.t2 61.9308
R143 a_29987_37189.n6 a_29987_37189.n5 54.4565
R144 a_29987_37189.t1 a_29987_37189.t0 31.3624
R145 a_29987_37189.n6 a_29987_37189.n2 21.8285
R146 a_29987_37189.n2 a_29987_37189.n0 6.4865
R147 a_29987_37189.n5 a_29987_37189.n3 6.4865
R148 a_29987_37189.n2 a_29987_37189.n1 4.5005
R149 a_29987_37189.n5 a_29987_37189.n4 4.5005
R150 a_36825_105682.t0 a_36825_105682.n0 184.656
R151 a_36825_105682.n0 a_36825_105682.t2 84.1509
R152 a_36825_105682.n0 a_36825_105682.t3 61.6959
R153 a_36825_105682.t1 a_36825_105682.t0 17.4124
R154 a_36707_106069.n2 a_36707_106069.n0 109.597
R155 a_36707_106069.n2 a_36707_106069.n1 108.811
R156 a_36707_106069.n0 a_36707_106069.t5 83.7789
R157 a_36707_106069.n5 a_36707_106069.t8 83.4129
R158 a_36707_106069.n1 a_36707_106069.t10 76.6929
R159 a_36707_106069.n3 a_36707_106069.t3 70.611
R160 a_36707_106069.n5 a_36707_106069.t7 67.2612
R161 a_36707_106069.n3 a_36707_106069.t4 67.041
R162 a_36707_106069.n0 a_36707_106069.t6 61.6959
R163 a_36707_106069.n6 a_36707_106069.n4 56.2025
R164 a_36707_106069.n1 a_36707_106069.t9 48.3305
R165 a_36707_106069.n4 a_36707_106069.n3 38.5625
R166 a_36707_106069.t0 a_36707_106069.t2 23.2264
R167 a_36707_106069.n4 a_36707_106069.n2 22.7465
R168 a_36707_106069.n6 a_36707_106069.n5 18.8885
R169 a_36707_106069.t1 a_36707_106069.n6 16.7225
R170 a_36707_106069.t2 a_36707_106069.t1 2.9165
R171 a_30665_105682.t0 a_30665_105682.n4 218.719
R172 a_30665_105682.n0 a_30665_105682.t7 76.6929
R173 a_30665_105682.n1 a_30665_105682.t2 72.2797
R174 a_30665_105682.n1 a_30665_105682.t3 72.2797
R175 a_30665_105682.n2 a_30665_105682.t4 72.2797
R176 a_30665_105682.n2 a_30665_105682.t5 72.2797
R177 a_30665_105682.n0 a_30665_105682.t6 48.3305
R178 a_30665_105682.n4 a_30665_105682.n0 31.4645
R179 a_30665_105682.t1 a_30665_105682.t0 17.4124
R180 a_30665_105682.n3 a_30665_105682.n1 9.22887
R181 a_30665_105682.n3 a_30665_105682.n2 6.53487
R182 a_30665_105682.n4 a_30665_105682.n3 4.5005
R183 a_8265_82520.n2 a_8265_82520.n1 99.5045
R184 a_8265_82520.n2 a_8265_82520.n0 85.9865
R185 a_8265_82520.n1 a_8265_82520.t4 76.9029
R186 a_8265_82520.n0 a_8265_82520.t7 76.6929
R187 a_8265_82520.n1 a_8265_82520.t3 61.8369
R188 a_8265_82520.t5 a_8265_82520.n2 55.2695
R189 a_8265_82520.n0 a_8265_82520.t6 48.3305
R190 a_8265_82520.t0 a_8265_82520.t2 23.2264
R191 a_8265_82520.t1 a_8265_82520.t5 16.7225
R192 a_8265_82520.t2 a_8265_82520.t1 2.9165
R193 a_15987_66729.n2 a_15987_66729.t5 83.2872
R194 a_15987_66729.n0 a_15987_66729.t10 83.2872
R195 a_15987_66729.n7 a_15987_66729.t7 83.2872
R196 a_15987_66729.n5 a_15987_66729.t11 83.2872
R197 a_15987_66729.n2 a_15987_66729.t8 72.1929
R198 a_15987_66729.n0 a_15987_66729.t12 72.1929
R199 a_15987_66729.n7 a_15987_66729.t9 72.1929
R200 a_15987_66729.n5 a_15987_66729.t13 72.1929
R201 a_15987_66729.n10 a_15987_66729.n9 71.7545
R202 a_15987_66729.n1 a_15987_66729.t2 70.611
R203 a_15987_66729.n6 a_15987_66729.t3 70.611
R204 a_15987_66729.n1 a_15987_66729.t4 67.041
R205 a_15987_66729.n6 a_15987_66729.t6 67.041
R206 a_15987_66729.n10 a_15987_66729.n4 55.5845
R207 a_15987_66729.n3 a_15987_66729.n1 49.9025
R208 a_15987_66729.n8 a_15987_66729.n6 49.9025
R209 a_15987_66729.t0 a_15987_66729.n10 46.7495
R210 a_15987_66729.n4 a_15987_66729.n0 21.3425
R211 a_15987_66729.n9 a_15987_66729.n5 21.3425
R212 a_15987_66729.n4 a_15987_66729.n3 19.5065
R213 a_15987_66729.n9 a_15987_66729.n8 19.5065
R214 a_15987_66729.t1 a_15987_66729.t0 17.4124
R215 a_15987_66729.n3 a_15987_66729.n2 9.8165
R216 a_15987_66729.n8 a_15987_66729.n7 9.8165
R217 a_5907_106069.t1 a_5907_106069.n0 219.898
R218 a_5907_106069.n0 a_5907_106069.t3 76.6929
R219 a_5907_106069.n0 a_5907_106069.t2 48.3305
R220 a_5907_106069.t0 a_5907_106069.t1 15.0386
R221 a_3540_181966.n2 a_3540_181966.n1 82.7264
R222 a_3540_181966.t1 a_3540_181966.n5 37.3317
R223 a_3540_181966.n1 a_3540_181966.t7 24.8971
R224 a_3540_181966.n4 a_3540_181966.t9 21.837
R225 a_3540_181966.n4 a_3540_181966.t10 21.837
R226 a_3540_181966.n3 a_3540_181966.n2 14.0165
R227 a_3540_181966.t0 a_3540_181966.t1 12.181
R228 a_3540_181966.n3 a_3540_181966.t2 12.0986
R229 a_3540_181966.n2 a_3540_181966.t3 12.0986
R230 a_3540_181966.n1 a_3540_181966.n0 11.2412
R231 a_3540_181966.n0 a_3540_181966.t5 10.6415
R232 a_3540_181966.n0 a_3540_181966.t4 9.63669
R233 a_3540_181966.n5 a_3540_181966.n3 9.32939
R234 a_3540_181966.n5 a_3540_181966.n4 2.23383
R235 a_3540_181966.t7 a_3540_181966.t6 1.07624
R236 a_3540_181966.t7 a_3540_181966.t8 1.07624
C836 LO VSS 29.4959f
C837 REFIN VSS 17.3901f
C838 FS VSS 28.8815f
C839 NB VSS 63.85859f
C840 FB VSS 0.11134p
C841 REFCK VSS 96.9403f
C842 PB VSS 62.38308f
C843 ICP2 VSS 75.64519f
C844 VCTRL VSS 86.57364f
C845 VDD VSS 1.72663p
C846 a_61614_7420# VSS 0.3275f
C847 a_61204_7420# VSS 0.33627f ; **FLOATING
C848 a_59934_7420# VSS 0.31855f
C849 a_59640_7480# VSS 0.96816f ; **FLOATING
C850 a_59524_7420# VSS 0.31943f
C851 a_58254_7762# VSS 0.24128f
C852 a_57844_7762# VSS 0.25327f ; **FLOATING
C853 a_47614_7420# VSS 0.3275f
C854 a_47204_7420# VSS 0.33627f ; **FLOATING
C855 a_45934_7420# VSS 0.31855f
C856 a_45640_7480# VSS 0.96816f ; **FLOATING
C857 a_45524_7420# VSS 0.31943f
C858 a_44254_7762# VSS 0.24128f
C859 a_43844_7762# VSS 0.25327f ; **FLOATING
C860 a_33614_7420# VSS 0.3275f
C861 a_33204_7420# VSS 0.33627f ; **FLOATING
C862 a_31934_7420# VSS 0.31855f
C863 a_31640_7480# VSS 0.96816f ; **FLOATING
C864 a_31524_7420# VSS 0.31943f
C865 a_30254_7762# VSS 0.24128f
C866 a_29844_7762# VSS 0.25327f ; **FLOATING
C867 a_61614_11962# VSS 0.24128f ; **FLOATING
C868 a_61204_11962# VSS 0.25327f ; **FLOATING
C869 a_59934_11620# VSS 0.3275f
C870 a_59524_11620# VSS 0.33726f ; **FLOATING
C871 a_58254_11620# VSS 0.31705f
C872 a_57960_11680# VSS 0.90387f ; **FLOATING
C873 a_57844_11620# VSS 0.32093f
C874 a_47614_11962# VSS 0.24128f
C875 a_47204_11962# VSS 0.25327f ; **FLOATING
C876 a_45934_11620# VSS 0.3275f
C877 a_45524_11620# VSS 0.33726f ; **FLOATING
C878 a_44254_11620# VSS 0.31705f
C879 a_43960_11680# VSS 0.90387f ; **FLOATING
C880 a_43844_11620# VSS 0.32093f
C881 a_33614_11962# VSS 0.24128f
C882 a_33204_11962# VSS 0.25327f ; **FLOATING
C883 a_31934_11620# VSS 0.3275f
C884 a_31524_11620# VSS 0.33726f ; **FLOATING
C885 a_30254_11620# VSS 0.31705f
C886 a_29960_11680# VSS 0.90387f ; **FLOATING
C887 a_29844_11620# VSS 0.32093f
C888 a_19614_10640# VSS 0.67521f
C889 a_19204_10640# VSS 0.70788f
C890 a_17934_10640# VSS 0.67521f
C891 a_17524_10640# VSS 0.70854f
C892 a_5614_11760# VSS 0.39203f
C893 a_5204_11760# VSS 0.4097f
C894 a_3934_11760# VSS 0.39203f
C895 a_3524_11760# VSS 0.41056f
C896 a_61614_15820# VSS 0.04368f
C897 a_61204_15820# VSS 0.04368f
C898 a_59934_15820# VSS 0.04368f
C899 a_58105_7822# VSS 4.50781f ; **FLOATING
C900 a_59524_15820# VSS 0.04368f
C901 a_58254_15820# VSS 0.04368f
C902 a_58105_15880# VSS 0.41535f ; **FLOATING
C903 a_57844_15820# VSS 0.04368f
C904 a_47614_15820# VSS 0.04368f
C905 a_47204_15820# VSS 0.04368f
C906 a_45934_15820# VSS 0.04368f
C907 a_44105_7822# VSS 4.50781f ; **FLOATING
C908 a_45524_15820# VSS 0.04368f
C909 a_44254_15820# VSS 0.04368f
C910 a_44105_15880# VSS 0.41535f ; **FLOATING
C911 a_43844_15820# VSS 0.04368f
C912 a_33614_15820# VSS 0.04368f
C913 a_33204_15820# VSS 0.04368f
C914 a_31934_15820# VSS 0.04368f
C915 a_30105_7822# VSS 4.50781f ; **FLOATING
C916 a_31524_15820# VSS 0.04368f
C917 a_30254_15820# VSS 0.04368f
C918 a_30105_15880# VSS 0.41535f ; **FLOATING
C919 a_29844_15820# VSS 0.04368f
C920 a_17540_17346# VSS 0.72782f ; **FLOATING
C921 a_11100_18186# VSS 0.69869f ; **FLOATING
C922 a_10680_16064# VSS 0.68267f ; **FLOATING
C923 a_10260_18186# VSS 0.66956f ; **FLOATING
C924 a_9840_16064# VSS 0.67035f ; **FLOATING
C925 a_9420_18186# VSS 0.66956f ; **FLOATING
C926 a_9000_16064# VSS 0.66956f ; **FLOATING
C927 a_8580_18186# VSS 0.66956f ; **FLOATING
C928 a_8160_16064# VSS 0.67314f ; **FLOATING
C929 a_7740_18186# VSS 0.66956f ; **FLOATING
C930 a_7320_16064# VSS 0.66956f ; **FLOATING
C931 a_6900_18186# VSS 0.66956f ; **FLOATING
C932 a_6480_16064# VSS 0.67437f ; **FLOATING
C933 a_6060_18186# VSS 0.66956f ; **FLOATING
C934 a_5640_16064# VSS 0.66956f ; **FLOATING
C935 a_5220_18186# VSS 0.66956f ; **FLOATING
C936 a_4800_16064# VSS 0.67334f ; **FLOATING
C937 a_4380_18186# VSS 0.66956f ; **FLOATING
C938 a_3960_16064# VSS 0.68075f ; **FLOATING
C939 a_3540_18186# VSS 0.69869f ; **FLOATING
C940 a_59934_19880# VSS 0.04368f
C941 a_59524_19880# VSS 0.04368f
C942 a_58254_19880# VSS 0.05836f
C943 a_57987_8209# VSS 15.629f ; **FLOATING
C944 a_57844_19880# VSS 0.05836f
C945 a_57987_20669# VSS 6.26928f ; **FLOATING
C946 a_45934_19880# VSS 0.04368f
C947 a_45785_19940# VSS 15.4182f ; **FLOATING
C948 a_45524_19880# VSS 0.04368f
C949 a_44254_19880# VSS 0.05836f
C950 a_43987_8209# VSS 16.6979f ; **FLOATING
C951 a_43844_19880# VSS 0.05836f
C952 a_43987_20669# VSS 6.26928f ; **FLOATING
C953 a_31934_19880# VSS 0.04368f
C954 a_31785_19940# VSS 15.4182f ; **FLOATING
C955 a_31524_19880# VSS 0.04368f
C956 a_30254_19880# VSS 0.05836f
C957 a_29987_8209# VSS 16.6979f ; **FLOATING
C958 a_29844_19880# VSS 0.05836f
C959 a_29987_20669# VSS 6.26928f ; **FLOATING
C960 a_19614_21000# VSS 0.13083f
C961 a_19465_10700# VSS 24.3114f ; **FLOATING
C962 a_19204_21000# VSS 0.13083f
C963 a_17934_21000# VSS 0.13083f
C964 a_17540_15224# VSS 6.32159f ; **FLOATING
C965 a_17524_21000# VSS 0.13083f
C966 a_17667_11569# VSS 10.1788f ; **FLOATING
C967 a_5614_21840# VSS 0.07326f
C968 a_5204_21840# VSS 0.07326f
C969 a_3934_21840# VSS 0.07326f
C970 a_3540_16064# VSS 6.5209f ; **FLOATING
C971 a_3524_21840# VSS 0.07326f
C972 a_3667_12409# VSS 15.7324f ; **FLOATING
C973 a_79696_30380# VSS 0.58425f ; **FLOATING
C974 a_79124_30380# VSS 0.58298f ; **FLOATING
C975 a_73374_30380# VSS 0.39203f
C976 a_72964_30380# VSS 0.41056f ; **FLOATING
C977 a_64974_32480# VSS 0.3275f
C978 a_64564_32480# VSS 0.33627f ; **FLOATING
C979 a_63294_32480# VSS 0.31855f
C980 a_63000_32540# VSS 0.94307f ; **FLOATING
C981 a_62884_32480# VSS 0.31943f
C982 a_61614_32822# VSS 0.24128f
C983 a_61204_32822# VSS 0.25327f ; **FLOATING
C984 a_50974_32822# VSS 0.24358f
C985 a_50564_32822# VSS 0.2518f ; **FLOATING
C986 a_49294_32822# VSS 0.24128f
C987 a_48884_32822# VSS 0.25327f ; **FLOATING
C988 a_43134_32480# VSS 0.3275f
C989 a_42724_32480# VSS 0.33627f ; **FLOATING
C990 a_41454_32480# VSS 0.31855f
C991 a_41160_32540# VSS 0.96816f ; **FLOATING
C992 a_41044_32480# VSS 0.31943f
C993 a_39774_32822# VSS 0.24128f
C994 a_39364_32822# VSS 0.25327f ; **FLOATING
C995 a_33614_32480# VSS 0.3275f
C996 a_33204_32480# VSS 0.33627f ; **FLOATING
C997 a_31934_32480# VSS 0.31855f
C998 a_31640_32540# VSS 0.96816f ; **FLOATING
C999 a_31524_32480# VSS 0.31943f
C1000 a_30254_32822# VSS 0.24128f
C1001 a_29844_32822# VSS 0.25327f ; **FLOATING
C1002 a_80020_34580# VSS 0.07989f
C1003 a_79124_34580# VSS 0.07989f
C1004 a_73374_34440# VSS 0.07326f
C1005 a_73225_30440# VSS 8.02484f ; **FLOATING
C1006 a_72964_34440# VSS 0.07326f
C1007 a_64974_37022# VSS 0.24128f
C1008 a_64564_37022# VSS 0.25327f ; **FLOATING
C1009 a_63294_36680# VSS 0.3275f
C1010 a_62884_36680# VSS 0.33726f ; **FLOATING
C1011 a_61614_36680# VSS 0.31705f
C1012 a_61320_36740# VSS 0.90387f ; **FLOATING
C1013 a_61204_36680# VSS 0.32093f
C1014 a_50974_36680# VSS 0.07326f
C1015 a_50564_36680# VSS 0.07326f
C1016 a_49294_36680# VSS 0.07326f
C1017 a_49145_36740# VSS 0.53402f ; **FLOATING
C1018 a_48884_36680# VSS 0.07326f
C1019 a_43134_37022# VSS 0.24128f
C1020 a_42724_37022# VSS 0.25327f ; **FLOATING
C1021 a_41454_36680# VSS 0.3275f
C1022 a_41044_36680# VSS 0.33726f ; **FLOATING
C1023 a_39774_36680# VSS 0.31705f
C1024 a_39480_36740# VSS 0.90387f ; **FLOATING
C1025 a_39364_36680# VSS 0.32093f
C1026 a_33614_37022# VSS 0.24128f
C1027 a_33204_37022# VSS 0.25327f ; **FLOATING
C1028 a_31934_36680# VSS 0.3275f
C1029 a_31524_36680# VSS 0.33726f ; **FLOATING
C1030 a_30254_36680# VSS 0.31705f
C1031 a_29960_36740# VSS 0.90387f ; **FLOATING
C1032 a_29844_36680# VSS 0.32093f
C1033 a_64974_40880# VSS 0.04368f
C1034 a_64564_40880# VSS 0.04368f
C1035 a_63294_40880# VSS 0.04368f
C1036 a_61465_32882# VSS 4.5025f ; **FLOATING
C1037 a_62884_40880# VSS 0.04368f
C1038 a_61614_40880# VSS 0.04368f
C1039 a_61465_40940# VSS 0.41535f ; **FLOATING
C1040 a_61204_40880# VSS 0.04368f
C1041 a_43134_40880# VSS 0.04368f
C1042 a_42724_40880# VSS 0.04368f
C1043 a_41454_40880# VSS 0.04368f
C1044 a_39625_32882# VSS 4.49719f ; **FLOATING
C1045 a_41044_40880# VSS 0.04368f
C1046 a_39774_40880# VSS 0.04368f
C1047 a_39625_40940# VSS 0.41535f ; **FLOATING
C1048 a_39364_40880# VSS 0.04368f
C1049 a_33614_40880# VSS 0.04368f
C1050 a_33204_40880# VSS 0.04368f
C1051 a_31934_40880# VSS 0.04368f
C1052 a_30105_32882# VSS 4.49719f ; **FLOATING
C1053 a_31524_40880# VSS 0.04368f
C1054 a_30254_40880# VSS 0.04368f
C1055 a_30105_40940# VSS 0.41535f ; **FLOATING
C1056 a_29844_40880# VSS 0.04368f
C1057 a_29987_33269# VSS 18.782f ; **FLOATING
C1058 a_63294_44940# VSS 0.04368f
C1059 a_62884_44940# VSS 0.04368f
C1060 a_61614_44940# VSS 0.05836f
C1061 a_61347_33269# VSS 16.685f ; **FLOATING
C1062 a_61204_44940# VSS 0.05836f
C1063 a_61347_45729# VSS 6.26397f ; **FLOATING
C1064 a_41454_44940# VSS 0.04368f
C1065 a_41305_45000# VSS 7.53871f ; **FLOATING
C1066 a_41044_44940# VSS 0.04368f
C1067 a_39774_44940# VSS 0.05836f
C1068 a_39625_36740# VSS 6.54446f ; **FLOATING
C1069 a_39364_44940# VSS 0.05836f
C1070 a_39507_45729# VSS 6.26274f ; **FLOATING
C1071 a_31934_44940# VSS 0.04368f
C1072 a_31785_45000# VSS 29.4529f ; **FLOATING
C1073 a_31524_44940# VSS 0.04368f
C1074 a_30254_44940# VSS 0.05836f
C1075 a_30105_36740# VSS 6.53761f ; **FLOATING
C1076 a_29844_44940# VSS 0.05836f
C1077 a_29987_45729# VSS 6.25866f ; **FLOATING
C1078 a_79534_59640# VSS 0.39521f
C1079 a_79124_59640# VSS 0.4082f ; **FLOATING
C1080 a_77854_59640# VSS 0.38483f
C1081 a_77560_59700# VSS 1.15362f ; **FLOATING
C1082 a_77444_59640# VSS 0.38539f
C1083 a_69454_61740# VSS 0.39521f
C1084 a_69044_61740# VSS 0.4082f ; **FLOATING
C1085 a_67774_61740# VSS 0.38483f
C1086 a_67480_61800# VSS 1.15362f ; **FLOATING
C1087 a_67364_61740# VSS 0.38539f
C1088 a_61614_61740# VSS 0.52329f
C1089 a_61204_61740# VSS 0.52235f
C1090 a_59934_61740# VSS 0.52235f
C1091 a_59640_61800# VSS 0.93177f ; **FLOATING
C1092 a_59524_61740# VSS 0.52189f
C1093 a_53774_61740# VSS 0.52329f
C1094 a_53364_61740# VSS 0.52235f
C1095 a_52094_61740# VSS 0.52235f
C1096 a_51800_61800# VSS 0.93177f ; **FLOATING
C1097 a_51684_61740# VSS 0.52189f
C1098 a_45934_61740# VSS 0.39521f
C1099 a_45524_61740# VSS 0.4082f ; **FLOATING
C1100 a_44254_61740# VSS 0.38483f
C1101 a_43960_61800# VSS 1.15362f ; **FLOATING
C1102 a_43844_61740# VSS 0.38539f
C1103 a_33614_61740# VSS 0.39521f
C1104 a_33204_61740# VSS 0.4082f ; **FLOATING
C1105 a_31934_61740# VSS 0.38483f
C1106 a_31640_61800# VSS 1.15362f ; **FLOATING
C1107 a_31524_61740# VSS 0.38539f
C1108 a_25774_61740# VSS 0.52329f
C1109 a_25364_61740# VSS 0.52235f
C1110 a_24094_61740# VSS 0.52235f
C1111 a_23800_61800# VSS 0.93177f ; **FLOATING
C1112 a_23684_61740# VSS 0.52189f
C1113 a_17934_61740# VSS 0.52329f
C1114 a_17524_61740# VSS 0.52235f
C1115 a_16254_61740# VSS 0.52235f
C1116 a_15960_61800# VSS 0.93177f ; **FLOATING
C1117 a_15844_61740# VSS 0.52189f
C1118 a_10094_61740# VSS 0.39521f
C1119 a_9684_61740# VSS 0.4082f ; **FLOATING
C1120 a_8414_61740# VSS 0.38483f
C1121 a_8120_61800# VSS 1.15362f ; **FLOATING
C1122 a_8004_61740# VSS 0.38539f
C1123 a_79534_63700# VSS 0.04368f
C1124 a_79124_63700# VSS 0.04368f
C1125 a_77854_63700# VSS 0.04368f
C1126 a_77444_63700# VSS 0.04368f
C1127 a_69454_65800# VSS 0.04368f
C1128 a_69044_65800# VSS 0.04368f
C1129 a_67774_65800# VSS 0.04368f
C1130 a_67364_65800# VSS 0.04368f
C1131 a_59934_65940# VSS 0.53244f
C1132 a_59785_66000# VSS 2.2232f ; **FLOATING
C1133 a_59524_65940# VSS 0.55851f ; **FLOATING
C1134 a_52094_65940# VSS 0.53244f
C1135 a_51945_66000# VSS 2.22831f ; **FLOATING
C1136 a_51684_65940# VSS 0.55851f ; **FLOATING
C1137 a_45934_65800# VSS 0.04368f
C1138 a_45524_65800# VSS 0.04368f
C1139 a_44254_65800# VSS 0.04368f
C1140 a_43844_65800# VSS 0.04368f
C1141 a_33614_65800# VSS 0.04368f
C1142 a_33204_65800# VSS 0.04368f
C1143 a_31934_65800# VSS 0.04368f
C1144 a_31524_65800# VSS 0.04368f
C1145 a_24094_65940# VSS 0.53244f
C1146 a_23945_66000# VSS 2.2232f ; **FLOATING
C1147 a_23684_65940# VSS 0.55851f ; **FLOATING
C1148 a_16254_65940# VSS 0.53244f
C1149 a_16105_66000# VSS 2.22831f ; **FLOATING
C1150 a_15844_65940# VSS 0.55851f ; **FLOATING
C1151 a_10094_65800# VSS 0.04368f
C1152 a_9684_65800# VSS 0.04368f
C1153 a_8414_65800# VSS 0.04368f
C1154 a_8004_65800# VSS 0.04368f
C1155 a_109236_69580# VSS 0.40335f
C1156 a_108664_69580# VSS 0.40132f
C1157 a_107394_69580# VSS 0.38721f
C1158 a_106984_69580# VSS 0.38367f
C1159 a_105714_69580# VSS 0.38401f
C1160 a_105420_69640# VSS 1.16063f ; **FLOATING
C1161 a_105304_69580# VSS 0.38539f
C1162 a_104034_69580# VSS 0.38639f
C1163 a_103624_69580# VSS 0.38413f
C1164 a_102354_69580# VSS 0.38639f ; **FLOATING
C1165 a_101944_69580# VSS 0.38427f
C1166 a_100476_69819# VSS 1.18014f
C1167 a_98860_69819# VSS 1.18134f
C1168 a_97160_69580# VSS 3.60235f
C1169 a_92457_69640# VSS 2.77183f ; **FLOATING
C1170 a_89421_69640# VSS 4.3555f ; **FLOATING
C1171 a_88409_69640# VSS 6.28864f ; **FLOATING
C1172 a_87460_69580# VSS 3.60235f ; **FLOATING
C1173 a_61614_70140# VSS 0.04368f
C1174 a_61204_70140# VSS 0.04368f
C1175 a_59934_70140# VSS 0.04368f
C1176 a_59524_70140# VSS 0.04368f
C1177 a_53774_70140# VSS 0.04368f
C1178 a_53364_70140# VSS 0.04368f
C1179 a_52094_70140# VSS 0.04368f
C1180 a_51684_70140# VSS 0.04368f
C1181 a_44105_61800# VSS 8.44509f ; **FLOATING
C1182 a_25774_70140# VSS 0.04368f
C1183 a_25364_70140# VSS 0.04368f
C1184 a_24094_70140# VSS 0.04368f
C1185 a_23684_70140# VSS 0.04368f
C1186 a_17934_70140# VSS 0.04368f
C1187 a_17524_70140# VSS 0.04368f
C1188 a_16254_70140# VSS 0.04368f
C1189 a_15844_70140# VSS 0.04368f
C1190 a_8265_61800# VSS 8.23333f ; **FLOATING
C1191 a_107476_74760# VSS 0.1192f
C1192 a_105860_74760# VSS 0.1192f
C1193 a_99409_69879# VSS 3.37293f ; **FLOATING
C1194 a_104244_74760# VSS 0.22758f
C1195 a_87460_74760# VSS 0.22758f
C1196 a_59934_74200# VSS 0.04368f
C1197 a_59524_74200# VSS 0.04368f
C1198 a_43987_62389# VSS 25.1524f ; **FLOATING
C1199 a_52094_74200# VSS 0.04368f
C1200 a_51684_74200# VSS 0.04368f
C1201 a_24094_74200# VSS 0.04368f
C1202 a_23684_74200# VSS 0.04368f
C1203 a_8147_62389# VSS 25.1486f ; **FLOATING
C1204 a_16254_74200# VSS 0.04368f
C1205 a_15844_74200# VSS 0.04368f
C1206 a_92900_79940# VSS 0.14509f
C1207 a_89421_74820# VSS 5.29302f ; **FLOATING
C1208 a_92004_79940# VSS 0.14509f
C1209 a_90660_80179# VSS 0.09961f
C1210 a_89880_80239# VSS 0.32235f ; **FLOATING
C1211 a_89764_80179# VSS 0.09961f
C1212 a_88420_80179# VSS 0.09961f
C1213 a_88109_80239# VSS 46.2816f ; **FLOATING
C1214 a_87640_80239# VSS 4.21226f ; **FLOATING
C1215 a_87524_80179# VSS 0.09961f
C1216 a_53774_82460# VSS 0.52329f
C1217 a_53364_82460# VSS 0.52235f
C1218 a_52094_82460# VSS 0.52235f
C1219 a_51800_82520# VSS 0.93177f ; **FLOATING
C1220 a_51684_82460# VSS 0.52189f
C1221 a_45934_82460# VSS 0.39521f
C1222 a_45524_82460# VSS 0.4082f ; **FLOATING
C1223 a_44254_82460# VSS 0.38483f
C1224 a_43960_82520# VSS 1.15362f ; **FLOATING
C1225 a_43844_82460# VSS 0.38539f
C1226 a_17934_82460# VSS 0.52329f
C1227 a_17524_82460# VSS 0.52235f
C1228 a_16254_82460# VSS 0.52235f
C1229 a_15960_82520# VSS 0.93177f ; **FLOATING
C1230 a_15844_82460# VSS 0.52189f
C1231 a_10094_82460# VSS 0.39521f
C1232 a_9684_82460# VSS 0.4082f ; **FLOATING
C1233 a_8414_82460# VSS 0.38483f
C1234 a_8120_82520# VSS 1.15362f ; **FLOATING
C1235 a_8004_82460# VSS 0.38539f
C1236 a_96334_87142# VSS 0.24128f
C1237 a_95924_87142# VSS 0.25327f ; **FLOATING
C1238 a_90174_87142# VSS 0.24128f
C1239 a_89764_87142# VSS 0.25327f ; **FLOATING
C1240 a_52094_86660# VSS 0.53244f
C1241 a_51945_86720# VSS 2.22921f ; **FLOATING
C1242 a_51684_86660# VSS 0.55851f ; **FLOATING
C1243 a_45934_86520# VSS 0.04368f
C1244 a_45524_86520# VSS 0.04368f
C1245 a_44254_86520# VSS 0.04368f
C1246 a_43844_86520# VSS 0.04368f
C1247 a_43987_83109# VSS 29.1013f ; **FLOATING
C1248 a_16254_86660# VSS 0.53244f
C1249 a_16105_86720# VSS 2.2241f ; **FLOATING
C1250 a_15844_86660# VSS 0.55851f ; **FLOATING
C1251 a_10094_86520# VSS 0.04368f
C1252 a_9684_86520# VSS 0.04368f
C1253 a_8414_86520# VSS 0.04368f
C1254 a_8004_86520# VSS 0.04368f
C1255 a_8147_83109# VSS 29.1019f ; **FLOATING
C1256 a_96334_91000# VSS 0.04368f
C1257 a_92189_81289# VSS 7.41063f ; **FLOATING
C1258 a_95924_91000# VSS 0.04368f
C1259 a_90174_91000# VSS 0.04368f
C1260 a_88033_80029# VSS 7.12445f ; **FLOATING
C1261 a_89764_91000# VSS 0.04368f
C1262 a_53774_90860# VSS 0.04368f
C1263 a_53364_90860# VSS 0.04368f
C1264 a_53507_83249# VSS 26.9135f ; **FLOATING
C1265 a_52094_90860# VSS 0.04368f
C1266 a_51684_90860# VSS 0.04368f
C1267 a_17934_90860# VSS 0.04368f
C1268 a_17524_90860# VSS 0.04368f
C1269 a_17667_83249# VSS 26.9072f ; **FLOATING
C1270 a_16254_90860# VSS 0.04368f
C1271 a_15844_90860# VSS 0.04368f
C1272 a_52094_94920# VSS 0.04368f
C1273 a_45667_83109# VSS 13.3523f ; **FLOATING
C1274 a_51684_94920# VSS 0.04368f
C1275 a_16254_94920# VSS 0.04368f
C1276 a_9827_83109# VSS 13.526f ; **FLOATING
C1277 a_15844_94920# VSS 0.04368f
C1278 a_36974_105622# VSS 0.24128f ; **FLOATING
C1279 a_36564_105622# VSS 0.25327f ; **FLOATING
C1280 a_30814_105622# VSS 0.24128f ; **FLOATING
C1281 a_30404_105622# VSS 0.25327f ; **FLOATING
C1282 a_24654_105622# VSS 0.24128f ; **FLOATING
C1283 a_24244_105622# VSS 0.25327f ; **FLOATING
C1284 a_18494_105622# VSS 0.24128f
C1285 a_18084_105622# VSS 0.25327f ; **FLOATING
C1286 a_12334_105622# VSS 0.24128f
C1287 a_11924_105622# VSS 0.25327f ; **FLOATING
C1288 a_6174_105622# VSS 0.24128f
C1289 a_5764_105622# VSS 0.25327f ; **FLOATING
C1290 a_36974_109480# VSS 0.04368f
C1291 a_36564_109480# VSS 0.04368f
C1292 a_30814_109480# VSS 0.04368f
C1293 a_30404_109480# VSS 0.04368f
C1294 a_24654_109480# VSS 0.04368f
C1295 a_24244_109480# VSS 0.04368f
C1296 a_18494_109480# VSS 0.04368f
C1297 a_18345_105682# VSS 7.48739f ; **FLOATING
C1298 a_18084_109480# VSS 0.04368f
C1299 a_12334_109480# VSS 0.04368f
C1300 a_12185_105682# VSS 7.48739f ; **FLOATING
C1301 a_11924_109480# VSS 0.04368f
C1302 a_6174_109480# VSS 0.04368f
C1303 a_6025_105682# VSS 7.48739f ; **FLOATING
C1304 a_5764_109480# VSS 0.04368f
C1305 a_3540_180844# VSS 1.36019p ; **FLOATING
C1306 a_3540_181966.t0 VSS 0.01359f ; **FLOATING
C1307 a_3540_181966.t8 VSS 1.88067f ; **FLOATING
C1308 a_3540_181966.t7 VSS 32.3216f ; **FLOATING
C1309 a_3540_181966.t6 VSS 1.88067f ; **FLOATING
C1310 a_3540_181966.n0 VSS 0.67444f ; **FLOATING
C1311 a_3540_181966.n1 VSS 5.15662f ; **FLOATING
C1312 a_3540_181966.n2 VSS 2.16525f ; **FLOATING
C1313 a_3540_181966.n3 VSS 0.01932f ; **FLOATING
C1314 a_3540_181966.t9 VSS 0.014f ; **FLOATING
C1315 a_3540_181966.t10 VSS 0.014f ; **FLOATING
C1316 a_3540_181966.n4 VSS 0.01259f ; **FLOATING
C1317 a_3540_181966.n5 VSS 0.05946f ; **FLOATING
C1318 a_3540_181966.t1 VSS 0.08447f ; **FLOATING
C1319 a_5907_106069.t2 VSS 0.02258f ; **FLOATING
C1320 a_5907_106069.t3 VSS 0.06471f ; **FLOATING
C1321 a_5907_106069.n0 VSS 4.14814f ; **FLOATING
C1322 a_5907_106069.t1 VSS 4.282f ; **FLOATING
C1323 a_5907_106069.t0 VSS 0.07587f ; **FLOATING
C1324 a_15987_66729.t12 VSS 0.07436f ; **FLOATING
C1325 a_15987_66729.t10 VSS 0.11704f ; **FLOATING
C1326 a_15987_66729.n0 VSS 1.23398f ; **FLOATING
C1327 a_15987_66729.t4 VSS 0.04579f ; **FLOATING
C1328 a_15987_66729.t2 VSS 0.05673f ; **FLOATING
C1329 a_15987_66729.n1 VSS 1.46721f ; **FLOATING
C1330 a_15987_66729.t8 VSS 0.07436f ; **FLOATING
C1331 a_15987_66729.t5 VSS 0.11704f ; **FLOATING
C1332 a_15987_66729.n2 VSS 1.04479f ; **FLOATING
C1333 a_15987_66729.n3 VSS 1.66835f ; **FLOATING
C1334 a_15987_66729.n4 VSS 1.75261f ; **FLOATING
C1335 a_15987_66729.t13 VSS 0.07436f ; **FLOATING
C1336 a_15987_66729.t11 VSS 0.11704f ; **FLOATING
C1337 a_15987_66729.n5 VSS 1.23398f ; **FLOATING
C1338 a_15987_66729.t6 VSS 0.04579f ; **FLOATING
C1339 a_15987_66729.t3 VSS 0.05673f ; **FLOATING
C1340 a_15987_66729.n6 VSS 1.46721f ; **FLOATING
C1341 a_15987_66729.t9 VSS 0.07436f ; **FLOATING
C1342 a_15987_66729.t7 VSS 0.11704f ; **FLOATING
C1343 a_15987_66729.n7 VSS 1.04479f ; **FLOATING
C1344 a_15987_66729.n8 VSS 1.66835f ; **FLOATING
C1345 a_15987_66729.n9 VSS 2.10251f ; **FLOATING
C1346 a_15987_66729.n10 VSS 3.42514f ; **FLOATING
C1347 a_15987_66729.t0 VSS 1.44649f ; **FLOATING
C1348 a_15987_66729.t1 VSS 0.17236f ; **FLOATING
C1349 a_8265_82520.t6 VSS 0.02447f ; **FLOATING
C1350 a_8265_82520.t7 VSS 0.07012f ; **FLOATING
C1351 a_8265_82520.n0 VSS 1.48704f ; **FLOATING
C1352 a_8265_82520.t3 VSS 0.03239f ; **FLOATING
C1353 a_8265_82520.t4 VSS 0.07189f ; **FLOATING
C1354 a_8265_82520.n1 VSS 2.95921f ; **FLOATING
C1355 a_8265_82520.n2 VSS 4.54523f ; **FLOATING
C1356 a_8265_82520.t5 VSS 2.2172f ; **FLOATING
C1357 a_8265_82520.t1 VSS 0.45284f ; **FLOATING
C1358 a_8265_82520.t2 VSS 0.24856f ; **FLOATING
C1359 a_8265_82520.t0 VSS 0.10518f ; **FLOATING
C1360 a_30665_105682.t6 VSS 0.03735f ; **FLOATING
C1361 a_30665_105682.t7 VSS 0.10702f ; **FLOATING
C1362 a_30665_105682.n0 VSS 1.04007f ; **FLOATING
C1363 a_30665_105682.t2 VSS 0.06571f ; **FLOATING
C1364 a_30665_105682.t3 VSS 0.06571f ; **FLOATING
C1365 a_30665_105682.n1 VSS 0.13358f ; **FLOATING
C1366 a_30665_105682.t4 VSS 0.06571f ; **FLOATING
C1367 a_30665_105682.t5 VSS 0.06571f ; **FLOATING
C1368 a_30665_105682.n2 VSS 0.09309f ; **FLOATING
C1369 a_30665_105682.n3 VSS 0.24034f ; **FLOATING
C1370 a_30665_105682.n4 VSS 6.47323f ; **FLOATING
C1371 a_30665_105682.t0 VSS 6.73873f ; **FLOATING
C1372 a_30665_105682.t1 VSS 0.21091f ; **FLOATING
C1373 a_36707_106069.t5 VSS 0.12355f ; **FLOATING
C1374 a_36707_106069.t6 VSS 0.05833f ; **FLOATING
C1375 a_36707_106069.n0 VSS 3.40821f ; **FLOATING
C1376 a_36707_106069.t9 VSS 0.04428f ; **FLOATING
C1377 a_36707_106069.t10 VSS 0.12688f ; **FLOATING
C1378 a_36707_106069.n1 VSS 3.70227f ; **FLOATING
C1379 a_36707_106069.n2 VSS 7.84583f ; **FLOATING
C1380 a_36707_106069.t4 VSS 0.06643f ; **FLOATING
C1381 a_36707_106069.t3 VSS 0.0823f ; **FLOATING
C1382 a_36707_106069.n3 VSS 1.58312f ; **FLOATING
C1383 a_36707_106069.n4 VSS 3.91234f ; **FLOATING
C1384 a_36707_106069.t7 VSS 0.07098f ; **FLOATING
C1385 a_36707_106069.t8 VSS 0.21638f ; **FLOATING
C1386 a_36707_106069.n5 VSS 1.38847f ; **FLOATING
C1387 a_36707_106069.n6 VSS 2.37106f ; **FLOATING
C1388 a_36707_106069.t1 VSS 0.81934f ; **FLOATING
C1389 a_36707_106069.t2 VSS 0.44973f ; **FLOATING
C1390 a_36707_106069.t0 VSS 0.1903f ; **FLOATING
C1391 a_36825_105682.t2 VSS 0.11307f ; **FLOATING
C1392 a_36825_105682.t3 VSS 0.04915f ; **FLOATING
C1393 a_36825_105682.n0 VSS 5.21812f ; **FLOATING
C1394 a_36825_105682.t0 VSS 5.8449f ; **FLOATING
C1395 a_36825_105682.t1 VSS 0.21069f ; **FLOATING
C1396 a_29987_37189.t3 VSS 0.1071f ; **FLOATING
C1397 a_29987_37189.t5 VSS 0.09613f ; **FLOATING
C1398 a_29987_37189.n0 VSS 1.10781f ; **FLOATING
C1399 a_29987_37189.t8 VSS 0.05822f ; **FLOATING
C1400 a_29987_37189.t9 VSS 0.0562f ; **FLOATING
C1401 a_29987_37189.n1 VSS 0.33089f ; **FLOATING
C1402 a_29987_37189.n2 VSS 0.60014f ; **FLOATING
C1403 a_29987_37189.t2 VSS 0.1071f ; **FLOATING
C1404 a_29987_37189.t4 VSS 0.09613f ; **FLOATING
C1405 a_29987_37189.n3 VSS 1.10781f ; **FLOATING
C1406 a_29987_37189.t6 VSS 0.05822f ; **FLOATING
C1407 a_29987_37189.t7 VSS 0.0562f ; **FLOATING
C1408 a_29987_37189.n4 VSS 0.33089f ; **FLOATING
C1409 a_29987_37189.n5 VSS 1.1198f ; **FLOATING
C1410 a_29987_37189.n6 VSS 5.86706f ; **FLOATING
C1411 a_29987_37189.t0 VSS 4.83685f ; **FLOATING
C1412 a_29987_37189.t1 VSS 0.58102f ; **FLOATING
C1413 VCTRL.t1 VSS 23.9748f ; **FLOATING
C1414 VCTRL.t0 VSS 1.19079f ; **FLOATING
C1415 VCTRL.n0 VSS 3.23001f ; **FLOATING
C1416 ICP2.t0 VSS 0.03852f ; **FLOATING
C1417 ICP2.t1 VSS 0.03852f ; **FLOATING
C1418 ICP2.n0 VSS 1.34016f ; **FLOATING
C1419 ICP2.t2 VSS 0.03337f ; **FLOATING
C1420 ICP2.t3 VSS 0.09561f ; **FLOATING
C1421 ICP2.n1 VSS 0.70605f ; **FLOATING
C1422 ICP2.n2 VSS 8.63362f ; **FLOATING
C1423 PB.t15 VSS 0.97547f ; **FLOATING
C1424 PB.t14 VSS 0.97547f ; **FLOATING
C1425 PB.t13 VSS 0.97547f ; **FLOATING
C1426 PB.t12 VSS 0.97547f ; **FLOATING
C1427 PB.t11 VSS 0.97547f ; **FLOATING
C1428 PB.t10 VSS 0.97547f ; **FLOATING
C1429 PB.t9 VSS 0.97547f ; **FLOATING
C1430 PB.t8 VSS 0.97547f ; **FLOATING
C1431 PB.t7 VSS 0.97547f ; **FLOATING
C1432 PB.t6 VSS 0.97547f ; **FLOATING
C1433 PB.t5 VSS 0.97547f ; **FLOATING
C1434 PB.t4 VSS 0.97547f ; **FLOATING
C1435 PB.t3 VSS 0.97547f ; **FLOATING
C1436 PB.t2 VSS 0.97547f ; **FLOATING
C1437 PB.t1 VSS 0.97547f ; **FLOATING
C1438 PB.t0 VSS 1.26536f ; **FLOATING
C1439 PB.n0 VSS 0.6915f ; **FLOATING
C1440 PB.n1 VSS 0.49395f ; **FLOATING
C1441 PB.n2 VSS 0.49395f ; **FLOATING
C1442 PB.n3 VSS 0.49395f ; **FLOATING
C1443 PB.n4 VSS 0.49395f ; **FLOATING
C1444 PB.n5 VSS 0.49395f ; **FLOATING
C1445 PB.n6 VSS 0.49395f ; **FLOATING
C1446 PB.n7 VSS 0.49395f ; **FLOATING
C1447 PB.n8 VSS 0.49395f ; **FLOATING
C1448 PB.n9 VSS 0.49395f ; **FLOATING
C1449 PB.n10 VSS 0.49395f ; **FLOATING
C1450 PB.n11 VSS 0.49395f ; **FLOATING
C1451 PB.n12 VSS 0.49395f ; **FLOATING
C1452 PB.n13 VSS 0.49395f ; **FLOATING
C1453 PB.n14 VSS 0.45896f ; **FLOATING
C1454 PB.t16 VSS 0.97547f ; **FLOATING
C1455 PB.t17 VSS 0.97547f ; **FLOATING
C1456 PB.t18 VSS 0.97547f ; **FLOATING
C1457 PB.t19 VSS 0.97547f ; **FLOATING
C1458 PB.t20 VSS 0.97547f ; **FLOATING
C1459 PB.t21 VSS 0.97547f ; **FLOATING
C1460 PB.t22 VSS 0.97547f ; **FLOATING
C1461 PB.t23 VSS 0.97547f ; **FLOATING
C1462 PB.t24 VSS 0.97547f ; **FLOATING
C1463 PB.t25 VSS 0.97547f ; **FLOATING
C1464 PB.t26 VSS 0.97547f ; **FLOATING
C1465 PB.t27 VSS 0.97547f ; **FLOATING
C1466 PB.t28 VSS 0.97547f ; **FLOATING
C1467 PB.t29 VSS 0.97547f ; **FLOATING
C1468 PB.t30 VSS 0.97547f ; **FLOATING
C1469 PB.t31 VSS 1.26536f ; **FLOATING
C1470 PB.n15 VSS 0.6915f ; **FLOATING
C1471 PB.n16 VSS 0.49395f ; **FLOATING
C1472 PB.n17 VSS 0.49395f ; **FLOATING
C1473 PB.n18 VSS 0.49395f ; **FLOATING
C1474 PB.n19 VSS 0.49395f ; **FLOATING
C1475 PB.n20 VSS 0.49395f ; **FLOATING
C1476 PB.n21 VSS 0.49395f ; **FLOATING
C1477 PB.n22 VSS 0.49395f ; **FLOATING
C1478 PB.n23 VSS 0.49395f ; **FLOATING
C1479 PB.n24 VSS 0.49395f ; **FLOATING
C1480 PB.n25 VSS 0.49395f ; **FLOATING
C1481 PB.n26 VSS 0.49395f ; **FLOATING
C1482 PB.n27 VSS 0.49395f ; **FLOATING
C1483 PB.n28 VSS 0.49395f ; **FLOATING
C1484 PB.n29 VSS 0.45896f ; **FLOATING
C1485 PB.n30 VSS 12.3569f ; **FLOATING
C1486 REFCK.t5 VSS 0.06474f ; **FLOATING
C1487 REFCK.t3 VSS 0.09895f ; **FLOATING
C1488 REFCK.n0 VSS 1.07581f ; **FLOATING
C1489 REFCK.t4 VSS 0.06474f ; **FLOATING
C1490 REFCK.t2 VSS 0.09895f ; **FLOATING
C1491 REFCK.n1 VSS 1.53431f ; **FLOATING
C1492 REFCK.n2 VSS 2.34188f ; **FLOATING
C1493 REFCK.t0 VSS 0.07314f ; **FLOATING
C1494 REFCK.t1 VSS 0.6439f ; **FLOATING
C1495 REFCK.n3 VSS 3.87165f ; **FLOATING
C1496 REFCK.n4 VSS 13.364f ; **FLOATING
C1497 FB.t0 VSS 0.04415f ; **FLOATING
C1498 FB.t1 VSS 0.53258f ; **FLOATING
C1499 FB.n0 VSS 1.11293f ; **FLOATING
C1500 FB.t3 VSS 0.11557f ; **FLOATING
C1501 FB.t2 VSS 0.09337f ; **FLOATING
C1502 FB.n1 VSS 1.06217f ; **FLOATING
C1503 FB.n2 VSS 5.46933f ; **FLOATING
C1504 FB.t7 VSS 0.06743f ; **FLOATING
C1505 FB.t5 VSS 0.10307f ; **FLOATING
C1506 FB.n3 VSS 1.12055f ; **FLOATING
C1507 FB.t6 VSS 0.06743f ; **FLOATING
C1508 FB.t4 VSS 0.10307f ; **FLOATING
C1509 FB.n4 VSS 1.59812f ; **FLOATING
C1510 FB.n5 VSS 9.93246f ; **FLOATING
C1511 FB.n6 VSS 15.4226f ; **FLOATING
C1512 NB.t8 VSS 0.36219f ; **FLOATING
C1513 NB.t7 VSS 0.36219f ; **FLOATING
C1514 NB.t6 VSS 0.36219f ; **FLOATING
C1515 NB.t5 VSS 0.36219f ; **FLOATING
C1516 NB.t4 VSS 0.36219f ; **FLOATING
C1517 NB.t3 VSS 0.36219f ; **FLOATING
C1518 NB.t2 VSS 0.36219f ; **FLOATING
C1519 NB.t1 VSS 0.36219f ; **FLOATING
C1520 NB.t0 VSS 0.46982f ; **FLOATING
C1521 NB.n0 VSS 0.25675f ; **FLOATING
C1522 NB.n1 VSS 0.1834f ; **FLOATING
C1523 NB.n2 VSS 0.1834f ; **FLOATING
C1524 NB.n3 VSS 0.1834f ; **FLOATING
C1525 NB.n4 VSS 0.1834f ; **FLOATING
C1526 NB.n5 VSS 0.1834f ; **FLOATING
C1527 NB.n6 VSS 0.1834f ; **FLOATING
C1528 NB.n7 VSS 0.17041f ; **FLOATING
C1529 NB.t9 VSS 0.36219f ; **FLOATING
C1530 NB.t10 VSS 0.36219f ; **FLOATING
C1531 NB.t11 VSS 0.36219f ; **FLOATING
C1532 NB.t12 VSS 0.36219f ; **FLOATING
C1533 NB.t13 VSS 0.36219f ; **FLOATING
C1534 NB.t14 VSS 0.36219f ; **FLOATING
C1535 NB.t15 VSS 0.36219f ; **FLOATING
C1536 NB.t16 VSS 0.36219f ; **FLOATING
C1537 NB.t17 VSS 0.46982f ; **FLOATING
C1538 NB.n8 VSS 0.25675f ; **FLOATING
C1539 NB.n9 VSS 0.1834f ; **FLOATING
C1540 NB.n10 VSS 0.1834f ; **FLOATING
C1541 NB.n11 VSS 0.1834f ; **FLOATING
C1542 NB.n12 VSS 0.1834f ; **FLOATING
C1543 NB.n13 VSS 0.1834f ; **FLOATING
C1544 NB.n14 VSS 0.1834f ; **FLOATING
C1545 NB.n15 VSS 0.17041f ; **FLOATING
C1546 NB.n16 VSS 3.36113f ; **FLOATING
.ends
