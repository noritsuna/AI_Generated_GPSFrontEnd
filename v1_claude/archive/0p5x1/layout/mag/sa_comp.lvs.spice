* NGSPICE file created from sa_comp.ext - technology: gf180mcuD

.subckt sa_comp_M12 x2 CLK VDD
X0 x2 CLK VDD VDD pfet_03v3 ad=0.445p pd=2.89u as=0.445p ps=2.89u w=1u l=0.28u
.ends

.subckt nor2_MP1 n1 A VDD
X0 n1 A VDD VDD pfet_03v3 ad=1.78p pd=8.89u as=1.78p ps=8.89u w=4u l=0.28u
.ends

.subckt nor2_MP2 n1 Y B VDD
X0 Y B n1 VDD pfet_03v3 ad=1.78p pd=8.89u as=1.78p ps=8.89u w=4u l=0.28u
.ends

.subckt nor2_MN1 Y A VSS
X0 Y A VSS VSS nfet_03v3 ad=0.445p pd=2.89u as=0.445p ps=2.89u w=1u l=0.28u
.ends

.subckt nor2_MN2 Y B VSS
X0 Y B VSS VSS nfet_03v3 ad=0.445p pd=2.89u as=0.445p ps=2.89u w=1u l=0.28u
.ends

.subckt nor2 VDD A B Y VSS
XXMP1 XMP2/n1 A VDD nor2_MP1
XXMP2 XMP2/n1 Y B VDD nor2_MP2
XXMN1 Y A VSS nor2_MN1
XXMN2 Y B VSS nor2_MN2
.ends

.subckt sa_comp_MT t CLK VSS
X0 VSS CLK t VSS nfet_03v3 ad=1.78p pd=8.89u as=1.06p ps=4.53u w=4u l=0.28u
X1 t CLK VSS VSS nfet_03v3 ad=1.06p pd=4.53u as=1.78p ps=8.89u w=4u l=0.28u
.ends

.subckt sa_comp_M1 t x1 INP VSS
X0 x1 INP t VSS nfet_03v3 ad=1.78p pd=8.89u as=1.78p ps=8.89u w=4u l=0.28u
.ends

.subckt sa_comp_M2 t x2 INN VSS
X0 x2 INN t VSS nfet_03v3 ad=1.78p pd=8.89u as=1.78p ps=8.89u w=4u l=0.28u
.ends

.subckt sa_comp_M3 t x2 REFP VSS
X0 x2 REFP t VSS nfet_03v3 ad=1.78p pd=8.89u as=1.78p ps=8.89u w=4u l=0.28u
.ends

.subckt sa_comp_M4 t x1 REFN VSS
X0 x1 REFN t VSS nfet_03v3 ad=1.78p pd=8.89u as=1.78p ps=8.89u w=4u l=0.28u
.ends

.subckt inv_dig_MN Y A VSS
X0 Y A VSS VSS nfet_03v3 ad=0.445p pd=2.89u as=0.445p ps=2.89u w=1u l=0.28u
.ends

.subckt inv_dig_MP Y A VDD
X0 Y A VDD VDD pfet_03v3 ad=0.89p pd=4.89u as=0.89p ps=4.89u w=2u l=0.28u
.ends

.subckt inv_dig VDD A Y VSS
XXMN Y A VSS inv_dig_MN
XXMP Y A VDD inv_dig_MP
.ends

.subckt sa_comp_M5 x1 on op VSS
X0 on op x1 VSS nfet_03v3 ad=0.89p pd=4.89u as=0.89p ps=4.89u w=2u l=0.28u
.ends

.subckt sa_comp_M6 x2 op on VSS
X0 op on x2 VSS nfet_03v3 ad=0.89p pd=4.89u as=0.89p ps=4.89u w=2u l=0.28u
.ends

.subckt sa_comp_M7 on op VDD
X0 on op VDD VDD pfet_03v3 ad=0.89p pd=4.89u as=0.89p ps=4.89u w=2u l=0.28u
.ends

.subckt sa_comp_M8 op on VDD
X0 op on VDD VDD pfet_03v3 ad=0.89p pd=4.89u as=0.89p ps=4.89u w=2u l=0.28u
.ends

.subckt sa_comp_M9 on CLK VDD
X0 on CLK VDD VDD pfet_03v3 ad=0.445p pd=2.89u as=0.445p ps=2.89u w=1u l=0.28u
.ends

.subckt sa_comp_M10 op CLK VDD
X0 op CLK VDD VDD pfet_03v3 ad=0.445p pd=2.89u as=0.445p ps=2.89u w=1u l=0.28u
.ends

.subckt sa_comp_M11 x1 CLK VDD
X0 x1 CLK VDD VDD pfet_03v3 ad=0.445p pd=2.89u as=0.445p ps=2.89u w=1u l=0.28u
.ends

.subckt sa_comp VSS VDD INP INN REFP REFN CLK Q QB
XXM12 XM6/x2 CLK VDD sa_comp_M12
XXS1 VDD XS1/A QB Q VSS nor2
XXS2 VDD XS2/A Q QB VSS nor2
XXMT XMT/t CLK VSS sa_comp_MT
XXM1 XMT/t XM5/x1 INP VSS sa_comp_M1
XXM2 XMT/t XM6/x2 INN VSS sa_comp_M2
XXM3 XMT/t XM6/x2 REFP VSS sa_comp_M3
XXM4 XMT/t XM5/x1 REFN VSS sa_comp_M4
XXI1 VDD XI1/A XS1/A VSS inv_dig
XXM5 XM5/x1 XI2/A XI1/A VSS sa_comp_M5
XXI2 VDD XI2/A XS2/A VSS inv_dig
XXM6 XM6/x2 XI1/A XI2/A VSS sa_comp_M6
XXM7 XI2/A XI1/A VDD sa_comp_M7
XXM8 XI1/A XI2/A VDD sa_comp_M8
XXM9 XI2/A CLK VDD sa_comp_M9
XXM10 XI1/A CLK VDD sa_comp_M10
XXM11 XM5/x1 CLK VDD sa_comp_M11
.ends
