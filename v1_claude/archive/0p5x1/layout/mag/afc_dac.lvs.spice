* NGSPICE file created from afc_dac.ext - technology: gf180mcuD

.subckt afc_dac_R1u_0 VSS n0 dr0 n1 dr1 n2 dr2 n3 dr3 n4 dr4 n5 dr5 n6 dr6 OUT dr7
X0 a_320_2086# dr0 VSS ppolyf_u_1k r_width=1u r_length=10u
X1 a_3260_2086# dr3 VSS ppolyf_u_1k r_width=1u r_length=10u
X2 a_6620_2086# dr7 VSS ppolyf_u_1k r_width=1u r_length=10u
X3 a_3260_2086# n3 VSS ppolyf_u_1k r_width=1u r_length=10u
X4 a_5360_2086# dr6 VSS ppolyf_u_1k r_width=1u r_length=10u
X5 a_1580_2086# dr1 VSS ppolyf_u_1k r_width=1u r_length=10u
X6 n4 n5 VSS ppolyf_u_1k r_width=1u r_length=10u
X7 a_5360_2086# n6 VSS ppolyf_u_1k r_width=1u r_length=10u
X8 n2 n3 VSS ppolyf_u_1k r_width=1u r_length=10u
X9 a_1580_2086# n1 VSS ppolyf_u_1k r_width=1u r_length=10u
X10 a_3680_2086# dr4 VSS ppolyf_u_1k r_width=1u r_length=10u
X11 a_320_2086# n0 VSS ppolyf_u_1k r_width=1u r_length=10u
X12 n0 n1 VSS ppolyf_u_1k r_width=1u r_length=10u
X13 a_3680_2086# n4 VSS ppolyf_u_1k r_width=1u r_length=10u
X14 a_6620_2086# OUT VSS ppolyf_u_1k r_width=1u r_length=10u
X15 a_2000_2086# dr2 VSS ppolyf_u_1k r_width=1u r_length=10u
X16 n5 n6 VSS ppolyf_u_1k r_width=1u r_length=10u
X17 a_4940_2086# dr5 VSS ppolyf_u_1k r_width=1u r_length=10u
X18 n3 n4 VSS ppolyf_u_1k r_width=1u r_length=10u
X19 a_4940_2086# n5 VSS ppolyf_u_1k r_width=1u r_length=10u
X20 a_n100_2086# n0 VSS ppolyf_u_1k r_width=1u r_length=10u
X21 n1 n2 VSS ppolyf_u_1k r_width=1u r_length=10u
X22 a_2000_2086# n2 VSS ppolyf_u_1k r_width=1u r_length=10u
X23 a_n100_2086# VSS VSS ppolyf_u_1k r_width=1u r_length=10u
.ends

.subckt afc_dac_R1u_1 OUT n6 VSS
X0 n6 OUT VSS ppolyf_u_1k r_width=1u r_length=10u
.ends

.subckt inv_dac_MN Y A VSS
X0 VSS A Y VSS nfet_03v3 ad=1.78p pd=8.89u as=1.06p ps=4.53u w=4u l=0.28u
X1 Y A VSS VSS nfet_03v3 ad=1.06p pd=4.53u as=1.78p ps=8.89u w=4u l=0.28u
.ends

.subckt inv_dac_MP Y A VDD
X0 VDD A Y VDD pfet_03v3 ad=1.59p pd=6.53u as=1.59p ps=6.53u w=6u l=0.28u
X1 Y A VDD VDD pfet_03v3 ad=1.59p pd=6.53u as=2.67p ps=12.89u w=6u l=0.28u
X2 VDD A Y VDD pfet_03v3 ad=2.67p pd=12.89u as=1.59p ps=6.53u w=6u l=0.28u
X3 Y A VDD VDD pfet_03v3 ad=1.59p pd=6.53u as=1.59p ps=6.53u w=6u l=0.28u
.ends

.subckt inv_dac VDD A Y VSS
XXMN Y A VSS inv_dac_MN
XXMP Y A VDD inv_dac_MP
.ends

.subckt inv_dig_MN Y A VSS
X0 Y A VSS VSS nfet_03v3 ad=0.445p pd=2.89u as=0.445p ps=2.89u w=1u l=0.28u
.ends

.subckt inv_dig_MP Y A VDD
X0 Y A VDD VDD pfet_03v3 ad=0.89p pd=4.89u as=0.89p ps=4.89u w=2u l=0.28u
.ends

.subckt inv_dig VDD A Y VSS
XXMN Y A VSS inv_dig_MN
XXMP Y A VDD inv_dig_MP
.ends

.subckt afc_dac VSS VDD D0 D1 D2 D3 D4 D5 D6 D7 OUT
XXR1u_0 VSS XR1u_0/n0 XB0/Y XR1u_0/n1 XB1/Y XR1u_0/n2 XB2/Y XR1u_0/n3 XB3/Y XR1u_0/n4
+ XB4/Y XR1u_0/n5 XB5/Y XR1u_1/n6 XB6/Y OUT XB7/Y afc_dac_R1u_0
XXR1u_1 OUT XR1u_1/n6 VSS afc_dac_R1u_1
XXB0 VDD XB0/A XB0/Y VSS inv_dac
XXB1 VDD XB1/A XB1/Y VSS inv_dac
XXA0 VDD D0 XB0/A VSS inv_dig
XXB2 VDD XB2/A XB2/Y VSS inv_dac
XXA1 VDD D1 XB1/A VSS inv_dig
XXB3 VDD XB3/A XB3/Y VSS inv_dac
XXA2 VDD D2 XB2/A VSS inv_dig
XXB4 VDD XB4/A XB4/Y VSS inv_dac
XXA3 VDD D3 XB3/A VSS inv_dig
XXB6 VDD XB6/A XB6/Y VSS inv_dac
XXB5 VDD XB5/A XB5/Y VSS inv_dac
XXA5 VDD D5 XB5/A VSS inv_dig
XXA4 VDD D4 XB4/A VSS inv_dig
XXB7 VDD XB7/A XB7/Y VSS inv_dac
XXA6 VDD D6 XB6/A VSS inv_dig
XXA7 VDD D7 XB7/A VSS inv_dig
.ends
