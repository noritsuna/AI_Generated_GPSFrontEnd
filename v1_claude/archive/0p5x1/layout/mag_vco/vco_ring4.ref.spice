.subckt vco_core ap1 an1 ap2 an2 ap3 an3 ap4 an4 kh kl VR VSS
XMNa1 n1 p4 VSS VSS nfet_03v3 L=0.35u W=16u nf=4  m=1
XMNb1 p1 n4 VSS VSS nfet_03v3 L=0.35u W=16u nf=4  m=1
XMPa1 n1 p4 VR VR pfet_03v3 L=0.35u W=24u nf=8  m=1
XMPb1 p1 n4 VR VR pfet_03v3 L=0.35u W=24u nf=8  m=1
XMNc1 n1 p1 VSS VSS nfet_03v3 L=0.35u W=2u nf=1  m=1
XMNd1 p1 n1 VSS VSS nfet_03v3 L=0.35u W=2u nf=1  m=1
XMPc1 n1 p1 VR VR pfet_03v3 L=0.35u W=4u nf=1  m=1
XMPd1 p1 n1 VR VR pfet_03v3 L=0.35u W=4u nf=1  m=1
XMNa2 n2 p1 VSS VSS nfet_03v3 L=0.35u W=16u nf=4  m=1
XMNb2 p2 n1 VSS VSS nfet_03v3 L=0.35u W=16u nf=4  m=1
XMPa2 n2 p1 VR VR pfet_03v3 L=0.35u W=24u nf=8  m=1
XMPb2 p2 n1 VR VR pfet_03v3 L=0.35u W=24u nf=8  m=1
XMNc2 n2 p2 VSS VSS nfet_03v3 L=0.35u W=2u nf=1  m=1
XMNd2 p2 n2 VSS VSS nfet_03v3 L=0.35u W=2u nf=1  m=1
XMPc2 n2 p2 VR VR pfet_03v3 L=0.35u W=4u nf=1  m=1
XMPd2 p2 n2 VR VR pfet_03v3 L=0.35u W=4u nf=1  m=1
XMNa3 n3 p2 VSS VSS nfet_03v3 L=0.35u W=16u nf=4  m=1
XMNb3 p3 n2 VSS VSS nfet_03v3 L=0.35u W=16u nf=4  m=1
XMPa3 n3 p2 VR VR pfet_03v3 L=0.35u W=24u nf=8  m=1
XMPb3 p3 n2 VR VR pfet_03v3 L=0.35u W=24u nf=8  m=1
XMNc3 n3 p3 VSS VSS nfet_03v3 L=0.35u W=2u nf=1  m=1
XMNd3 p3 n3 VSS VSS nfet_03v3 L=0.35u W=2u nf=1  m=1
XMPc3 n3 p3 VR VR pfet_03v3 L=0.35u W=4u nf=1  m=1
XMPd3 p3 n3 VR VR pfet_03v3 L=0.35u W=4u nf=1  m=1
XMNa4 p4 p3 VSS VSS nfet_03v3 L=0.35u W=16u nf=4  m=1
XMNb4 n4 n3 VSS VSS nfet_03v3 L=0.35u W=16u nf=4  m=1
XMPa4 p4 p3 VR VR pfet_03v3 L=0.35u W=24u nf=8  m=1
XMPb4 n4 n3 VR VR pfet_03v3 L=0.35u W=24u nf=8  m=1
XMNc4 p4 n4 VSS VSS nfet_03v3 L=0.35u W=2u nf=1  m=1
XMNd4 n4 p4 VSS VSS nfet_03v3 L=0.35u W=2u nf=1  m=1
XMPc4 p4 n4 VR VR pfet_03v3 L=0.35u W=4u nf=1  m=1
XMPd4 n4 p4 VR VR pfet_03v3 L=0.35u W=4u nf=1  m=1
XMBNp1 ap1 p1 VSS VSS nfet_03v3 L=0.28u W=2u nf=1  m=1
XMBPp1 ap1 p1 VR VR pfet_03v3 L=0.28u W=4u nf=1  m=1
XMBNn1 an1 n1 VSS VSS nfet_03v3 L=0.28u W=2u nf=1  m=1
XMBPn1 an1 n1 VR VR pfet_03v3 L=0.28u W=4u nf=1  m=1
XMBNp2 ap2 p2 VSS VSS nfet_03v3 L=0.28u W=2u nf=1  m=1
XMBPp2 ap2 p2 VR VR pfet_03v3 L=0.28u W=4u nf=1  m=1
XMBNn2 an2 n2 VSS VSS nfet_03v3 L=0.28u W=2u nf=1  m=1
XMBPn2 an2 n2 VR VR pfet_03v3 L=0.28u W=4u nf=1  m=1
XMBNp3 ap3 p3 VSS VSS nfet_03v3 L=0.28u W=2u nf=1  m=1
XMBPp3 ap3 p3 VR VR pfet_03v3 L=0.28u W=4u nf=1  m=1
XMBNn3 an3 n3 VSS VSS nfet_03v3 L=0.28u W=2u nf=1  m=1
XMBPn3 an3 n3 VR VR pfet_03v3 L=0.28u W=4u nf=1  m=1
XMBNp4 ap4 p4 VSS VSS nfet_03v3 L=0.28u W=2u nf=1  m=1
XMBPp4 ap4 p4 VR VR pfet_03v3 L=0.28u W=4u nf=1  m=1
XMBNn4 an4 n4 VSS VSS nfet_03v3 L=0.28u W=2u nf=1  m=1
XMBPn4 an4 n4 VR VR pfet_03v3 L=0.28u W=4u nf=1  m=1
XMK1 n1 kh VSS VSS nfet_03v3 L=0.35u W=16u nf=4  m=1
XMKD1 p1 VSS VSS VSS nfet_03v3 L=0.35u W=16u nf=4  m=1
XMK2 n2 kl VSS VSS nfet_03v3 L=0.35u W=16u nf=4  m=1
XMKD2 p2 VSS VSS VSS nfet_03v3 L=0.35u W=16u nf=4  m=1
XMK3 n3 VSS VSS VSS nfet_03v3 L=0.35u W=16u nf=4  m=1
XMKD3 p3 VSS VSS VSS nfet_03v3 L=0.35u W=16u nf=4  m=1
XMK4 p4 VSS VSS VSS nfet_03v3 L=0.35u W=16u nf=4  m=1
XMKD4 n4 VSS VSS VSS nfet_03v3 L=0.35u W=16u nf=4  m=1
.ends
.subckt lo_comb ap1 an1 ap2 an2 ap3 an3 ap4 an4 LOIP LOIN LOQP LOQN VR VSS
XMGNp1 gp1 ap1 VSS VSS nfet_03v3 L=0.28u W=6u nf=2  m=1
XMGPp1 gp1 ap1 VR VR pfet_03v3 L=0.28u W=12u nf=4  m=1
XMGNn1 gn1 an1 VSS VSS nfet_03v3 L=0.28u W=6u nf=2  m=1
XMGPn1 gn1 an1 VR VR pfet_03v3 L=0.28u W=12u nf=4  m=1
XMGNp2 gp2 ap2 VSS VSS nfet_03v3 L=0.28u W=6u nf=2  m=1
XMGPp2 gp2 ap2 VR VR pfet_03v3 L=0.28u W=12u nf=4  m=1
XMGNn2 gn2 an2 VSS VSS nfet_03v3 L=0.28u W=6u nf=2  m=1
XMGPn2 gn2 an2 VR VR pfet_03v3 L=0.28u W=12u nf=4  m=1
XMGNp3 gp3 ap3 VSS VSS nfet_03v3 L=0.28u W=6u nf=2  m=1
XMGPp3 gp3 ap3 VR VR pfet_03v3 L=0.28u W=12u nf=4  m=1
XMGNn3 gn3 an3 VSS VSS nfet_03v3 L=0.28u W=6u nf=2  m=1
XMGPn3 gn3 an3 VR VR pfet_03v3 L=0.28u W=12u nf=4  m=1
XMGNp4 gp4 ap4 VSS VSS nfet_03v3 L=0.28u W=6u nf=2  m=1
XMGPp4 gp4 ap4 VR VR pfet_03v3 L=0.28u W=12u nf=4  m=1
XMGNn4 gn4 an4 VSS VSS nfet_03v3 L=0.28u W=6u nf=2  m=1
XMGPn4 gn4 an4 VR VR pfet_03v3 L=0.28u W=12u nf=4  m=1
XMCAIP xIP gp1 naIP VSS nfet_03v3 L=0.28u W=4u nf=1  m=1
XMCBIP naIP gn3 VSS VSS nfet_03v3 L=0.28u W=4u nf=1  m=1
XMCCIP xIP gn1 ncIP VSS nfet_03v3 L=0.28u W=4u nf=1  m=1
XMCDIP ncIP gp3 VSS VSS nfet_03v3 L=0.28u W=4u nf=1  m=1
XMCPAIP pmIP gp1 VR VR pfet_03v3 L=0.28u W=8u nf=1  m=1
XMCPBIP pmIP gn3 VR VR pfet_03v3 L=0.28u W=8u nf=1  m=1
XMCPCIP xIP gn1 pmIP VR pfet_03v3 L=0.28u W=8u nf=1  m=1
XMCPDIP xIP gp3 pmIP VR pfet_03v3 L=0.28u W=8u nf=1  m=1
XMLNIP LOIP xIP VSS VSS nfet_03v3 L=0.28u W=6u nf=2  m=1
XMLPIP LOIP xIP VR VR pfet_03v3 L=0.28u W=12u nf=4  m=1
XMCAIN xIN gp1 naIN VSS nfet_03v3 L=0.28u W=4u nf=1  m=1
XMCBIN naIN gp3 VSS VSS nfet_03v3 L=0.28u W=4u nf=1  m=1
XMCCIN xIN gn1 ncIN VSS nfet_03v3 L=0.28u W=4u nf=1  m=1
XMCDIN ncIN gn3 VSS VSS nfet_03v3 L=0.28u W=4u nf=1  m=1
XMCPAIN pmIN gp1 VR VR pfet_03v3 L=0.28u W=8u nf=1  m=1
XMCPBIN pmIN gp3 VR VR pfet_03v3 L=0.28u W=8u nf=1  m=1
XMCPCIN xIN gn1 pmIN VR pfet_03v3 L=0.28u W=8u nf=1  m=1
XMCPDIN xIN gn3 pmIN VR pfet_03v3 L=0.28u W=8u nf=1  m=1
XMLNIN LOIN xIN VSS VSS nfet_03v3 L=0.28u W=6u nf=2  m=1
XMLPIN LOIN xIN VR VR pfet_03v3 L=0.28u W=12u nf=4  m=1
XMCAQP xQP gp2 naQP VSS nfet_03v3 L=0.28u W=4u nf=1  m=1
XMCBQP naQP gn4 VSS VSS nfet_03v3 L=0.28u W=4u nf=1  m=1
XMCCQP xQP gn2 ncQP VSS nfet_03v3 L=0.28u W=4u nf=1  m=1
XMCDQP ncQP gp4 VSS VSS nfet_03v3 L=0.28u W=4u nf=1  m=1
XMCPAQP pmQP gp2 VR VR pfet_03v3 L=0.28u W=8u nf=1  m=1
XMCPBQP pmQP gn4 VR VR pfet_03v3 L=0.28u W=8u nf=1  m=1
XMCPCQP xQP gn2 pmQP VR pfet_03v3 L=0.28u W=8u nf=1  m=1
XMCPDQP xQP gp4 pmQP VR pfet_03v3 L=0.28u W=8u nf=1  m=1
XMLNQP LOQN xQP VSS VSS nfet_03v3 L=0.28u W=6u nf=2  m=1
XMLPQP LOQN xQP VR VR pfet_03v3 L=0.28u W=12u nf=4  m=1
XMCAQN xQN gp2 naQN VSS nfet_03v3 L=0.28u W=4u nf=1  m=1
XMCBQN naQN gp4 VSS VSS nfet_03v3 L=0.28u W=4u nf=1  m=1
XMCCQN xQN gn2 ncQN VSS nfet_03v3 L=0.28u W=4u nf=1  m=1
XMCDQN ncQN gn4 VSS VSS nfet_03v3 L=0.28u W=4u nf=1  m=1
XMCPAQN pmQN gp2 VR VR pfet_03v3 L=0.28u W=8u nf=1  m=1
XMCPBQN pmQN gp4 VR VR pfet_03v3 L=0.28u W=8u nf=1  m=1
XMCPCQN xQN gn2 pmQN VR pfet_03v3 L=0.28u W=8u nf=1  m=1
XMCPDQN xQN gn4 pmQN VR pfet_03v3 L=0.28u W=8u nf=1  m=1
XMLNQN LOQP xQN VSS VSS nfet_03v3 L=0.28u W=6u nf=2  m=1
XMLPQN LOQP xQN VR VR pfet_03v3 L=0.28u W=12u nf=4  m=1
.ends
.subckt nor2 A B Y VDD VSS
XMN1 Y A VSS VSS nfet_03v3 L=0.28u W=1u nf=1  m=1
XMN2 Y B VSS VSS nfet_03v3 L=0.28u W=1u nf=1  m=1
XMP1 n1 A VDD VDD pfet_03v3 L=0.28u W=4u nf=1  m=1
XMP2 Y B n1 VDD pfet_03v3 L=0.28u W=4u nf=1  m=1
.ends
.subckt nand2 A B Y VDD VSS
XMN1 Y A n1 VSS nfet_03v3 L=0.28u W=2u nf=1  m=1
XMN2 n1 B VSS VSS nfet_03v3 L=0.28u W=2u nf=1  m=1
XMP1 Y A VDD VDD pfet_03v3 L=0.28u W=2u nf=1  m=1
XMP2 Y B VDD VDD pfet_03v3 L=0.28u W=2u nf=1  m=1
.ends
.subckt inv_dig A Y VDD VSS
XMN Y A VSS VSS nfet_03v3 L=0.28u W=1u nf=1  m=1
XMP Y A VDD VDD pfet_03v3 L=0.28u W=2u nf=1  m=1
.ends
.subckt vco_ring4 VCTRL B0 B1 LOIP LOIN LOQP LOQN VR VDD VSS
XMVI nb VCTRL ns VSS nfet_03v3 L=0.5u W=20u nf=4  m=1
XRDEG VSS ns VSS ppolyf_u_1k r_width=2u r_length=4u
XMPD nb nb VDD VDD pfet_03v3 L=0.28u W=40u nf=8  m=1
XMPO VR nb VDD VDD pfet_03v3 L=0.28u W=40u nf=8  m=16
XRMIN VR VDD VSS ppolyf_u_1k r_width=2u r_length=5u
XB0 B0 b0n VDD VSS inv_dig
XB1 B1 b1n VDD VSS inv_dig
XMPB0 nb0 nb VDD VDD pfet_03v3 L=0.28u W=40u nf=8  m=4
XMSB0 VR b0n nb0 VDD pfet_03v3 L=0.28u W=40u nf=8  m=4
XMPB1 nb1 nb VDD VDD pfet_03v3 L=0.28u W=40u nf=8  m=16
XMSB1 VR b1n nb1 VDD pfet_03v3 L=0.28u W=40u nf=8  m=16
XCVR VR VSS cap_mim_2f0_m4m5_noshield c_width=5e-6 c_length=5e-6 m=36
XCORE ap1 an1 ap2 an2 ap3 an3 ap4 an4 kh kl VR VSS vco_core
XLO ap1 an1 ap2 an2 ap3 an3 ap4 an4 LOIP LOIN LOQP LOQN VR VSS lo_comb
XSUA ap2 an2 sua VR VSS nand2
XSUB ap2 an2 sub VR VSS nor2
XSUAD1 ap1 an1 suad1 VR VSS nand2
XSUBD1 ap1 an1 subd1 VR VSS nor2
XSUAD3 ap3 an3 suad3 VR VSS nand2
XSUBD3 ap3 an3 subd3 VR VSS nor2
XSUAD4 ap4 an4 suad4 VR VSS nand2
XSUBD4 ap4 an4 subd4 VR VSS nor2
XRSUA fsua sua VSS ppolyf_u_1k r_width=1u r_length=100u
XCSUA fsua VSS cap_mim_2f0_m4m5_noshield c_width=5e-6 c_length=5e-6 m=1
XRSUB fsub sub VSS ppolyf_u_1k r_width=1u r_length=100u
XCSUB fsub VSS cap_mim_2f0_m4m5_noshield c_width=5e-6 c_length=5e-6 m=1
XSUA1 sua fsua kh VR VSS nor2
XSUA2 kh khn VR VSS inv_dig
XSUB1 sub fsub kln VR VSS nand2
XSUB2 kln kl VR VSS inv_dig
.ends
