* NGSPICE file created from top_wires_flat.ext - technology: gf180mcuD

.subckt top_wires_flat
C0 mqn mip 0.15924f
C1 REFIN vmon 0.04359f
C2 AFCOUT refck 0.04359f
C3 nb AFC4 0.04457f
C4 IG3A fs 0.04359f
C5 B1 ain 0.0412f
C6 BWN aqn 0.04359f
C7 BWK aqp 0.03676f
C8 IG3B IG1B 0.0412f
C9 IG2B IG2A 0.65234f
C10 min l3p 0.04932f
C11 nb min 0.34121f
C12 mqp IG2B 0.05551f
C13 pb AFC6 0.04457f
C14 BWK AFC0 0.04457f
C15 ICP2 Q_SIGN 0.00784f
C16 mqn mqp 14.2509f
C17 aip min 0.04359f
C18 B1 ICP2 0.04457f
C19 ckr pb 0.03564f
C20 B0 BWK 0.55924f
C21 AFC1 AFC7 0.04223f
C22 AFC4 AFC6 0.04223f
C23 I_MAG AFC2 0.58873f
C24 AFC3 AFC0 0.22817f
C25 AFCOUT vctrl_i 0.04359f
C26 mqn refck 0.04359f
C27 RFIN pb 2.58121f
C28 BWN AFC5 0.04457f
C29 pb IG1A 0.00298f
C30 IG2A fs 0.04359f
C31 BWK aqn 0.04359f
C32 IG3A aip 0.03676f
C33 IG2B IG1B 0.04359f
C34 mip l3p 0.03234f
C35 ckr min 0.04262f
C36 nb mip 0.12394f
C37 l2p l4n 0.26303f
C38 AFCOUT aqp 0.04359f
C39 mqn IG1B 0.05616f
C40 aip mip 0.04359f
C41 IG1A min 0.011f
C42 B0 IG3B 0.04359f
C43 B1 pb 0.04359f
C44 BWN BWK 14.6556f
C45 AFC4 Q_SIGN 0.04457f
C46 I_MAG AFC6 0.04262f
C47 AFC1 AFC0 0.54406f
C48 I_SIGN AFC7 0.04258f
C49 mqp l3p 0.0517f
C50 mqp nb 0.04359f
C51 mqn vctrl_i 0.04359f
C52 ICP2 Q_MAG 0.00784f
C53 IG3A IG1A 0.03901f
C54 BWN AFC3 0.27537f
C55 BWK AFC5 0.04359f
C56 fs IG1B 0.03834f
C57 IG2A aip 0.04359f
C58 ckr mip 0.04262f
C59 B1 min 0.06396f
C60 refck nb 0.04359f
C61 AFCOUT aqn 0.04359f
C62 aqp I_SIGN 0.69081f
C63 AFC5 AFC3 0.04359f
C64 IG1A mip 0.011f
C65 ain min 0.04359f
C66 vctrl_i fs 0.03564f
C67 B0 IG2B 0.04359f
C68 B1 IG3A 0.04359f
C69 ICP2 pb 5.00707f
C70 AFC2 AFC7 0.04457f
C71 I_SIGN AFC0 0.73415f
C72 I_MAG Q_SIGN 0.49124f
C73 mqp ckr 0.04457f
C74 nb AFC7 0.04457f
C75 BWN AFC1 0.03901f
C76 pb Q_MAG 0.04457f
C77 ICP2 AFC4 0.04028f
C78 IG2A IG1A 0.04457f
C79 BWK AFC3 0.04359f
C80 fs aqp 0.15132f
C81 IG1B aip 0.65018f
C82 IG3A ain 0.08718f
C83 B1 mip 0.0412f
C84 ICP2 min 0.03676f
C85 nb vctrl_i 0.57951f
C86 mqp IG1A 0.08615f
C87 AFC5 AFC1 0.04223f
C88 ain mip 0.04359f
C89 B0 fs 0.0412f
C90 nb aqp 7.40117f
C91 B1 IG2A 0.03676f
C92 ICP2 IG3A 0.05531f
C93 AFC7 AFC6 0.04457f
C94 AFC2 AFC0 0.26358f
C95 l3n min 0.03198f
C96 mqn BWN 0.04359f
C97 mqp B1 0.04359f
C98 pb AFC4 0.04457f
C99 BWK AFC1 0.04223f
C100 BWN I_SIGN 0.03749f
C101 ICP2 I_MAG 3.02036f
C102 fs aqn 0.08718f
C103 IG1B IG1A 0.66593f
C104 IG2A ain 0.08718f
C105 pb min 0.04359f
C106 ICP2 mip 0.03676f
C107 nb B0 0.04359f
C108 vctrl_i ckr 0.05427f
C109 Q_MAG I_MAG 0.00492f
C110 AFC5 I_SIGN 0.3178f
C111 AFC3 AFC1 0.04359f
C112 VCTRL min 0.03676f
C113 BWN fs 0.04359f
C114 nb aqn 0.03676f
C115 B0 aip 0.03676f
C116 B1 IG1B 0.03676f
C117 ICP2 IG2A 0.05531f
C118 pb IG3A 0.03423f
C119 AFC6 AFC0 0.04457f
C120 l3n mip 0.03234f
C121 mqp ICP2 5.99375f
C122 mqn BWK 0.04359f
C123 BWN AFC2 2.25744f
C124 BWK I_SIGN 0.03917f
C125 IG1B ain 5.4868f
C126 pb mip 0.04359f
C127 IG3A min 0.04359f
C128 ckr B0 0.04457f
C129 nb BWN 1.39499f
C130 vctrl_i B1 0.0354f
C131 AFC4 I_MAG 0.04028f
C132 AFC5 AFC2 1.57332f
C133 AFC3 I_SIGN 0.74801f
C134 VCTRL mip 0.03676f
C135 mqp l3n 0.03559f
C136 mqn l2n 0.03596f
C137 nb AFC5 0.04457f
C138 B0 IG1A 0.03901f
C139 BWK fs 0.04359f
C140 pb IG2A 0.03423f
C141 IG3B IG2B 0.04463f
C142 min mip 28.1715f
C143 l2n l2p 1.13366f
C144 mqp pb 0.07684f
C145 BWK AFC2 0.06797f
C146 BWN AFC6 0.04457f
C147 ICP2 AFC7 0.04457f
C148 VCTRL mqp 0.0412f
C149 IG3A mip 0.04359f
C150 IG2A min 0.04359f
C151 B0 B1 10.9497f
C152 nb BWK 0.08293f
C153 refck pb 0.07923f
C154 AFC3 AFC2 0.03582f
C155 AFC1 I_SIGN 0.15734f
C156 AFC5 AFC6 0.05598f
C157 mqp min 0.04103f
C158 AFCOUT vmon 0.04359f
C159 nb AFC3 0.04457f
C160 pb IG1B 0.00298f
C161 IG3B fs 0.04359f
C162 B0 ain 0.0412f
C163 ICP2 aqp 0.03676f
C164 IG3A IG2A 0.04223f
C165 refck min 0.03676f
C166 l2n l3p 0.99563f
C167 nb rfn 0.17061f
C168 AFCOUT fs 0.08816f
C169 mqp IG3A 0.05551f
C170 pb AFC7 0.04457f
C171 BWN Q_SIGN 0.04457f
C172 BWK AFC6 0.04457f
C173 ICP2 AFC0 0.04262f
C174 IG2A mip 0.04359f
C175 IG1B min 0.04359f
C176 B1 BWN 0.04359f
C177 B0 ICP2 0.0831f
C178 AFC1 AFC2 0.03901f
C179 AFC4 AFC7 0.04223f
C180 AFC3 AFC6 0.04359f
C181 mqp mip 0.06177f
C182 AFCOUT nb 0.05642f
C183 REFIN refck 0.43442f
C184 IG2B fs 0.04359f
C185 pb aqp 2.6657f
C186 ICP2 aqn 0.04359f
C187 IG3B aip 0.15806f
C188 IG3A IG1B 0.0412f
C189 vctrl_i min 0.03676f
C190 refck mip 0.03676f
C191 l4p l4n 0.20512f
C192 nb rfp 0.17061f
C193 mqp IG2A 0.05551f
C194 BWK Q_SIGN 0.04457f
C195 IG1B mip 0.04359f
C196 B0 pb 0.04359f
C197 B1 BWK 0.04359f
C198 BWN ICP2 4.14532f
C199 Q_MAG fsb 0.04457f
C200 AFC3 Q_SIGN 0.04457f
C201 I_MAG AFC7 0.04457f
C202 AFC1 AFC6 0.04223f
C203 I_SIGN AFC2 3.80394f
C204 AFC4 AFC0 0.51549f
C205 mqn l3p 0.0412f
C206 mqn nb 0.16766f
C207 mqp refck 0.04359f
C208 BWN Q_MAG 0.04457f
C209 IG3B IG1A 0.06168f
C210 ICP2 AFC5 0.0412f
C211 pb aqn 1.29301f
C212 IG2B aip 0.03676f
C213 IG2A IG1B 0.04359f
C214 l2p l3p 0.00114f
C215 B0 min 0.03676f
C216 vctrl_i mip 0.03676f
C217 mqp IG1B 0.05551f
C218 aqp I_MAG 0.04457f
C219 nb fs 0.04359f
C220 B0 IG3A 0.04359f
C221 B1 IG3B 0.04359f
C222 ICP2 BWK 0.97909f
C223 BWN pb 0.12218f
C224 I_MAG AFC0 0.04262f
C225 I_SIGN AFC6 0.27531f
C226 mqn ckr 0.04457f
C227 mqp vctrl_i 0.04359f
C228 nb AFC2 0.04457f
C229 pb AFC5 0.04457f
C230 BWN AFC4 0.04457f
C231 BWK Q_MAG 0.04457f
C232 IG2B IG1A 0.03901f
C233 fs aip 0.04457f
C234 ICP2 AFC3 0.0412f
C235 IG3B ain 0.09042f
C236 B0 mip 0.0412f
C237 BWN min 0.13211f
C238 mqn IG1A 0.08505f
C239 AFC5 AFC4 0.04223f
C240 aqn I_MAG 0.04457f
C241 BWK pb 0.07413f
C242 B0 IG2A 0.03676f
C243 B1 IG2B 0.04359f
C244 ICP2 IG3B 0.05531f
C245 AFC2 AFC6 1.30247f
C246 I_SIGN Q_SIGN 1.06511f
C247 l3n l2n 1.6241f
C248 nb AFC6 0.04457f
C249 BWK AFC4 0.04223f
C250 ICP2 AFC1 0.04028f
C251 fs IG1A 0.00298f
C252 BWN I_MAG 0.0313f
C253 IG2B ain 0.08718f
C254 BWK min 0.03676f
C255 BWN mip 0.25886f
C256 nb ckr 0.04457f
C257 AFC3 AFC4 0.66917f
C258 AFC5 I_MAG 0.0412f
C259 B1 fs 0.0412f
C260 B0 IG1B 0.03676f
C261 ICP2 IG2B 0.05531f
C262 pb IG3B 0.03423f
C263 AFC7 AFC0 0.04457f
C264 mqn ICP2 0.72602f
C265 mqp BWN 0.05121f
C266 nb Q_SIGN 0.04457f
C267 ICP2 I_SIGN 0.03917f
C268 BWK I_MAG 0.27879f
C269 fs ain 0.04868f
C270 aip IG1A 2.34448f
C271 IG3B min 0.04359f
C272 BWK mip 0.03676f
C273 nb B1 0.04359f
C274 vctrl_i B0 0.0354f
C275 AFC4 AFC1 5.85766f
C276 AFC3 I_MAG 0.0412f
C277 mqn l3n 0.03596f
C278 ICP2 fs 0.04359f
C279 B1 aip 0.03676f
C280 pb IG2B 0.03423f
C281 IG3B IG3A 2.18791f
C282 l3n vmon 0.66576f
C283 mqn pb 0.04146f
C284 mqp BWK 0.05551f
C285 ICP2 AFC2 0.05479f
C286 BWN AFC7 0.04457f
C287 aip ain 0.08021f
C288 fs Q_MAG 0.04359f
C289 aqp aqn 1.24713f
C290 AFCOUT REFIN 0.04457f
C291 VCTRL mqn 0.0412f
C292 IG3B mip 0.04359f
C293 IG2B min 0.04359f
C294 ckr B1 0.04457f
C295 nb ICP2 1.18605f
C296 AFC1 I_MAG 0.04028f
C297 AFC4 I_SIGN 0.03812f
C298 AFC5 AFC7 0.04359f
C299 mqn min 0.32826f
C300 mqp l2n 0.38703f
C301 nb Q_MAG 0.04457f
C302 B1 IG1A 0.03901f
C303 pb fs 0.04359f
C304 BWN aqp 0.02994f
C305 IG3B IG2A 0.07441f
C306 IG3A IG2B 2.64866f
C307 l3n l3p 1.17419f
C308 mqp IG3B 0.05551f
C309 BWN AFC0 0.03901f
C310 BWK AFC7 0.04457f
C311 ICP2 AFC6 0.04262f
C312 IG1A ain 0.04755f
C313 IG2B mip 0.04359f
C314 ckr ICP2 0.04457f
C315 nb pb 4.11133f
C316 B0 BWN 0.04359f
C317 AFC5 AFC0 0.04457f
C318 AFC4 AFC2 0.05639f
C319 I_MAG I_SIGN 3.66948f
C320 AFC3 AFC7 0.04359f
C321 fsb VSUBS 0.44072f
C322 Q_SIGN VSUBS 15.7642f
C323 AFC0 VSUBS 25.1726f
C324 AFC6 VSUBS 17.5772f
C325 AFC7 VSUBS 17.1526f
C326 AFC2 VSUBS 18.3854f
C327 CLKOUT VSUBS 1.4078f ; **FLOATING
C328 I_SIGN VSUBS 29.516f
C329 I_MAG VSUBS 33.8715f
C330 AFC1 VSUBS 20.0203f
C331 AFC4 VSUBS 14.1216f
C332 AFC3 VSUBS 24.9402f
C333 Q_MAG VSUBS 25.0742f
C334 AFC5 VSUBS 20.5547f
C335 ain VSUBS 62.6762f
C336 aqn VSUBS 74.5781f
C337 IG1A VSUBS 52.4513f
C338 aqp VSUBS 58.2361f
C339 aip VSUBS 54.5821f
C340 IG1B VSUBS 61.4576f
C341 fs VSUBS 0.12539p
C342 IG2A VSUBS 70.3582f
C343 IG2B VSUBS 71.1525f
C344 IG3A VSUBS 69.5388f
C345 IG3B VSUBS 77.1674f
C346 pb VSUBS 0.12187p
C347 BWK VSUBS 88.5272f
C348 ICP2 VSUBS 84.625f
C349 BWN VSUBS 88.00301f
C350 B1 VSUBS 71.1237f
C351 B0 VSUBS 72.0725f
C352 ckr VSUBS 53.2683f
C353 vctrl_i VSUBS 57.1413f
C354 nb VSUBS 0.16374p
C355 refck VSUBS 79.4068f
C356 l2p VSUBS 7.41225f
C357 l4p VSUBS 5.32109f
C358 l1n VSUBS 4.03688f ; **FLOATING
C359 l1p VSUBS 2.34469f ; **FLOATING
C360 l2n VSUBS 6.1977f
C361 l3n VSUBS 10.7745f
C362 l3p VSUBS 10.6288f
C363 l4n VSUBS 6.1981f
C364 vmon VSUBS 36.9787f
C365 mip VSUBS 97.1041f
C366 rfp VSUBS 1.56756f
C367 min VSUBS 97.2655f
C368 rfn VSUBS 1.51514f
C369 mqp VSUBS 67.713f
C370 mqn VSUBS 77.3863f
C371 REFIN VSUBS 39.4644f
C372 AFCOUT VSUBS 96.71021f
C373 VCTRL VSUBS 21.6482f
C374 RFIN VSUBS 23.9038f
.ends
