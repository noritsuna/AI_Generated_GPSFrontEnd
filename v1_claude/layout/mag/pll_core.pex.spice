* NGSPICE file created from pll_core_flat.ext - technology: gf180mcuD

.subckt pll_core_flat VSS VDD REFCK LO NB PB ICP2 VCTRL FS FB
X0 a_5465_14900# a_5347_15489# a_5320_14900# VSS nfet_03v3 ad=0.89p pd=4.89u as=0.89p ps=4.89u w=2u l=0.28u
X1 a_149000_15084# VSS cap_mim_2f0_m4m5_noshield c_width=89.88u c_length=89.88u
X2 a_29987_23329# a_29987_31589# VDD VDD pfet_03v3 ad=0.89p pd=4.89u as=0.89p ps=4.89u w=2u l=0.28u
X3 a_31667_15349# a_29987_23329# a_36825_22740# VDD pfet_03v3 ad=0.89p pd=4.89u as=0.89p ps=4.89u w=2u l=0.28u
X4 a_31785_22740# a_29987_23329# VSS VSS nfet_03v3 ad=0.445p pd=2.89u as=0.445p ps=2.89u w=1u l=0.28u
X5 a_10645_3280.t1 a_6760_3464# VSS VSS nfet_03v3 ad=1.78p pd=8.89u as=1.78p ps=8.89u w=4u l=0.28u
X6 a_169869_15139# a_20585_14900.t3 a_180040_14900# VSS nfet_03v3 ad=0.89p pd=4.89u as=0.89p ps=4.89u w=2u l=0.28u
X7 a_149000_17206.t0 a_18905_14900.t3 a_167305_14900# VDD pfet_03v3 ad=1.06p pd=4.53u as=1.78p ps=8.89u w=4u l=0.28u
X8 a_158721_14900# a_167229_16189# a_167305_14900# VDD pfet_03v3 ad=1.59p pd=6.53u as=1.59p ps=6.53u w=6u l=0.28u
X9 a_35145_26800# a_31785_18820# VSS VSS nfet_03v3 ad=0.445p pd=2.89u as=0.445p ps=2.89u w=1u l=0.28u
X10 VDD a_33465_35060# FS.t1 VDD pfet_03v3 ad=1.335p pd=6.89u as=0.795p ps=3.53u w=3u l=0.28u
X11 a_13865_23020# a_5347_31869# a_13720_23020# VSS nfet_03v3 ad=0.89p pd=4.89u as=0.89p ps=4.89u w=2u l=0.28u
X12 a_38360_18820# a_35145_18820# VSS VSS nfet_03v3 ad=0.6675p pd=3.89u as=0.6675p ps=3.89u w=1.5u l=0.28u
X13 a_30105_26800# a_35145_35402# a_45080_22740# VSS nfet_03v3 ad=0.6675p pd=3.89u as=0.6675p ps=3.89u w=1.5u l=0.28u
X14 LO a_7180_3464# cap_mim_2f0_m4m5_noshield c_width=5u c_length=5u
X15 VCTRL VSS cap_mim_2f0_m4m5_noshield c_width=5u c_length=5u
X16 a_180040_14900# NB.t9 VSS VSS nfet_03v3 ad=2.12p pd=8.53u as=3.56p ps=16.89u w=8u l=2u
X17 a_3785_18960# FB.t2 VDD VDD pfet_03v3 ad=0.89p pd=4.89u as=0.89p ps=4.89u w=2u l=0.28u
X18 a_7027_15489.t1 a_3667_19549# a_15400_18960# VSS nfet_03v3 ad=0.89p pd=4.89u as=0.89p ps=4.89u w=2u l=0.28u
X19 a_8680_35340# a_5347_36069# a_10360_35340# VSS nfet_03v3 ad=1.335p pd=6.89u as=1.335p ps=6.89u w=3u l=0.28u
X20 a_12185_14900# a_5465_14900# VSS VSS nfet_03v3 ad=0.445p pd=2.89u as=0.445p ps=2.89u w=1u l=0.28u
X21 a_15545_14900# a_13865_14900# VDD VDD pfet_03v3 ad=0.89p pd=4.89u as=0.89p ps=4.89u w=2u l=0.28u
X22 a_158721_14900# a_167229_16189# a_167305_14900# VDD pfet_03v3 ad=2.67p pd=12.89u as=1.59p ps=6.53u w=6u l=0.28u
X23 a_33347_19269# a_29987_19269# VDD VDD pfet_03v3 ad=0.89p pd=4.89u as=0.89p ps=4.89u w=2u l=0.28u
X24 a_174020_15139# NB.t5 VSS VSS nfet_03v3 ad=2.12p pd=8.53u as=2.12p ps=8.53u w=8u l=2u
X25 VCTRL VSS cap_mim_2f0_m4m5_noshield c_width=5u c_length=5u
X26 a_3785_14900# a_7027_15489.t6 a_7000_31140# VSS nfet_03v3 ad=1.335p pd=6.89u as=1.335p ps=6.89u w=3u l=0.28u
X27 a_8825_35340# a_5347_36069# VDD VDD pfet_03v3 ad=0.89p pd=4.89u as=0.89p ps=4.89u w=2u l=0.28u
X28 a_167229_16189# ICP2.t3 VSS VSS nfet_03v3 ad=0.445p pd=2.89u as=0.445p ps=2.89u w=1u l=0.28u
X29 a_149000_15084# VSS cap_mim_2f0_m4m5_noshield c_width=89.88u c_length=89.88u
X30 VDD a_174309_15139# a_174309_15139# VDD pfet_03v3 ad=1.06p pd=4.53u as=1.06p ps=4.53u w=4u l=1u
X31 a_167305_14900# a_167229_16189# a_158721_14900# VDD pfet_03v3 ad=1.59p pd=6.53u as=2.67p ps=12.89u w=6u l=0.28u
X32 a_29987_15349# a_31667_23329# VDD VDD pfet_03v3 ad=0.89p pd=4.89u as=0.89p ps=4.89u w=2u l=0.28u
X33 a_10645_3280.t0 a_6760_3464# VDD VDD pfet_03v3 ad=3.56p pd=16.89u as=3.56p ps=16.89u w=8u l=0.28u
X34 a_31667_35929# a_33465_30860# VSS VSS nfet_03v3 ad=0.445p pd=2.89u as=0.445p ps=2.89u w=1u l=0.28u
X35 a_169869_15139# a_20585_14900.t2 a_183400_14900# VSS nfet_03v3 ad=0.89p pd=4.89u as=0.89p ps=4.89u w=2u l=0.28u
X36 a_169869_15139# a_174309_15139# VDD VDD pfet_03v3 ad=1.06p pd=4.53u as=1.06p ps=4.53u w=4u l=1u
X37 VDD PB.t4 a_157709_14900# VDD pfet_03v3 ad=2.12p pd=8.53u as=2.12p ps=8.53u w=8u l=2u
X38 a_3667_19549# a_13865_23020# VDD VDD pfet_03v3 ad=0.89p pd=4.89u as=0.89p ps=4.89u w=2u l=0.28u
X39 a_33465_30860# a_31667_23329# a_30105_14900# VSS nfet_03v3 ad=0.6675p pd=3.89u as=0.6675p ps=3.89u w=1.5u l=0.28u
X40 a_35145_18820# a_36707_19269# VDD VDD pfet_03v3 ad=0.89p pd=4.89u as=0.89p ps=4.89u w=2u l=0.28u
X41 a_8680_18960# a_3667_15489.t2 VSS VSS nfet_03v3 ad=0.89p pd=4.89u as=0.89p ps=4.89u w=2u l=0.28u
X42 a_3667_36069# a_3667_27669# a_22120_31140# VSS nfet_03v3 ad=0.89p pd=4.89u as=0.89p ps=4.89u w=2u l=0.28u
X43 a_3667_27669# a_8825_35340# a_17080_27080# VSS nfet_03v3 ad=0.89p pd=4.89u as=0.89p ps=4.89u w=2u l=0.28u
X44 a_3667_27669# a_8825_35340# VDD VDD pfet_03v3 ad=0.89p pd=4.89u as=0.89p ps=4.89u w=2u l=0.28u
X45 a_174020_15139# a_169869_15139# a_169869_15139# VSS nfet_03v3 ad=1.78p pd=8.89u as=1.06p ps=4.53u w=4u l=1u
X46 a_21167_1909# a_21167_1909# VSS VSS nfet_03v3 ad=0.445p pd=2.89u as=0.445p ps=2.89u w=1u l=0.28u
X47 a_5465_14900# a_7027_15489.t1 VDD VDD pfet_03v3 ad=0.89p pd=4.89u as=0.89p ps=4.89u w=2u l=0.28u
X48 a_8825_35340# a_3785_35340# a_8680_35340# VSS nfet_03v3 ad=1.335p pd=6.89u as=1.335p ps=6.89u w=3u l=0.28u
X49 a_13865_23020# a_5347_31869# VDD VDD pfet_03v3 ad=0.89p pd=4.89u as=0.89p ps=4.89u w=2u l=0.28u
X50 a_31785_14900# a_29987_23329# VDD VDD pfet_03v3 ad=0.89p pd=4.89u as=0.89p ps=4.89u w=2u l=0.28u
X51 FS.t0 a_33465_35060# VDD VDD pfet_03v3 ad=0.795p pd=3.53u as=1.335p ps=6.89u w=3u l=0.28u
X52 a_29987_19269# a_31667_27389# VDD VDD pfet_03v3 ad=0.89p pd=4.89u as=0.89p ps=4.89u w=2u l=0.28u
X53 a_30105_35060# a_29987_23329# VDD VDD pfet_03v3 ad=1.78p pd=8.89u as=1.78p ps=8.89u w=4u l=0.28u
X54 FS.t1 a_33465_35060# VDD VDD pfet_03v3 ad=0.795p pd=3.53u as=0.795p ps=3.53u w=3u l=0.28u
X55 LO a_7180_3464# cap_mim_2f0_m4m5_noshield c_width=5u c_length=5u
X56 a_49285_30860# a_31667_27389# VDD VDD pfet_03v3 ad=0.89p pd=4.89u as=0.89p ps=4.89u w=2u l=0.28u
X57 a_35000_18820# a_36707_19269# VSS VSS nfet_03v3 ad=0.6675p pd=3.89u as=0.6675p ps=3.89u w=1.5u l=0.28u
X58 a_29987_23329# a_29987_31589# VSS VSS nfet_03v3 ad=0.445p pd=2.89u as=0.445p ps=2.89u w=1u l=0.28u
X59 a_149000_17206.t3 a_7027_15489.t3 a_180040_14900# VSS nfet_03v3 ad=0.89p pd=4.89u as=0.89p ps=4.89u w=2u l=0.28u
X60 a_181821_20080# NB.t3 VSS VSS nfet_03v3 ad=2.12p pd=8.53u as=2.12p ps=8.53u w=8u l=2u
X61 a_33347_19269# a_35145_26800# a_30105_18820# VSS nfet_03v3 ad=0.6675p pd=3.89u as=0.6675p ps=3.89u w=1.5u l=0.28u
X62 a_6760_3464# a_7180_3464# VSS VSS nfet_03v3 ad=1.78p pd=8.89u as=1.78p ps=8.89u w=4u l=0.28u
X63 a_5347_31869# a_3785_18960# a_8680_18960# VSS nfet_03v3 ad=0.89p pd=4.89u as=0.89p ps=4.89u w=2u l=0.28u
X64 a_36707_19269# a_31785_18820# VSS VSS nfet_03v3 ad=0.445p pd=2.89u as=0.445p ps=2.89u w=1u l=0.28u
X65 VCTRL VSS cap_mim_2f0_m4m5_noshield c_width=5u c_length=5u
X66 a_5465_14900# a_5347_15489# VDD VDD pfet_03v3 ad=0.89p pd=4.89u as=0.89p ps=4.89u w=2u l=0.28u
X67 a_3785_35340# a_3667_36069# a_3640_35340# VSS nfet_03v3 ad=1.335p pd=6.89u as=1.335p ps=6.89u w=3u l=0.28u
X68 a_3667_23609# a_3667_15489.t5 VDD VDD pfet_03v3 ad=0.89p pd=4.89u as=0.89p ps=4.89u w=2u l=0.28u
X69 a_41720_18820# a_31667_23329# VSS VSS nfet_03v3 ad=0.6675p pd=3.89u as=0.6675p ps=3.89u w=1.5u l=0.28u
X70 a_149000_17206.t6 VSS cap_mim_2f0_m4m5_noshield c_width=51.67u c_length=51.67u
X71 a_35145_26800# a_29987_19269# a_33465_26800# VDD pfet_03v3 ad=0.89p pd=4.89u as=0.89p ps=4.89u w=2u l=0.28u
X72 a_8825_35340# a_3785_35340# VDD VDD pfet_03v3 ad=0.89p pd=4.89u as=0.89p ps=4.89u w=2u l=0.28u
X73 VCTRL VSS cap_mim_2f0_m4m5_noshield c_width=5u c_length=5u
X74 VDD PB.t2 a_158721_14900# VDD pfet_03v3 ad=2.12p pd=8.53u as=2.12p ps=8.53u w=8u l=2u
X75 VDD PB.t14 a_157709_14900# VDD pfet_03v3 ad=2.12p pd=8.53u as=2.12p ps=8.53u w=8u l=2u
X76 a_15545_14900# a_13865_14900# VSS VSS nfet_03v3 ad=0.445p pd=2.89u as=0.445p ps=2.89u w=1u l=0.28u
X77 a_31785_18820# a_29987_19269# a_31640_18820# VSS nfet_03v3 ad=0.6675p pd=3.89u as=0.6675p ps=3.89u w=1.5u l=0.28u
X78 VCTRL VSS cap_mim_2f0_m4m5_noshield c_width=5u c_length=5u
X79 a_166745_22522# a_18905_14900.t7 VSS VSS nfet_03v3 ad=0.445p pd=2.89u as=0.445p ps=2.89u w=1u l=0.28u
X80 a_36825_22740# a_35145_14900# VDD VDD pfet_03v3 ad=0.89p pd=4.89u as=0.89p ps=4.89u w=2u l=0.28u
X81 VCTRL VSS cap_mim_2f0_m4m5_noshield c_width=5u c_length=5u
X82 a_35145_14900# a_31785_14900# VDD VDD pfet_03v3 ad=1.335p pd=6.89u as=1.335p ps=6.89u w=3u l=0.28u
X83 VSS a_33465_35060# FS.t2 VSS nfet_03v3 ad=1.335p pd=6.89u as=0.795p ps=3.53u w=3u l=0.28u
X84 a_5347_15489# a_3785_35340# a_3785_23020# VSS nfet_03v3 ad=0.89p pd=4.89u as=0.89p ps=4.89u w=2u l=0.28u
X85 a_3785_14900# a_3667_15489.t2 VDD VDD pfet_03v3 ad=0.89p pd=4.89u as=0.89p ps=4.89u w=2u l=0.28u
X86 a_169869_15139# a_169869_15139# a_174020_15139# VSS nfet_03v3 ad=1.06p pd=4.53u as=1.06p ps=4.53u w=4u l=1u
X87 a_5320_35340# a_3667_15489.t12 VSS VSS nfet_03v3 ad=1.335p pd=6.89u as=1.335p ps=6.89u w=3u l=0.28u
X88 a_3667_19549# a_3667_15489.t4 VDD VDD pfet_03v3 ad=0.89p pd=4.89u as=0.89p ps=4.89u w=2u l=0.28u
X89 a_33465_35060# FB.t3 VSS VSS nfet_03v3 ad=0.89p pd=4.89u as=0.89p ps=4.89u w=2u l=0.28u
X90 a_30105_26800# a_10645_3280.t4 VDD VDD pfet_03v3 ad=0.89p pd=4.89u as=0.89p ps=4.89u w=2u l=0.28u
X91 a_3785_18960# a_3667_19549# VDD VDD pfet_03v3 ad=0.89p pd=4.89u as=0.89p ps=4.89u w=2u l=0.28u
X92 a_180040_14900# NB.t1 VSS VSS nfet_03v3 ad=2.12p pd=8.53u as=2.12p ps=8.53u w=8u l=2u
X93 a_158721_14900# PB.t9 VDD VDD pfet_03v3 ad=2.12p pd=8.53u as=2.12p ps=8.53u w=8u l=2u
X94 a_35145_35402# a_31667_27389# VSS VSS nfet_03v3 ad=0.445p pd=2.89u as=0.445p ps=2.89u w=1u l=0.28u
X95 a_19487_1769# a_17807_1769# VSS VSS nfet_03v3 ad=0.445p pd=2.89u as=0.445p ps=2.89u w=1u l=0.28u
X96 a_35145_18820# a_35027_19269# a_35000_18820# VSS nfet_03v3 ad=0.6675p pd=3.89u as=0.6675p ps=3.89u w=1.5u l=0.28u
X97 a_149000_17206.t5 a_149000_15084# VSS ppolyf_u_1k r_width=1u r_length=10u
X98 a_149000_17206.t4 VCTRL VSS ppolyf_u_1k r_width=2u r_length=4u
X99 a_20440_35340# a_3667_15489.t10 VSS VSS nfet_03v3 ad=1.335p pd=6.89u as=1.335p ps=6.89u w=3u l=0.28u
X100 FS.t2 a_33465_35060# VSS VSS nfet_03v3 ad=0.795p pd=3.53u as=1.335p ps=6.89u w=3u l=0.28u
X101 a_31785_22740# a_31667_23329# a_30105_22740# VDD pfet_03v3 ad=0.89p pd=4.89u as=0.89p ps=4.89u w=2u l=0.28u
X102 a_5320_14900# a_7027_15489.t1 VSS VSS nfet_03v3 ad=0.89p pd=4.89u as=0.89p ps=4.89u w=2u l=0.28u
X103 a_41747_19269# a_31667_23329# a_46905_26800# VDD pfet_03v3 ad=0.89p pd=4.89u as=0.89p ps=4.89u w=2u l=0.28u
X104 a_157709_14900# a_18905_14900.t4 a_149000_17206.t2 VDD pfet_03v3 ad=1.06p pd=4.53u as=1.06p ps=4.53u w=4u l=0.28u
X105 VDD PB.t0 a_157709_14900# VDD pfet_03v3 ad=3.56p pd=16.89u as=2.12p ps=8.53u w=8u l=2u
X106 a_149000_17206.t1 a_7027_15489.t2 a_183400_14900# VSS nfet_03v3 ad=0.89p pd=4.89u as=0.89p ps=4.89u w=2u l=0.28u
X107 VDD PB.t12 a_158721_14900# VDD pfet_03v3 ad=2.12p pd=8.53u as=2.12p ps=8.53u w=8u l=2u
X108 a_174309_15139# a_174309_15139# VDD VDD pfet_03v3 ad=1.06p pd=4.53u as=1.78p ps=8.89u w=4u l=1u
X109 a_5347_15489# a_3785_35340# VDD VDD pfet_03v3 ad=0.89p pd=4.89u as=0.89p ps=4.89u w=2u l=0.28u
X110 a_13720_23020# a_3667_19549# VSS VSS nfet_03v3 ad=0.89p pd=4.89u as=0.89p ps=4.89u w=2u l=0.28u
X111 LO a_7180_3464# cap_mim_2f0_m4m5_noshield c_width=5u c_length=5u
X112 VCTRL VSS cap_mim_2f0_m4m5_noshield c_width=5u c_length=5u
X113 a_33465_30860# a_29987_15349# VDD VDD pfet_03v3 ad=1.335p pd=6.89u as=1.335p ps=6.89u w=3u l=0.28u
X114 a_3667_36069# a_3785_35340# VDD VDD pfet_03v3 ad=0.89p pd=4.89u as=0.89p ps=4.89u w=2u l=0.28u
X115 a_3785_18960# a_5347_31869# VDD VDD pfet_03v3 ad=0.89p pd=4.89u as=0.89p ps=4.89u w=2u l=0.28u
X116 a_31640_14900# a_29987_23329# VSS VSS nfet_03v3 ad=0.6675p pd=3.89u as=0.6675p ps=3.89u w=1.5u l=0.28u
X117 a_157709_14900# a_166745_22522# a_169869_15139# VDD pfet_03v3 ad=1.78p pd=8.89u as=1.06p ps=4.53u w=4u l=0.28u
X118 a_35145_35402# a_10645_3280.t5 a_49285_30860# VDD pfet_03v3 ad=0.89p pd=4.89u as=0.89p ps=4.89u w=2u l=0.28u
X119 a_30105_18820# a_29987_19269# VSS VSS nfet_03v3 ad=0.6675p pd=3.89u as=0.6675p ps=3.89u w=1.5u l=0.28u
X120 a_149000_17206.t2 a_18905_14900.t5 a_157709_14900# VDD pfet_03v3 ad=1.06p pd=4.53u as=1.78p ps=8.89u w=4u l=0.28u
X121 a_8825_35340# a_3667_27669# VDD VDD pfet_03v3 ad=0.89p pd=4.89u as=0.89p ps=4.89u w=2u l=0.28u
X122 a_149000_15084# VSS cap_mim_2f0_m4m5_noshield c_width=89.88u c_length=89.88u
X123 LO a_7180_3464# cap_mim_2f0_m4m5_noshield c_width=5u c_length=5u
X124 a_31667_35929# a_33465_30860# VDD VDD pfet_03v3 ad=0.89p pd=4.89u as=0.89p ps=4.89u w=2u l=0.28u
X125 a_3785_14900# a_7027_15489.t1 VDD VDD pfet_03v3 ad=0.89p pd=4.89u as=0.89p ps=4.89u w=2u l=0.28u
X126 a_158721_14900# PB.t7 VDD VDD pfet_03v3 ad=2.12p pd=8.53u as=2.12p ps=8.53u w=8u l=2u
X127 a_31667_23329# a_38505_18820# VSS VSS nfet_03v3 ad=0.445p pd=2.89u as=0.445p ps=2.89u w=1u l=0.28u
X128 a_29987_15349# a_31785_22740# a_48440_18820# VSS nfet_03v3 ad=0.6675p pd=3.89u as=0.6675p ps=3.89u w=1.5u l=0.28u
X129 a_158721_14900# PB.t3 VDD VDD pfet_03v3 ad=2.12p pd=8.53u as=2.12p ps=8.53u w=8u l=2u
X130 a_38505_18820# a_35145_18820# VDD VDD pfet_03v3 ad=1.335p pd=6.89u as=1.335p ps=6.89u w=3u l=0.28u
X131 a_3667_19549# a_13865_23020# a_18760_35340# VSS nfet_03v3 ad=1.335p pd=6.89u as=1.335p ps=6.89u w=3u l=0.28u
X132 a_3667_23609# a_8825_35340# VDD VDD pfet_03v3 ad=0.89p pd=4.89u as=0.89p ps=4.89u w=2u l=0.28u
X133 VCTRL VSS cap_mim_2f0_m4m5_noshield c_width=5u c_length=5u
X134 a_41865_18820# a_31667_23329# VDD VDD pfet_03v3 ad=0.89p pd=4.89u as=0.89p ps=4.89u w=2u l=0.28u
X135 VDD PB.t10 a_157709_14900# VDD pfet_03v3 ad=2.12p pd=8.53u as=2.12p ps=8.53u w=8u l=2u
X136 a_3785_35340# a_3667_15489.t8 VDD VDD pfet_03v3 ad=0.89p pd=4.89u as=0.89p ps=4.89u w=2u l=0.28u
X137 a_167229_16189# ICP2.t2 VDD VDD pfet_03v3 ad=0.89p pd=4.89u as=0.89p ps=4.89u w=2u l=0.28u
X138 a_30105_22740# a_29987_23329# VDD VDD pfet_03v3 ad=0.89p pd=4.89u as=0.89p ps=4.89u w=2u l=0.28u
X139 VSS NB.t8 a_180040_14900# VSS nfet_03v3 ad=2.12p pd=8.53u as=2.12p ps=8.53u w=8u l=2u
X140 VCTRL VSS cap_mim_2f0_m4m5_noshield c_width=5u c_length=5u
X141 VCTRL VSS cap_mim_2f0_m4m5_noshield c_width=5u c_length=5u
X142 a_31667_27389# a_10645_3280.t2 a_48440_22740# VSS nfet_03v3 ad=0.6675p pd=3.89u as=0.6675p ps=3.89u w=1.5u l=0.28u
X143 a_169869_15139# a_166745_22522# a_157709_14900# VDD pfet_03v3 ad=1.06p pd=4.53u as=1.06p ps=4.53u w=4u l=0.28u
X144 VCTRL VSS cap_mim_2f0_m4m5_noshield c_width=5u c_length=5u
X145 a_31785_18820# a_33347_19269# VDD VDD pfet_03v3 ad=1.335p pd=6.89u as=1.335p ps=6.89u w=3u l=0.28u
X146 a_18905_14900.t0 a_5347_15489# VDD VDD pfet_03v3 ad=0.89p pd=4.89u as=0.89p ps=4.89u w=2u l=0.28u
X147 a_3667_23609# a_5347_15489# a_13720_35340# VSS nfet_03v3 ad=1.335p pd=6.89u as=1.335p ps=6.89u w=3u l=0.28u
X148 a_3667_23609# a_5347_15489# VDD VDD pfet_03v3 ad=0.89p pd=4.89u as=0.89p ps=4.89u w=2u l=0.28u
X149 a_157709_14900# PB.t5 VDD VDD pfet_03v3 ad=2.12p pd=8.53u as=2.12p ps=8.53u w=8u l=2u
X150 a_22120_31140# a_3785_35340# VSS VSS nfet_03v3 ad=0.89p pd=4.89u as=0.89p ps=4.89u w=2u l=0.28u
X151 a_7027_15489.t1 a_3667_19549# VDD VDD pfet_03v3 ad=0.89p pd=4.89u as=0.89p ps=4.89u w=2u l=0.28u
X152 a_167305_14900# a_18905_14900.t2 a_149000_17206.t0 VDD pfet_03v3 ad=1.06p pd=4.53u as=1.06p ps=4.53u w=4u l=0.28u
X153 a_41747_19269# a_31785_35060# VSS VSS nfet_03v3 ad=0.445p pd=2.89u as=0.445p ps=2.89u w=1u l=0.28u
X154 a_3785_35340# a_5347_36069# VDD VDD pfet_03v3 ad=0.89p pd=4.89u as=0.89p ps=4.89u w=2u l=0.28u
X155 a_35000_14900# a_31785_14900# VSS VSS nfet_03v3 ad=0.6675p pd=3.89u as=0.6675p ps=3.89u w=1.5u l=0.28u
X156 a_48440_18820# a_31667_23329# VSS VSS nfet_03v3 ad=0.6675p pd=3.89u as=0.6675p ps=3.89u w=1.5u l=0.28u
X157 a_174020_15139# a_149000_17206.t7 a_174309_15139# VSS nfet_03v3 ad=1.06p pd=4.53u as=1.06p ps=4.53u w=4u l=1u
X158 a_157709_14900# PB.t1 VDD VDD pfet_03v3 ad=2.12p pd=8.53u as=2.12p ps=8.53u w=8u l=2u
X159 a_31785_35060# a_31667_35929# VSS VSS nfet_03v3 ad=0.445p pd=2.89u as=0.445p ps=2.89u w=1u l=0.28u
X160 a_158721_14900# PB.t13 VDD VDD pfet_03v3 ad=2.12p pd=8.53u as=2.12p ps=8.53u w=8u l=2u
X161 a_18760_35340# FB.t7 a_20440_35340# VSS nfet_03v3 ad=1.335p pd=6.89u as=1.335p ps=6.89u w=3u l=0.28u
X162 a_46905_26800# a_31785_35060# VDD VDD pfet_03v3 ad=0.89p pd=4.89u as=0.89p ps=4.89u w=2u l=0.28u
X163 a_3785_23020# a_3667_23609# VSS VSS nfet_03v3 ad=0.89p pd=4.89u as=0.89p ps=4.89u w=2u l=0.28u
X164 a_6760_5586# a_7180_3464# VSS ppolyf_u_1k r_width=1u r_length=10u
X165 VSS NB.t6 a_181821_20080# VSS nfet_03v3 ad=2.12p pd=8.53u as=2.12p ps=8.53u w=8u l=2u
X166 a_13865_14900# a_12185_14900# VDD VDD pfet_03v3 ad=0.89p pd=4.89u as=0.89p ps=4.89u w=2u l=0.28u
X167 a_15400_35340# a_3667_15489.t11 VSS VSS nfet_03v3 ad=1.335p pd=6.89u as=1.335p ps=6.89u w=3u l=0.28u
X168 a_5347_31869# a_3667_15489.t3 VDD VDD pfet_03v3 ad=0.89p pd=4.89u as=0.89p ps=4.89u w=2u l=0.28u
X169 LO a_7180_3464# cap_mim_2f0_m4m5_noshield c_width=5u c_length=5u
X170 a_169869_15139# a_166745_22522# a_167305_14900# VDD pfet_03v3 ad=1.06p pd=4.53u as=1.06p ps=4.53u w=4u l=0.28u
X171 a_3640_31140# a_5347_31869# VSS VSS nfet_03v3 ad=1.335p pd=6.89u as=1.335p ps=6.89u w=3u l=0.28u
X172 VSS NB.t2 a_181821_20080# VSS nfet_03v3 ad=2.12p pd=8.53u as=2.12p ps=8.53u w=8u l=2u
X173 a_5347_36069# a_17807_1769# VDD VDD pfet_03v3 ad=0.89p pd=4.89u as=0.89p ps=4.89u w=2u l=0.28u
X174 a_33465_35060# FB.t6 VDD VDD pfet_03v3 ad=1.78p pd=8.89u as=1.78p ps=8.89u w=4u l=0.28u
X175 a_3667_36069# a_3667_27669# VDD VDD pfet_03v3 ad=0.89p pd=4.89u as=0.89p ps=4.89u w=2u l=0.28u
X176 a_31785_14900# a_31667_15349# a_31640_14900# VSS nfet_03v3 ad=0.6675p pd=3.89u as=0.6675p ps=3.89u w=1.5u l=0.28u
X177 a_48440_22740# a_30105_26800# VSS VSS nfet_03v3 ad=0.6675p pd=3.89u as=0.6675p ps=3.89u w=1.5u l=0.28u
X178 a_166745_22522# a_18905_14900.t6 VDD VDD pfet_03v3 ad=0.89p pd=4.89u as=0.89p ps=4.89u w=2u l=0.28u
X179 a_20585_14900.t0 a_7027_15489.t4 VDD VDD pfet_03v3 ad=0.89p pd=4.89u as=0.89p ps=4.89u w=2u l=0.28u
X180 a_35027_19269# a_36707_19269# a_40185_26800# VDD pfet_03v3 ad=0.89p pd=4.89u as=0.89p ps=4.89u w=2u l=0.28u
X181 VCTRL VSS cap_mim_2f0_m4m5_noshield c_width=5u c_length=5u
X182 a_157709_14900# PB.t15 VDD VDD pfet_03v3 ad=2.12p pd=8.53u as=3.56p ps=16.89u w=8u l=2u
X183 a_15400_18960# a_3785_14900# VSS VSS nfet_03v3 ad=0.89p pd=4.89u as=0.89p ps=4.89u w=2u l=0.28u
X184 a_7027_15489.t0 a_3785_14900# VDD VDD pfet_03v3 ad=0.89p pd=4.89u as=0.89p ps=4.89u w=2u l=0.28u
X185 a_181821_20080# ICP2.t0 a_183400_14900# VSS nfet_03v3 ad=0.89p pd=4.89u as=0.53p ps=2.53u w=2u l=0.28u
X186 a_10360_35340# a_3667_27669# VSS VSS nfet_03v3 ad=1.335p pd=6.89u as=1.335p ps=6.89u w=3u l=0.28u
X187 a_45080_18820# a_41865_18820# VSS VSS nfet_03v3 ad=0.6675p pd=3.89u as=0.6675p ps=3.89u w=1.5u l=0.28u
X188 VCTRL VSS cap_mim_2f0_m4m5_noshield c_width=5u c_length=5u
X189 a_157709_14900# PB.t11 VDD VDD pfet_03v3 ad=2.12p pd=8.53u as=2.12p ps=8.53u w=8u l=2u
X190 a_3667_15489.t0 a_15545_14900# VDD VDD pfet_03v3 ad=0.89p pd=4.89u as=0.89p ps=4.89u w=2u l=0.28u
X191 a_31667_15349# a_35145_14900# VSS VSS nfet_03v3 ad=0.445p pd=2.89u as=0.445p ps=2.89u w=1u l=0.28u
X192 a_36707_19269# a_31785_18820# VDD VDD pfet_03v3 ad=0.89p pd=4.89u as=0.89p ps=4.89u w=2u l=0.28u
X193 a_5347_15489# a_3667_23609# VDD VDD pfet_03v3 ad=0.89p pd=4.89u as=0.89p ps=4.89u w=2u l=0.28u
X194 a_18905_14900.t1 a_5347_15489# VSS VSS nfet_03v3 ad=0.445p pd=2.89u as=0.445p ps=2.89u w=1u l=0.28u
X195 a_3785_35340# a_3667_36069# VDD VDD pfet_03v3 ad=0.89p pd=4.89u as=0.89p ps=4.89u w=2u l=0.28u
X196 a_35145_14900# a_29987_23329# a_35000_14900# VSS nfet_03v3 ad=0.6675p pd=3.89u as=0.6675p ps=3.89u w=1.5u l=0.28u
X197 LO a_7180_3464# cap_mim_2f0_m4m5_noshield c_width=5u c_length=5u
X198 REFCK a_5347_36069# VSS ppolyf_u_1k r_width=2u r_length=2u
X199 a_8680_31140# a_3667_15489.t9 VSS VSS nfet_03v3 ad=1.335p pd=6.89u as=1.335p ps=6.89u w=3u l=0.28u
X200 VSS NB.t4 a_174020_15139# VSS nfet_03v3 ad=2.12p pd=8.53u as=2.12p ps=8.53u w=8u l=2u
X201 a_5347_36069# a_19487_1769# VSS VSS nfet_03v3 ad=0.89p pd=4.89u as=0.89p ps=4.89u w=2u l=0.28u
X202 a_3667_19549# FB.t4 VDD VDD pfet_03v3 ad=0.89p pd=4.89u as=0.89p ps=4.89u w=2u l=0.28u
X203 a_169869_15139# VSS cap_mim_2f0_m4m5_noshield c_width=32.01u c_length=32.01u
X204 VSS NB.t0 a_180040_14900# VSS nfet_03v3 ad=3.56p pd=16.89u as=2.12p ps=8.53u w=8u l=2u
X205 VDD PB.t8 a_158721_14900# VDD pfet_03v3 ad=2.12p pd=8.53u as=2.12p ps=8.53u w=8u l=2u
X206 a_3667_27669# a_3667_15489.t6 VDD VDD pfet_03v3 ad=0.89p pd=4.89u as=0.89p ps=4.89u w=2u l=0.28u
X207 a_31667_23329# a_38505_18820# VDD VDD pfet_03v3 ad=0.89p pd=4.89u as=0.89p ps=4.89u w=2u l=0.28u
X208 a_29987_31589# a_41865_18820# VDD VDD pfet_03v3 ad=1.335p pd=6.89u as=1.335p ps=6.89u w=3u l=0.28u
X209 a_12185_14900# a_5465_14900# VDD VDD pfet_03v3 ad=0.89p pd=4.89u as=0.89p ps=4.89u w=2u l=0.28u
X210 a_3785_18960# a_3667_19549# a_3785_31140# VSS nfet_03v3 ad=1.335p pd=6.89u as=1.335p ps=6.89u w=3u l=0.28u
X211 a_41865_18820# a_41747_19269# a_41720_18820# VSS nfet_03v3 ad=0.6675p pd=3.89u as=0.6675p ps=3.89u w=1.5u l=0.28u
X212 a_33465_26800# a_31785_18820# VDD VDD pfet_03v3 ad=0.89p pd=4.89u as=0.89p ps=4.89u w=2u l=0.28u
X213 a_45080_22740# a_10645_3280.t3 VSS VSS nfet_03v3 ad=0.6675p pd=3.89u as=0.6675p ps=3.89u w=1.5u l=0.28u
X214 a_5347_31869# a_3785_18960# VDD VDD pfet_03v3 ad=0.89p pd=4.89u as=0.89p ps=4.89u w=2u l=0.28u
X215 a_167305_14900# a_167229_16189# a_158721_14900# VDD pfet_03v3 ad=1.59p pd=6.53u as=1.59p ps=6.53u w=6u l=0.28u
X216 a_29987_19269# a_31667_27389# VSS VSS nfet_03v3 ad=0.445p pd=2.89u as=0.445p ps=2.89u w=1u l=0.28u
X217 a_13865_14900# a_12185_14900# VSS VSS nfet_03v3 ad=0.445p pd=2.89u as=0.445p ps=2.89u w=1u l=0.28u
X218 VCTRL VSS cap_mim_2f0_m4m5_noshield c_width=5u c_length=5u
X219 a_149000_15084# VSS cap_mim_2f0_m4m5_noshield c_width=89.88u c_length=89.88u
X220 a_6760_3464# a_7180_3464# VDD VDD pfet_03v3 ad=3.56p pd=16.89u as=3.56p ps=16.89u w=8u l=0.28u
X221 a_167305_14900# a_166745_22522# a_169869_15139# VDD pfet_03v3 ad=1.78p pd=8.89u as=1.06p ps=4.53u w=4u l=0.28u
X222 a_30105_14900# a_29987_15349# VSS VSS nfet_03v3 ad=0.6675p pd=3.89u as=0.6675p ps=3.89u w=1.5u l=0.28u
X223 a_38505_18820# a_36707_19269# a_38360_18820# VSS nfet_03v3 ad=0.6675p pd=3.89u as=0.6675p ps=3.89u w=1.5u l=0.28u
X224 a_6760_5586# a_6760_3464# VSS ppolyf_u_1k r_width=1u r_length=10u
X225 a_7000_31140# a_3785_18960# a_8680_31140# VSS nfet_03v3 ad=1.335p pd=6.89u as=1.335p ps=6.89u w=3u l=0.28u
X226 a_31667_27389# a_30105_26800# VDD VDD pfet_03v3 ad=1.335p pd=6.89u as=1.335p ps=6.89u w=3u l=0.28u
X227 a_40185_26800# a_38505_18820# VDD VDD pfet_03v3 ad=0.89p pd=4.89u as=0.89p ps=4.89u w=2u l=0.28u
X228 VDD a_174309_15139# a_169869_15139# VDD pfet_03v3 ad=1.78p pd=8.89u as=1.06p ps=4.53u w=4u l=1u
X229 a_31785_35060# a_29987_23329# VSS VSS nfet_03v3 ad=0.445p pd=2.89u as=0.445p ps=2.89u w=1u l=0.28u
X230 a_181821_20080# NB.t7 VSS VSS nfet_03v3 ad=2.12p pd=8.53u as=2.12p ps=8.53u w=8u l=2u
X231 VCTRL VSS cap_mim_2f0_m4m5_noshield c_width=5u c_length=5u
X232 a_183400_14900# ICP2.t1 a_181821_20080# VSS nfet_03v3 ad=0.53p pd=2.53u as=0.89p ps=4.89u w=2u l=0.28u
X233 a_35027_19269# a_38505_18820# VSS VSS nfet_03v3 ad=0.445p pd=2.89u as=0.445p ps=2.89u w=1u l=0.28u
X234 a_3640_35340# a_5347_36069# a_5320_35340# VSS nfet_03v3 ad=1.335p pd=6.89u as=1.335p ps=6.89u w=3u l=0.28u
X235 a_20585_14900.t1 a_7027_15489.t5 VSS VSS nfet_03v3 ad=0.445p pd=2.89u as=0.445p ps=2.89u w=1u l=0.28u
X236 a_29987_31589# a_31667_23329# a_45080_18820# VSS nfet_03v3 ad=0.6675p pd=3.89u as=0.6675p ps=3.89u w=1.5u l=0.28u
X237 a_174309_15139# a_149000_17206.t7 a_174020_15139# VSS nfet_03v3 ad=1.06p pd=4.53u as=1.78p ps=8.89u w=4u l=1u
X238 a_17080_27080# a_3667_15489.t7 VSS VSS nfet_03v3 ad=0.89p pd=4.89u as=0.89p ps=4.89u w=2u l=0.28u
X239 a_3785_14900# a_3785_18960# VDD VDD pfet_03v3 ad=0.89p pd=4.89u as=0.89p ps=4.89u w=2u l=0.28u
X240 a_13720_35340# a_8825_35340# a_15400_35340# VSS nfet_03v3 ad=1.335p pd=6.89u as=1.335p ps=6.89u w=3u l=0.28u
X241 a_3667_15489.t1 a_15545_14900# VSS VSS nfet_03v3 ad=0.445p pd=2.89u as=0.445p ps=2.89u w=1u l=0.28u
X242 a_13865_23020# a_3667_19549# VDD VDD pfet_03v3 ad=0.89p pd=4.89u as=0.89p ps=4.89u w=2u l=0.28u
X243 FB.t0 a_35145_14900# VDD VDD pfet_03v3 ad=0.89p pd=4.89u as=0.89p ps=4.89u w=2u l=0.28u
X244 a_31640_18820# a_33347_19269# VSS VSS nfet_03v3 ad=0.6675p pd=3.89u as=0.6675p ps=3.89u w=1.5u l=0.28u
X245 a_17807_1769# a_21167_1909# VDD VDD pfet_03v3 ad=0.445p pd=2.89u as=0.445p ps=2.89u w=1u l=0.28u
X246 VDD PB.t6 a_158721_14900# VDD pfet_03v3 ad=2.12p pd=8.53u as=2.12p ps=8.53u w=8u l=2u
X247 FB.t1 a_35145_14900# VSS VSS nfet_03v3 ad=0.445p pd=2.89u as=0.445p ps=2.89u w=1u l=0.28u
X248 VDD a_33465_35060# FS.t0 VDD pfet_03v3 ad=0.795p pd=3.53u as=0.795p ps=3.53u w=3u l=0.28u
X249 a_31785_35060# a_31667_35929# a_30105_35060# VDD pfet_03v3 ad=1.78p pd=8.89u as=1.78p ps=8.89u w=4u l=0.28u
X250 a_3785_31140# FB.t5 a_3640_31140# VSS nfet_03v3 ad=1.335p pd=6.89u as=1.335p ps=6.89u w=3u l=0.28u
C0 PB a_29987_19269# 0.04363f
C1 PB a_30105_26800# 0.02484f
C2 a_169284_15079# VDD 0.58135f
C3 a_29987_23329# a_52094_26740# 0.01991f
C4 VDD a_15284_27020# 0.3627f
C5 a_3667_19549# a_13720_23020# 0.08929f
C6 a_48440_22740# a_33465_30860# 0.19752f
C7 a_3667_36069# a_3934_27020# 0.02648f
C8 a_6884_27020# a_3785_35340# 0.01092f
C9 FB a_3667_36069# 0.27256f
C10 a_20734_35280# a_20440_35340# 0.01363f
C11 a_31785_35060# a_33465_30860# 0.08247f
C12 a_149000_15084# NB 9.53056f
C13 a_7294_27020# VDD 0.34967f
C14 REFCK a_5347_36069# 0.0412f
C15 VDD a_33347_19269# 3.07189f
C16 a_13865_23020# a_3785_35340# 0.03601f
C17 a_15545_14900# a_3667_27669# 0.07693f
C18 FS a_31785_35060# 0.1891f
C19 a_8680_35340# a_3785_31140# 0.07821f
C20 a_41865_18820# a_48440_22740# 0.07788f
C21 a_36564_22680# VDD 0.36444f
C22 NB a_33347_19269# 0.07528f
C23 VDD a_5347_15489# 5.58795f
C24 a_29987_23329# a_33465_30860# 0.18088f
C25 a_31667_23329# a_33465_35060# 0.04994f
C26 a_41865_18820# a_41720_18820# 0.45912f
C27 a_15545_14900# a_8825_35340# 0.09078f
C28 NB a_5347_15489# 0.04397f
C29 a_5347_31869# PB 0.04359f
C30 a_30105_18820# a_29987_19269# 0.46f
C31 a_29987_15349# a_33347_19269# 0.02703f
C32 a_36707_19269# a_36825_22740# 0.07801f
C33 a_3785_35340# a_3640_35340# 0.29611f
C34 a_31667_23329# a_48734_35342# 0.01149f
C35 a_29987_23329# FS 0.03791f
C36 a_36974_31142# a_31785_35060# 0.0165f
C37 FS a_169869_15139# 0.27829f
C38 a_15400_35340# a_15694_35280# 0.0133f
C39 a_41747_19269# a_31667_23329# 0.15821f
C40 a_13744_3220# a_14154_3220# 0.0129f
C41 a_38505_18820# a_40185_26800# 0.02551f
C42 a_29987_31589# a_52094_35000# 0.03134f
C43 a_35027_19269# a_33465_35060# 1.74781f
C44 a_51684_18760# a_30105_14900# 0.01941f
C45 a_35145_35402# a_49285_30860# 0.30772f
C46 a_3785_14900# a_20734_18900# 0.01133f
C47 a_6884_27020# VDD 0.36279f
C48 a_41865_18820# a_29987_23329# 0.03761f
C49 a_40185_26800# a_40334_26740# 0.02332f
C50 a_5465_14900# a_5347_36069# 0.04193f
C51 a_22414_22960# VDD 0.34967f
C52 a_35145_35402# a_31785_18820# 0.03234f
C53 a_35294_22680# VDD 0.34666f
C54 a_35027_19269# a_41747_19269# 0.34599f
C55 a_13865_23020# VDD 2.39009f
C56 a_8564_14840# a_5465_14900# 0.01113f
C57 a_29987_23329# a_30105_22740# 0.115f
C58 NB a_13865_23020# 0.04224f
C59 a_169869_15139# a_157709_14900# 0.46222f
C60 a_36825_22740# a_31667_15349# 0.31194f
C61 a_31785_22740# FB 0.07093f
C62 a_178456_14840# a_169869_15139# 0.01347f
C63 a_5347_31869# a_3785_14900# 0.60246f
C64 a_169869_15139# a_175376_15079# 0.01693f
C65 a_33465_30860# a_33347_19269# 0.03509f
C66 FS a_149000_15084# 9.26833f
C67 a_5204_35280# a_5320_35340# 0.02865f
C68 a_36707_19269# a_38244_26740# 0.01036f
C69 a_33465_26800# a_31785_18820# 0.02996f
C70 FB a_35145_26800# 0.07535f
C71 a_31785_14900# a_38505_18820# 0.92542f
C72 a_22004_22960# VDD 0.36279f
C73 FS a_33347_19269# 0.04188f
C74 a_5347_15489# a_6884_22960# 0.01155f
C75 a_3667_23609# ICP2 0.04359f
C76 a_29987_31589# a_35145_18820# 0.90732f
C77 a_29987_31589# a_35145_35402# 0.51811f
C78 a_35145_35402# a_36707_19269# 0.03791f
C79 a_35145_18820# a_36707_19269# 0.28529f
C80 a_41865_18820# a_33347_19269# 0.08776f
C81 a_35027_19269# a_41604_26740# 0.0102f
C82 a_42014_22680# VDD 0.34727f
C83 a_169284_15079# a_157709_14900# 0.04528f
C84 a_49434_30800# VDD 0.3476f
C85 a_14014_35280# a_13720_35340# 0.01363f
C86 a_48440_22740# a_48324_22680# 0.01552f
C87 a_3640_31140# a_3785_31140# 0.36358f
C88 FB a_31667_35929# 0.04359f
C89 a_5347_15489# a_5347_36069# 0.04432f
C90 a_179860_20020# a_174020_15139# 0.07382f
C91 a_35294_22680# a_33465_30860# 0.01207f
C92 a_16964_18900# a_3785_14900# 0.01218f
C93 a_3785_23020# PB 0.03676f
C94 a_35000_14900# a_35145_14900# 0.31947f
C95 a_31785_14900# a_40185_26800# 0.0307f
C96 a_3667_19549# a_23684_22960# 0.01153f
C97 a_12185_14900# a_5465_14900# 0.05505f
C98 a_5347_31869# a_3667_23609# 0.03791f
C99 a_31667_23329# a_45374_26740# 0.02312f
C100 a_35145_35402# a_31667_15349# 0.03489f
C101 a_10360_35340# a_12334_35280# 0.02878f
C102 a_31667_27389# a_29987_19269# 0.25854f
C103 a_5347_31869# a_13865_14900# 0.04223f
C104 ICP2 a_3785_18960# 0.04359f
C105 a_31667_27389# ICP2 0.08035f
C106 VDD a_10794_3220# 1.08855f
C107 a_8680_35340# a_8974_35280# 0.01038f
C108 VCTRL VDD 0.5574f
C109 a_31667_27389# a_30105_26800# 0.21922f
C110 a_41747_19269# a_48324_26740# 0.01005f
C111 a_174734_22462# a_167229_16189# 0.01247f
C112 a_35145_18820# PB 0.02484f
C113 a_35145_35402# PB 0.03167f
C114 a_8704_3220# a_9114_3220# 0.02581f
C115 a_38360_18820# a_30105_14900# 0.0739f
C116 a_170180_15079# VDD 0.57888f
C117 NB VCTRL 0.5954f
C118 a_12064_3220# a_12474_3220# 0.0129f
C119 a_11924_18900# VDD 0.3627f
C120 a_35145_14900# VDD 4.01908f
C121 a_24094_18900# a_3785_14900# 0.01998f
C122 a_35000_18820# a_36974_18760# 0.01542f
C123 a_22120_31140# a_3785_18960# 0.08298f
C124 a_38505_18820# a_44964_35342# 0.01309f
C125 a_35294_26740# a_35145_26800# 0.02689f
C126 FB a_31785_35060# 0.14203f
C127 a_8680_31140# a_10654_31080# 0.02878f
C128 NB a_35145_14900# 0.0354f
C129 a_10654_18900# a_8680_18960# 0.01988f
C130 a_38505_18820# a_31785_18820# 0.13282f
C131 ICP2 a_3785_35340# 0.04359f
C132 a_3667_27669# a_3785_31140# 0.03841f
C133 a_22004_35280# a_20440_35340# 0.01133f
C134 a_3785_23020# a_3785_14900# 0.04223f
C135 VDD a_41604_35000# 0.49565f
C136 FB a_5465_14900# 0.08232f
C137 a_35145_14900# a_29987_15349# 0.02384f
C138 a_17374_22960# VDD 0.34967f
C139 VDD a_10384_3220# 1.15562f
C140 a_29987_23329# FB 0.12125f
C141 a_5347_31869# a_3785_18960# 0.31501f
C142 a_8825_35340# a_3785_31140# 1.30786f
C143 a_22120_31140# a_3785_35340# 0.08041f
C144 a_5347_36069# a_3640_35340# 0.05656f
C145 a_8564_35280# a_8680_35340# 0.02888f
C146 a_41865_18820# a_42014_18760# 0.01937f
C147 a_35145_18820# a_30105_18820# 0.03103f
C148 a_23684_18900# a_3785_14900# 0.01198f
C149 a_8825_35340# PB 0.03676f
C150 a_41747_19269# a_33465_35060# 0.04223f
C151 a_31785_22740# a_31667_23329# 0.25041f
C152 a_3934_35280# a_3640_35340# 0.01038f
C153 a_15400_35340# a_16964_35280# 0.01082f
C154 a_29987_31589# a_38505_18820# 0.03167f
C155 a_5347_31869# a_3785_35340# 0.04223f
C156 a_12185_14900# a_5347_15489# 0.10859f
C157 a_8680_35340# a_3785_35340# 0.09258f
C158 a_31667_23329# a_35145_26800# 0.03428f
C159 a_36707_19269# a_38505_18820# 0.91718f
C160 a_31524_26740# a_29987_19269# 0.01041f
C161 a_31785_22740# a_35027_19269# 0.02568f
C162 VDD a_29987_19269# 3.14486f
C163 a_16964_22960# VDD 0.36279f
C164 ICP2 VDD 2.32414f
C165 a_15694_14840# VDD 0.3476f
C166 VDD a_30105_26800# 2.42309f
C167 a_31524_14840# a_31640_14900# 0.01552f
C168 NB a_29987_19269# 0.03851f
C169 FS VCTRL 0.46794f
C170 ICP2 NB 0.17031f
C171 a_35145_14900# a_33465_30860# 1.09907f
C172 a_3667_27669# a_3785_14900# 0.04359f
C173 FB a_149000_15084# 9.53188f
C174 NB a_30105_26800# 0.02994f
C175 a_35027_19269# a_35145_26800# 0.17444f
C176 VDD a_20734_18900# 0.34888f
C177 a_42014_35000# a_31785_18820# 0.03143f
C178 a_33465_26800# a_34884_26740# 0.02763f
C179 a_3667_23609# a_3785_23020# 0.16447f
C180 FB a_33347_19269# 0.0931f
C181 a_29987_15349# a_29987_19269# 0.85096f
C182 a_18644_35280# a_18760_35340# 0.02888f
C183 a_5347_31869# a_7294_31080# 0.01066f
C184 a_23114_1462# VDD 0.21432f
C185 a_13865_14900# a_3785_23020# 0.03791f
C186 a_30105_26800# a_29987_15349# 0.04457f
C187 a_31667_23329# a_31667_35929# 0.04283f
C188 FB a_5347_15489# 0.97371f
C189 a_38505_18820# a_31667_15349# 0.97566f
C190 a_22704_1462# VDD 0.22416f
C191 a_3934_14840# a_3785_14900# 0.02481f
C192 a_5347_31869# VDD 3.68948f
C193 a_38505_18820# PB 0.0317f
C194 a_36707_19269# a_40185_26800# 0.02563f
C195 FB a_43694_31142# 0.01149f
C196 a_174020_15139# a_174309_15139# 0.59522f
C197 a_170180_15079# a_157709_14900# 0.04246f
C198 a_45080_22740# a_30105_26800# 0.28201f
C199 a_5347_31869# NB 0.04131f
C200 a_174309_15139# a_176840_14840# 0.05081f
C201 a_35027_19269# a_42014_26740# 0.02094f
C202 VDD a_36974_22680# 0.34666f
C203 a_33465_26800# a_33614_26740# 0.02332f
C204 a_166745_22522# a_167229_16189# 0.36512f
C205 a_10244_14840# VDD 0.36279f
C206 a_12334_27020# VDD 0.34827f
C207 a_30254_26740# VDD 0.34678f
C208 a_3785_23020# a_3785_18960# 0.11731f
C209 a_3667_19549# a_3667_36069# 0.04457f
C210 a_17080_27080# a_13865_23020# 0.07788f
C211 a_41720_18820# a_31667_23329# 0.02516f
C212 a_31667_23329# a_31785_35060# 0.09427f
C213 a_33465_30860# a_29987_19269# 0.08593f
C214 a_3934_31080# a_3785_31140# 0.03448f
C215 FB a_13865_23020# 0.10264f
C216 a_3667_27669# a_3667_23609# 0.03593f
C217 a_33465_30860# a_30105_26800# 0.38677f
C218 a_35000_14900# a_36974_14840# 0.01542f
C219 a_176414_22120# a_167229_16189# 0.02404f
C220 a_17374_18900# a_3785_14900# 0.01133f
C221 a_23684_27020# a_3785_35340# 0.01157f
C222 a_35000_18820# a_35145_14900# 0.0827f
C223 FS ICP2 0.03776f
C224 a_12185_14900# a_12334_31422# 0.01732f
C225 a_3667_27669# a_13865_14900# 0.03849f
C226 a_174020_15139# a_173760_15079# 0.09314f
C227 a_30105_18820# a_38505_18820# 0.03234f
C228 a_29987_31589# a_31785_14900# 0.14523f
C229 FS a_30105_26800# 0.03791f
C230 a_31667_27389# a_35145_35402# 0.06432f
C231 a_35145_18820# a_31667_27389# 0.16916f
C232 a_31785_14900# a_36707_19269# 0.03557f
C233 a_3667_23609# a_8825_35340# 0.17024f
C234 a_35027_19269# a_31785_35060# 0.03234f
C235 a_29987_23329# a_31667_23329# 2.69792f
C236 a_31667_27389# a_38654_35342# 0.01123f
C237 a_3785_23020# a_3785_35340# 1.51366f
C238 a_8680_35340# a_10244_35280# 0.01745f
C239 a_41865_18820# ICP2 0.04359f
C240 a_184964_14840# a_169869_15139# 0.01129f
C241 a_8825_35340# a_8974_35280# 0.03409f
C242 a_13865_14900# a_8825_35340# 0.07378f
C243 a_41865_18820# a_30105_26800# 0.04545f
C244 VDD a_36825_22740# 0.56812f
C245 a_8974_14840# VDD 0.34967f
C246 a_13604_14840# VDD 0.36495f
C247 a_11924_27020# VDD 0.36272f
C248 a_29844_26740# VDD 0.36665f
C249 ICP2 a_5347_36069# 0.04359f
C250 a_51684_26740# VDD 0.36279f
C251 VDD a_52094_35000# 0.47673f
C252 a_35027_19269# a_29987_23329# 0.03204f
C253 a_30105_22740# a_29987_19269# 0.07597f
C254 a_8704_3220# a_7180_3464# 0.01817f
C255 a_31640_18820# a_30105_14900# 0.07102f
C256 a_3667_27669# a_3785_18960# 0.04359f
C257 FB a_42014_22680# 0.02332f
C258 a_46644_35000# VDD 0.49577f
C259 a_10654_14840# a_5465_14900# 0.0228f
C260 a_31934_26740# VDD 0.34827f
C261 a_172420_15079# a_167305_14900# 0.04246f
C262 a_17374_14840# VDD 0.35048f
C263 a_8825_35340# a_14014_27020# 0.02077f
C264 a_24094_18900# VDD 0.35048f
C265 a_31785_14900# a_31667_15349# 0.21937f
C266 a_3667_19549# a_19054_35280# 0.03479f
C267 a_167305_14900# a_167229_16189# 0.27448f
C268 a_33465_35060# a_33614_35000# 0.0476f
C269 a_12334_14840# VDD 0.34678f
C270 a_41720_18820# a_30105_14900# 0.07609f
C271 a_31785_14900# PB 0.03849f
C272 a_5204_35280# a_3640_35340# 0.01745f
C273 a_15545_14900# PB 0.04198f
C274 a_31785_22740# a_33465_35060# 0.02141f
C275 a_3785_23020# VDD 0.78396f
C276 a_38244_26740# VDD 0.36272f
C277 a_50414_26740# VDD 0.34888f
C278 a_5347_31869# a_5347_36069# 0.04432f
C279 a_3667_27669# a_3785_35340# 0.72088f
C280 a_8680_35340# a_5347_36069# 0.19847f
C281 a_31667_23329# a_33347_19269# 0.16921f
C282 a_3785_23020# NB 0.03649f
C283 a_33465_35060# a_35145_26800# 0.05871f
C284 a_21167_1909# a_17807_1769# 0.18278f
C285 a_31785_22740# a_41747_19269# 0.03234f
C286 a_3667_19549# a_15400_18960# 0.0292f
C287 a_13865_14900# a_15284_14840# 0.01304f
C288 a_35294_31142# a_31667_35929# 0.01872f
C289 a_44964_18760# a_45080_18820# 0.01552f
C290 a_29987_23329# a_30105_14900# 0.03167f
C291 a_29987_31589# a_45080_18820# 0.31947f
C292 a_8825_35340# a_3785_35340# 1.69412f
C293 a_16964_14840# VDD 0.36295f
C294 a_35145_18820# VDD 2.35099f
C295 a_29987_31589# a_31785_18820# 0.04331f
C296 a_171524_15079# a_167305_14900# 0.04731f
C297 a_23684_18900# VDD 0.36279f
C298 a_35145_35402# VDD 1.17876f
C299 a_33465_30860# a_36825_22740# 0.28706f
C300 a_40334_31142# a_31667_15349# 0.01149f
C301 a_35027_19269# a_33347_19269# 0.07143f
C302 a_13720_23020# a_13865_23020# 0.39347f
C303 a_41747_19269# a_35145_26800# 0.13258f
C304 a_36707_19269# a_31785_18820# 0.20545f
C305 VDD a_22414_27020# 0.34888f
C306 a_35145_18820# NB 0.02994f
C307 VDD a_36564_35000# 0.49872f
C308 a_22004_31080# a_3667_36069# 0.01202f
C309 FB a_35145_14900# 0.14324f
C310 a_35145_35402# NB 0.03676f
C311 LO a_7180_3464# 2.55018f
C312 a_31785_14900# a_30105_18820# 0.0347f
C313 a_35145_18820# a_29987_15349# 0.85153f
C314 a_13604_18900# VDD 0.3627f
C315 a_36974_26740# VDD 0.34827f
C316 a_3667_23609# a_8564_22960# 0.01193f
C317 a_46905_26800# VDD 0.54348f
C318 a_15545_14900# a_3785_14900# 0.03794f
C319 a_5347_31869# a_7000_31140# 0.08135f
C320 a_33465_26800# VDD 0.57408f
C321 a_34884_22680# VDD 0.36665f
C322 a_13865_14900# a_14014_14840# 0.02648f
C323 a_3667_27669# VDD 4.61533f
C324 a_18760_35340# a_20324_35280# 0.01745f
C325 a_31667_27389# a_38505_18820# 0.53444f
C326 a_19487_1769# VDD 0.17932f
C327 a_50414_35342# a_41747_19269# 0.01149f
C328 a_31667_15349# a_31785_18820# 1.62423f
C329 a_35145_35402# a_45080_22740# 0.02533f
C330 a_29987_31589# a_36707_19269# 0.03792f
C331 a_8825_35340# VDD 3.71492f
C332 a_33465_26800# a_29987_15349# 0.03064f
C333 a_5614_14840# a_5465_14900# 0.02496f
C334 VDD a_44964_26740# 0.36434f
C335 a_166745_22522# a_167305_14900# 0.25245f
C336 PB a_31785_18820# 0.04363f
C337 a_180040_14900# a_181821_20080# 0.73072f
C338 a_8825_35340# NB 0.07737f
C339 a_12334_18900# VDD 0.34827f
C340 a_5347_31869# a_8680_18960# 0.27173f
C341 a_46644_26740# VDD 0.36505f
C342 a_3934_14840# VDD 0.34678f
C343 a_51684_22680# a_30105_18820# 0.02013f
C344 a_31785_35060# a_33465_35060# 0.03473f
C345 a_33204_26740# VDD 0.36444f
C346 a_5347_31869# a_12185_14900# 0.04223f
C347 a_5204_22960# VDD 0.36631f
C348 a_35145_18820# a_33465_30860# 0.0313f
C349 FB a_29987_19269# 0.04369f
C350 FB ICP2 0.12394f
C351 FB a_30105_26800# 0.07308f
C352 a_35145_35402# a_33465_30860# 0.16796f
C353 a_33614_22680# VDD 0.34967f
C354 a_156760_14840# VDD 3.38049f
C355 a_41865_18820# a_50414_26740# 0.0264f
C356 a_18760_35340# a_3785_31140# 0.09068f
C357 a_35145_18820# FS 0.03676f
C358 a_174020_15139# VDD 0.77093f
C359 a_3667_19549# a_5465_14900# 0.03557f
C360 a_41747_19269# a_41720_18820# 0.03205f
C361 a_35145_35402# FS 0.05835f
C362 a_3785_23020# a_5347_36069# 0.04433f
C363 a_29987_31589# a_31667_15349# 0.05631f
C364 a_41747_19269# a_31785_35060# 0.02354f
C365 VDD a_176840_14840# 1.21283f
C366 a_36707_19269# a_31667_15349# 0.06278f
C367 a_166745_22522# a_168574_22120# 0.02236f
C368 a_5320_14900# a_5465_14900# 0.39434f
C369 a_29987_23329# a_33465_35060# 0.03808f
C370 NB a_174020_15139# 0.83566f
C371 a_167305_14900# a_167940_14840# 0.01443f
C372 a_15545_14900# a_13865_14900# 0.06497f
C373 a_35145_35402# a_41865_18820# 0.07027f
C374 a_35145_18820# a_41865_18820# 0.02935f
C375 a_19754_1120# a_5347_36069# 0.02312f
C376 a_33614_22680# a_29987_15349# 0.02197f
C377 a_29987_31589# PB 0.03168f
C378 a_30105_18820# a_31785_18820# 0.05464f
C379 a_36707_19269# PB 0.03853f
C380 a_33465_26800# a_33465_30860# 0.03647f
C381 a_20324_27020# VDD 0.3627f
C382 a_29987_23329# a_41747_19269# 0.03234f
C383 a_46905_26800# FS 0.0307f
C384 LO REFCK 0.35714f
C385 a_5614_31080# a_3640_31140# 0.02878f
C386 a_22120_31140# a_24094_31080# 0.01988f
C387 a_5347_31869# FB 0.46164f
C388 VDD a_15284_14840# 0.36495f
C389 a_38505_18820# VDD 2.94614f
C390 a_10244_31080# a_8680_31140# 0.01037f
C391 a_180334_14840# a_180040_14900# 0.01069f
C392 VDD a_40334_26740# 0.34727f
C393 NB a_38505_18820# 0.03676f
C394 a_14014_18900# VDD 0.34827f
C395 FS a_185512_20020# 0.03494f
C396 a_13604_14840# a_12185_14900# 0.01071f
C397 a_35145_35402# a_51114_30800# 0.0199f
C398 a_184964_14840# a_183400_14900# 0.02452f
C399 a_31785_18820# a_39924_35342# 0.01114f
C400 a_6760_3464# VDD 1.8318f
C401 a_15545_14900# a_3785_18960# 0.03754f
C402 a_38505_18820# a_29987_15349# 0.0551f
C403 a_31667_23329# a_35145_14900# 0.25821f
C404 a_41720_18820# a_43694_18760# 0.01542f
C405 PB a_31667_15349# 0.03167f
C406 a_29987_31589# a_30105_18820# 0.0366f
C407 a_3667_27669# a_5347_36069# 0.60545f
C408 a_35145_18820# a_35000_18820# 0.27297f
C409 a_36707_19269# a_30105_18820# 0.03791f
C410 a_29987_23329# a_30254_35000# 0.01315f
C411 a_33465_35060# a_33347_19269# 0.07073f
C412 a_8564_22960# VDD 0.36281f
C413 a_19487_1769# a_5347_36069# 0.1184f
C414 VDD a_14014_14840# 0.34678f
C415 a_21167_1909# a_21024_1462# 0.01029f
C416 a_3667_19549# a_5347_15489# 0.20176f
C417 a_35027_19269# a_35145_14900# 1.01633f
C418 a_8825_35340# a_5347_36069# 0.13268f
C419 a_179924_14840# a_180040_14900# 0.01998f
C420 VDD a_40185_26800# 0.56868f
C421 a_15545_14900# a_3785_35340# 0.03582f
C422 a_41747_19269# a_33347_19269# 0.64065f
C423 FS a_174020_15139# 0.0724f
C424 a_5320_14900# a_5347_15489# 0.05272f
C425 a_12334_14840# a_12185_14900# 0.02648f
C426 a_35145_35402# a_50704_30800# 0.01063f
C427 a_3785_23020# a_12185_14900# 0.03791f
C428 a_10360_35340# a_8680_35340# 0.2601f
C429 a_183694_14840# a_183400_14900# 0.01069f
C430 a_33614_14840# a_31640_14900# 0.01542f
C431 a_34884_18760# a_35000_18820# 0.01552f
C432 a_14014_22960# a_13865_23020# 0.02496f
C433 VDD a_42014_35000# 0.47317f
C434 a_30105_18820# a_31667_15349# 0.02928f
C435 a_31785_14900# a_35000_14900# 0.04745f
C436 a_38505_18820# a_33465_30860# 0.02657f
C437 a_5465_14900# a_3667_36069# 0.04519f
C438 a_3667_19549# a_22414_22960# 0.02377f
C439 a_7294_22960# VDD 0.34967f
C440 REFCK a_7180_3464# 0.10418f
C441 a_3667_19549# a_13865_23020# 0.60938f
C442 a_3785_14900# PB 0.04359f
C443 ICP2 a_31667_23329# 0.04359f
C444 a_31667_27389# a_49285_30860# 0.06982f
C445 a_31667_23329# a_30105_26800# 0.06849f
C446 VDD a_31934_35000# 0.58373f
C447 a_174020_15139# a_175376_15079# 0.11329f
C448 a_35145_14900# a_30105_14900# 0.03204f
C449 a_172420_15079# VDD 0.58135f
C450 a_18760_35340# a_20440_35340# 0.26266f
C451 a_31785_14900# VDD 2.65039f
C452 a_3785_23020# a_17080_27080# 0.03671f
C453 a_5347_31869# a_13720_23020# 0.08086f
C454 a_3524_14840# VDD 0.36665f
C455 a_3785_23020# FB 0.84568f
C456 a_20324_35280# a_20440_35340# 0.02865f
C457 a_15545_14900# VDD 2.04999f
C458 a_167229_16189# VDD 2.96874f
C459 a_31667_27389# a_31785_18820# 0.32764f
C460 a_31667_35929# a_35145_26800# 0.10785f
C461 a_35027_19269# ICP2 0.03676f
C462 FB a_3640_31140# 0.13662f
C463 a_31785_14900# NB 0.0354f
C464 a_35027_19269# a_30105_26800# 1.64713f
C465 a_15545_14900# NB 0.04198f
C466 a_36707_19269# a_43694_35342# 0.01149f
C467 a_6884_35280# a_5320_35340# 0.01082f
C468 a_3667_19549# a_22004_22960# 0.01351f
C469 a_3667_27669# a_12185_14900# 0.07558f
C470 a_31785_14900# a_29987_15349# 0.02971f
C471 a_35145_35402# FB 0.10773f
C472 a_35145_18820# FB 0.91368f
C473 a_31667_27389# a_36974_35000# 0.03505f
C474 a_180040_14900# a_169869_15139# 0.31429f
C475 a_19054_22960# a_13865_23020# 0.0228f
C476 a_31934_22680# VDD 0.34055f
C477 a_8825_35340# a_12185_14900# 0.03124f
C478 a_31785_22740# a_31785_35060# 0.02148f
C479 a_171524_15079# VDD 0.57888f
C480 a_3667_23609# a_3785_31140# 0.04499f
C481 a_5320_35340# a_5614_35280# 0.01363f
C482 VDD a_33614_30800# 0.47168f
C483 a_3785_31140# a_20440_35340# 0.09113f
C484 a_29987_31589# a_31667_27389# 0.06727f
C485 a_31785_35060# a_35145_26800# 0.03805f
C486 VDD a_20734_14840# 0.3476f
C487 a_3667_23609# PB 0.04359f
C488 a_3667_36069# a_5347_15489# 0.03933f
C489 a_3667_27669# a_17080_27080# 0.18872f
C490 a_31785_22740# a_29987_23329# 0.06794f
C491 a_13865_14900# PB 0.04359f
C492 a_3667_27669# FB 0.22493f
C493 a_42014_30800# a_35145_14900# 0.03446f
C494 VDD a_49285_30860# 0.59602f
C495 a_29987_23329# a_35145_26800# 0.06743f
C496 a_18644_22960# a_13865_23020# 0.01259f
C497 a_31785_14900# a_33465_30860# 0.25872f
C498 a_8825_35340# a_17080_27080# 0.04869f
C499 a_8825_35340# FB 0.15191f
C500 a_33465_30860# a_34884_31142# 0.01292f
C501 a_167229_16189# a_158721_14900# 0.27097f
C502 VDD a_31785_18820# 3.49782f
C503 a_31667_23329# a_36825_22740# 0.02002f
C504 a_3785_31140# a_3785_18960# 0.29336f
C505 FS a_167229_16189# 0.04359f
C506 a_31785_35060# a_31667_35929# 1.48586f
C507 NB a_31785_18820# 0.04198f
C508 a_166745_22522# VDD 2.39422f
C509 a_13865_23020# a_3667_36069# 0.04457f
C510 a_3667_27669# a_16964_27020# 0.01025f
C511 a_3667_23609# a_3785_14900# 0.04575f
C512 a_3785_18960# PB 0.08035f
C513 a_31667_27389# PB 0.03814f
C514 a_41604_30800# a_35145_14900# 0.01385f
C515 a_45080_18820# a_29987_15349# 0.05263f
C516 VDD a_36974_35000# 0.47301f
C517 a_29987_15349# a_31785_18820# 0.16369f
C518 a_38244_22680# a_36825_22740# 0.02412f
C519 a_35145_18820# a_35294_18760# 0.01937f
C520 a_13865_14900# a_3785_14900# 0.03849f
C521 a_3785_14900# a_20324_18900# 0.01189f
C522 a_29987_23329# a_31667_35929# 0.92949f
C523 a_176414_22120# VDD 0.34888f
C524 a_52094_18760# a_33465_30860# 0.01542f
C525 a_3785_31140# a_3785_35340# 0.86964f
C526 a_31785_22740# a_33347_19269# 0.03124f
C527 a_3667_36069# a_3640_35340# 0.08183f
C528 a_33465_30860# a_33614_30800# 0.03383f
C529 a_19054_35280# a_5347_15489# 0.01066f
C530 a_3667_27669# a_10360_35340# 0.09694f
C531 a_29987_31589# VDD 3.11002f
C532 a_31524_18760# a_31640_18820# 0.01552f
C533 PB a_3785_35340# 0.04359f
C534 a_33347_19269# a_35145_26800# 0.19125f
C535 a_36707_19269# VDD 3.14354f
C536 a_167940_14840# VDD 0.8306f
C537 a_3667_23609# a_12334_22960# 0.0227f
C538 a_29987_31589# NB 0.03676f
C539 a_10360_35340# a_8825_35340# 0.06658f
C540 a_10654_35280# a_8680_35340# 0.02878f
C541 a_176004_22120# VDD 0.36282f
C542 a_36707_19269# NB 0.03851f
C543 a_13865_14900# a_14014_31422# 0.01732f
C544 FB a_38505_18820# 0.09407f
C545 a_35145_26800# a_40334_35342# 0.01226f
C546 a_29987_31589# a_29987_15349# 0.14173f
C547 a_5320_14900# a_7294_14840# 0.01988f
C548 a_3785_18960# a_3785_14900# 0.57285f
C549 a_3667_19549# ICP2 0.04359f
C550 a_29987_23329# a_31785_35060# 0.06632f
C551 ICP2 a_33465_35060# 0.02994f
C552 a_36707_19269# a_29987_15349# 0.01627f
C553 a_29987_19269# a_33465_35060# 0.02023f
C554 a_30105_26800# a_33465_35060# 0.08624f
C555 a_5320_35340# a_3640_35340# 0.26266f
C556 FS a_179860_20020# 0.03494f
C557 a_33465_30860# a_31785_18820# 0.03312f
C558 a_35145_35402# a_31667_23329# 0.1383f
C559 a_35145_18820# a_31667_23329# 0.12021f
C560 a_51684_35000# VDD 0.49942f
C561 a_48734_18760# a_29987_15349# 0.01547f
C562 a_41865_18820# a_49285_30860# 0.01749f
C563 a_31667_35929# a_33347_19269# 0.03546f
C564 VDD a_33204_35000# 0.63738f
C565 a_19054_27020# a_17080_27080# 0.01988f
C566 a_3785_31140# VDD 0.23364f
C567 a_41747_19269# ICP2 0.04359f
C568 a_167305_14900# VDD 0.75106f
C569 VDD a_31667_15349# 1.21259f
C570 a_41747_19269# a_30105_26800# 0.22372f
C571 a_29987_31589# a_45080_22740# 0.08119f
C572 a_35145_35402# a_35027_19269# 0.03234f
C573 a_35145_18820# a_35027_19269# 0.23673f
C574 a_41604_22680# VDD 0.36434f
C575 a_3785_14900# a_3785_35340# 0.04972f
C576 a_29844_35000# VDD 0.63738f
C577 NB a_31667_15349# 0.03516f
C578 a_166745_22522# FS 0.04359f
C579 a_46905_26800# a_31667_23329# 0.02221f
C580 a_41865_18820# a_45080_18820# 0.18895f
C581 PB VDD 22.8568f
C582 a_31785_14900# a_40334_22680# 0.02148f
C583 a_31640_18820# a_33347_19269# 0.046f
C584 NB PB 0.16614f
C585 a_29987_15349# a_31667_15349# 0.17226f
C586 a_13720_23020# a_15694_22960# 0.01988f
C587 a_3667_19549# a_5347_31869# 0.86262f
C588 a_181821_20080# a_183400_14900# 0.32925f
C589 a_29987_31589# a_33465_30860# 0.27618f
C590 PB a_29987_15349# 0.04208f
C591 a_36707_19269# a_33465_30860# 0.03339f
C592 a_168574_22120# VDD 0.34888f
C593 a_33204_22680# VDD 0.36374f
C594 a_48440_18820# a_29987_15349# 0.1626f
C595 a_167940_14840# a_158721_14900# 0.06035f
C596 a_29987_31589# FS 0.17182f
C597 a_3785_14900# a_7294_31080# 0.02878f
C598 a_31785_35060# a_33347_19269# 0.03896f
C599 a_166745_22522# a_157709_14900# 0.139f
C600 a_3667_23609# a_3785_18960# 0.13675f
C601 a_35294_22680# a_31667_35929# 0.0241f
C602 VDD a_174309_15139# 3.44152f
C603 a_13865_14900# a_3785_18960# 0.03791f
C604 a_29987_31589# a_41865_18820# 0.36404f
C605 a_30105_18820# VDD 0.54909f
C606 a_48440_22740# a_50414_22680# 0.01542f
C607 a_3667_23609# a_10244_22960# 0.01113f
C608 a_7294_18900# a_3785_18960# 0.02251f
C609 a_33204_22680# a_29987_15349# 0.0113f
C610 a_3785_14900# VDD 4.50357f
C611 a_181604_14840# a_180040_14900# 0.02581f
C612 a_38505_18820# a_47054_35000# 0.03216f
C613 a_29987_23329# a_33347_19269# 0.82193f
C614 a_24094_22960# VDD 0.35048f
C615 a_5465_14900# a_5347_15489# 0.64139f
C616 a_13604_35280# a_13720_35340# 0.02888f
C617 NB a_3785_14900# 0.03851f
C618 a_22414_31080# a_3667_36069# 0.01993f
C619 a_3667_23609# a_3785_35340# 0.09535f
C620 VDD a_34884_26740# 0.33892f
C621 a_31785_14900# FB 0.04359f
C622 a_33465_30860# a_31667_15349# 0.18547f
C623 a_15545_14900# FB 0.08455f
C624 a_50704_30800# a_49285_30860# 0.02412f
C625 a_168164_22120# VDD 0.36282f
C626 a_13865_14900# a_3785_35340# 0.03791f
C627 a_30105_18820# a_29987_15349# 0.09992f
C628 a_167305_14900# a_158721_14900# 1.49619f
C629 a_45374_35342# a_38505_18820# 0.01101f
C630 a_33465_30860# PB 0.04208f
C631 a_12334_22960# VDD 0.35048f
C632 ICP2 a_3667_36069# 0.0412f
C633 PB a_158721_14900# 2.77883f
C634 a_8974_27020# a_3785_35340# 0.02469f
C635 a_181821_20080# ICP2 0.13795f
C636 FS PB 0.08208f
C637 a_3524_35280# a_3640_35340# 0.02888f
C638 a_31785_22740# a_35145_14900# 0.02823f
C639 a_31667_23329# a_38505_18820# 0.13485f
C640 a_24384_1462# a_17807_1769# 0.01284f
C641 a_41865_18820# PB 0.03812f
C642 a_3785_31140# a_5347_36069# 0.04377f
C643 a_36707_19269# a_35000_18820# 0.046f
C644 a_22120_31140# a_3667_36069# 0.18791f
C645 a_41865_18820# a_48440_18820# 0.12132f
C646 VDD a_33614_26740# 0.34666f
C647 a_22120_31140# a_22004_31080# 0.01998f
C648 a_35145_14900# a_35145_26800# 0.1297f
C649 a_167044_14840# VDD 0.8306f
C650 a_46905_26800# a_48324_26740# 0.02419f
C651 a_21434_1462# a_21167_1909# 0.01727f
C652 a_3785_18960# a_3785_35340# 0.30746f
C653 PB a_5347_36069# 0.04359f
C654 a_167305_14900# a_157709_14900# 0.46348f
C655 a_35027_19269# a_38505_18820# 0.2719f
C656 a_3667_23609# VDD 3.09402f
C657 a_8564_35280# a_3785_35340# 0.0124f
C658 a_11924_35280# a_10360_35340# 0.01133f
C659 a_30105_18820# a_33465_30860# 0.04165f
C660 a_3667_19549# a_3785_23020# 0.04223f
C661 PB a_157709_14900# 2.85483f
C662 a_13865_14900# VDD 2.48856f
C663 a_8564_27020# a_3785_35340# 0.01254f
C664 VDD a_20324_18900# 0.3627f
C665 a_5347_31869# a_3667_36069# 0.06203f
C666 a_3667_23609# NB 0.10278f
C667 a_7294_18900# VDD 0.34827f
C668 a_20324_22960# VDD 0.36279f
C669 a_13865_14900# NB 0.04359f
C670 FS a_30105_18820# 0.03123f
C671 VDD a_8974_27020# 0.34967f
C672 a_23114_1462# a_17807_1769# 0.01772f
C673 a_30254_31142# a_29987_23329# 0.01732f
C674 a_33204_30800# VDD 0.49874f
C675 a_35145_35402# a_33465_35060# 0.12657f
C676 a_41865_18820# a_30105_18820# 0.04043f
C677 a_35145_18820# a_33465_35060# 0.07624f
C678 VDD a_18074_1120# 0.34678f
C679 a_35145_14900# a_31667_35929# 0.03969f
C680 FB a_31785_18820# 0.3402f
C681 VDD a_5614_22960# 0.3476f
C682 a_165448_14840# VDD 3.38049f
C683 a_46905_26800# a_47054_26740# 0.02332f
C684 a_5614_27020# a_3785_35340# 0.01087f
C685 VDD a_14014_27020# 0.34827f
C686 a_31785_22740# a_29987_19269# 0.07875f
C687 a_5614_35280# a_3640_35340# 0.02882f
C688 a_182014_14840# a_169869_15139# 0.02088f
C689 a_15400_35340# a_17374_35280# 0.02878f
C690 a_31785_22740# a_30105_26800# 0.05878f
C691 a_35145_35402# a_41747_19269# 0.07927f
C692 a_35145_18820# a_41747_19269# 1.54227f
C693 a_3785_14900# a_5347_36069# 0.04432f
C694 a_181821_20080# a_187216_14840# 0.02301f
C695 a_3667_23609# a_14014_35280# 0.02878f
C696 a_3785_18960# VDD 4.98846f
C697 a_35027_19269# a_40185_26800# 0.26748f
C698 a_31667_27389# VDD 3.9099f
C699 a_15284_35280# a_13720_35340# 0.01686f
C700 a_174309_15139# a_175376_15079# 0.03188f
C701 a_29987_19269# a_35145_26800# 0.02753f
C702 a_29987_23329# a_31640_14900# 0.02516f
C703 ICP2 a_35145_26800# 0.04359f
C704 a_30105_26800# a_35145_26800# 0.13331f
C705 NB a_3785_18960# 0.07528f
C706 a_31667_27389# NB 0.04322f
C707 a_5204_14840# a_5320_14900# 0.01998f
C708 VDD a_10244_22960# 0.36374f
C709 a_13865_23020# a_5347_15489# 0.17122f
C710 VDD a_8564_27020# 0.36293f
C711 a_30105_35060# VDD 0.90135f
C712 a_3667_19549# a_3667_27669# 0.03072f
C713 a_18760_35340# FB 0.13141f
C714 VDD a_17664_1120# 0.36665f
C715 a_13720_35340# a_5347_15489# 0.15071f
C716 a_41747_19269# a_46905_26800# 0.28744f
C717 a_31785_35060# a_35145_14900# 0.0785f
C718 a_29987_31589# FB 0.22666f
C719 a_167044_14840# a_158721_14900# 0.06347f
C720 FB a_20324_35280# 0.01154f
C721 a_36707_19269# FB 0.16812f
C722 VDD a_3785_35340# 4.75813f
C723 a_31785_14900# a_31667_23329# 0.05165f
C724 a_3667_19549# a_8825_35340# 0.04212f
C725 a_181604_14840# a_169869_15139# 0.01197f
C726 a_38244_18760# a_38360_18820# 0.01552f
C727 a_12185_14900# PB 0.04359f
C728 a_170180_15079# a_169869_15139# 0.01476f
C729 NB a_3785_35340# 0.03357f
C730 a_45374_22680# a_30105_26800# 0.01901f
C731 a_5614_27020# VDD 0.34967f
C732 a_169869_15139# a_183400_14900# 0.24865f
C733 a_181821_20080# a_186644_14840# 0.02282f
C734 a_35145_18820# a_38360_18820# 0.06711f
C735 a_3785_14900# a_7000_31140# 0.23634f
C736 ICP2 a_31667_35929# 0.02994f
C737 a_31667_35929# a_29987_19269# 0.11194f
C738 a_29987_23329# a_35145_14900# 0.35225f
C739 a_5614_18900# a_3785_18960# 0.02312f
C740 a_30105_26800# a_31667_35929# 0.08017f
C741 a_3667_19549# a_15694_22960# 0.01189f
C742 a_31785_14900# a_35027_19269# 0.03791f
C743 a_3667_23609# a_5347_36069# 0.11032f
C744 a_22414_35280# a_20440_35340# 0.02878f
C745 a_31785_35060# a_38654_31142# 0.0165f
C746 FB a_3785_31140# 0.22347f
C747 a_3785_23020# a_3667_36069# 0.01744f
C748 a_31640_18820# a_29987_19269# 0.03238f
C749 a_34884_14840# a_35000_14900# 0.01552f
C750 FB a_31667_15349# 0.03676f
C751 a_3640_31140# a_3667_36069# 0.10985f
C752 a_31667_27389# a_33465_30860# 0.18283f
C753 a_8680_18960# a_3785_14900# 0.2529f
C754 FB PB 0.11165f
C755 a_149000_15084# VCTRL 0.04226f
C756 a_31524_26740# VDD 0.36343f
C757 a_19487_1769# a_21167_1909# 0.24524f
C758 a_48440_22740# a_30105_26800# 0.04249f
C759 a_5204_27020# VDD 0.36281f
C760 a_6760_3464# a_9114_3220# 0.08539f
C761 a_3785_14900# a_6884_31080# 0.01608f
C762 a_6760_3464# a_12474_3220# 0.04953f
C763 a_6760_5586# REFCK 0.06361f
C764 a_12185_14900# a_3785_14900# 0.03849f
C765 a_52094_22680# a_33347_19269# 0.01542f
C766 ICP2 a_31785_35060# 0.08035f
C767 a_31785_35060# a_29987_19269# 0.03755f
C768 a_18074_1120# a_5347_36069# 0.02755f
C769 a_31785_35060# a_30105_26800# 0.07856f
C770 NB VDD 7.59087f
C771 a_19054_18900# VDD 0.34888f
C772 a_31785_22740# a_36825_22740# 0.01308f
C773 a_38505_18820# a_33465_35060# 1.68967f
C774 a_31667_27389# a_41865_18820# 0.3237f
C775 a_31785_14900# a_30105_14900# 0.03754f
C776 a_35145_14900# a_33347_19269# 0.07528f
C777 VDD a_29987_15349# 2.67791f
C778 a_165448_14840# a_157709_14900# 0.01791f
C779 a_23684_35280# a_3785_31140# 0.03432f
C780 a_29987_23329# ICP2 0.04359f
C781 ICP2 a_169869_15139# 0.88297f
C782 a_29987_23329# a_29987_19269# 0.08565f
C783 a_29987_23329# a_30105_26800# 0.94436f
C784 a_3785_18960# a_5347_36069# 0.04432f
C785 a_15284_35280# a_15400_35340# 0.02865f
C786 a_31667_23329# a_45080_18820# 0.02802f
C787 NB a_29987_15349# 0.0354f
C788 a_31667_23329# a_31785_18820# 0.03557f
C789 a_6760_3464# a_8704_3220# 0.0187f
C790 a_52094_26740# VDD 0.35048f
C791 a_6760_3464# a_12064_3220# 0.01432f
C792 a_3667_27669# a_22004_31080# 0.0103f
C793 a_3667_27669# a_3667_36069# 0.54525f
C794 a_5614_18900# VDD 0.34827f
C795 a_15400_35340# a_5347_15489# 0.13667f
C796 a_10360_35340# a_3785_31140# 0.0737f
C797 a_18644_18900# VDD 0.3627f
C798 FB a_3785_14900# 0.08645f
C799 a_181821_20080# a_185512_20020# 0.01654f
C800 a_8825_35340# a_3667_36069# 0.04457f
C801 a_5347_36069# a_3785_35340# 0.70619f
C802 VDD a_3524_27020# 0.36665f
C803 a_20734_22960# VDD 0.34967f
C804 VDD a_3524_18900# 0.36665f
C805 a_5347_31869# a_5465_14900# 0.04835f
C806 a_3667_23609# a_12185_14900# 0.08816f
C807 VDD a_47680_30800# 0.50376f
C808 a_3785_35340# a_3934_35280# 0.03452f
C809 a_33465_30860# VDD 3.10191f
C810 ICP2 a_149000_15084# 20.7467f
C811 a_29987_31589# a_31667_23329# 0.86173f
C812 a_3785_18960# a_7000_31140# 0.13104f
C813 a_38505_18820# a_38360_18820# 0.27817f
C814 VDD a_6884_22960# 0.36281f
C815 a_13865_14900# a_12185_14900# 0.05764f
C816 a_19054_14840# VDD 0.3476f
C817 a_36707_19269# a_31667_23329# 0.03755f
C818 a_36707_19269# a_38654_26740# 0.02054f
C819 a_35145_18820# a_43694_26740# 0.02233f
C820 a_10244_14840# a_5465_14900# 0.01113f
C821 VDD a_158721_14900# 3.88546f
C822 a_35145_18820# a_31785_22740# 0.03234f
C823 a_5347_31869# a_8974_18900# 0.02322f
C824 NB a_33465_30860# 0.0354f
C825 FS VDD 2.82162f
C826 a_19487_1769# a_17807_1769# 0.62167f
C827 a_5204_18900# VDD 0.36281f
C828 a_29987_19269# a_33347_19269# 0.30754f
C829 ICP2 a_33347_19269# 0.04359f
C830 a_30105_26800# a_33347_19269# 2.35674f
C831 a_35145_18820# a_35145_26800# 0.02484f
C832 FS NB 0.37497f
C833 a_29987_31589# a_35027_19269# 0.03676f
C834 a_35145_35402# a_35145_26800# 0.06957f
C835 a_181821_20080# a_174020_15139# 0.26528f
C836 ICP2 a_5347_15489# 0.04359f
C837 a_33465_30860# a_29987_15349# 0.07705f
C838 a_35027_19269# a_36707_19269# 0.08007f
C839 a_41865_18820# VDD 2.71505f
C840 a_15400_35340# a_13720_35340# 0.2601f
C841 a_17374_22960# a_13865_23020# 0.0228f
C842 a_30105_14900# a_45080_18820# 0.07609f
C843 a_7000_31140# a_3785_35340# 0.0685f
C844 a_41865_18820# NB 0.04322f
C845 a_8680_18960# a_3785_18960# 0.02602f
C846 VDD a_5347_36069# 3.83776f
C847 a_8680_31140# a_3785_18960# 0.04198f
C848 VDD a_46784_30800# 0.50039f
C849 a_3667_23609# FB 0.7827f
C850 a_15545_14900# a_3667_19549# 0.07285f
C851 a_18644_14840# VDD 0.36569f
C852 FB a_20440_35340# 0.04198f
C853 a_31667_23329# a_31667_15349# 0.55096f
C854 NB a_5347_36069# 0.03998f
C855 a_46905_26800# a_35145_26800# 0.01154f
C856 a_30105_22740# VDD 0.60544f
C857 a_12185_14900# a_3785_18960# 0.03791f
C858 VDD a_157709_14900# 5.66529f
C859 a_13865_14900# FB 0.08555f
C860 a_41865_18820# a_29987_15349# 0.25032f
C861 a_8564_14840# VDD 0.36293f
C862 a_8974_14840# a_5465_14900# 0.0228f
C863 a_45080_22740# a_33465_30860# 0.17236f
C864 a_33465_26800# a_35145_26800# 0.10121f
C865 a_29987_23329# a_36825_22740# 0.02275f
C866 a_3667_27669# a_17374_27020# 0.02091f
C867 a_41604_26740# a_40185_26800# 0.02412f
C868 a_178456_14840# VDD 1.21522f
C869 a_8974_31080# a_7000_31140# 0.02878f
C870 a_31667_23329# PB 0.03853f
C871 a_35145_35402# a_31667_35929# 0.16457f
C872 a_51114_30800# VDD 0.34201f
C873 FS a_45080_22740# 0.03258f
C874 a_48440_18820# a_31667_23329# 0.07529f
C875 a_13604_22960# a_13720_23020# 0.01998f
C876 a_8680_31140# a_3785_35340# 0.04619f
C877 a_180040_14900# a_174020_15139# 0.12439f
C878 a_44964_22680# a_45080_22740# 0.01552f
C879 a_7294_31080# a_7000_31140# 0.0133f
C880 a_35027_19269# a_31667_15349# 0.06433f
C881 a_30254_18760# a_30105_18820# 0.01923f
C882 ICP2 a_13865_23020# 0.04359f
C883 a_5347_31869# a_5347_15489# 0.08218f
C884 a_38244_22680# a_31667_15349# 0.01011f
C885 a_29987_23329# a_51684_26740# 0.01036f
C886 a_16964_22960# a_13865_23020# 0.01113f
C887 a_30105_22740# a_29987_15349# 0.07301f
C888 VDD a_48734_26740# 0.3412f
C889 a_12185_14900# a_3785_35340# 0.03557f
C890 a_8564_31080# a_3785_18960# 0.01154f
C891 a_35027_19269# PB 0.07586f
C892 FS a_33465_30860# 0.07762f
C893 a_3667_23609# a_11924_22960# 0.01113f
C894 a_29844_22680# VDD 0.36665f
C895 a_8974_31080# a_8680_31140# 0.01363f
C896 a_3785_18960# a_3934_18900# 0.02481f
C897 FB a_3785_18960# 0.16314f
C898 a_31667_27389# FB 0.91061f
C899 a_10244_35280# a_5347_36069# 0.01229f
C900 a_3785_23020# a_5465_14900# 0.03667f
C901 a_35000_18820# a_29987_15349# 0.05423f
C902 a_41865_18820# a_33465_30860# 0.03812f
C903 a_30105_18820# a_31667_23329# 0.03139f
C904 a_50704_30800# VDD 0.33915f
C905 a_35145_18820# a_31785_35060# 0.03234f
C906 a_35145_35402# a_31785_35060# 2.4521f
C907 a_31785_14900# a_38360_18820# 0.04899f
C908 a_40334_22680# VDD 0.34827f
C909 a_5347_31869# a_13865_23020# 0.38028f
C910 a_41865_18820# FS 0.04457f
C911 a_10244_27020# a_3785_35340# 0.011f
C912 a_15400_18960# a_15284_18900# 0.01998f
C913 a_17080_27080# a_3785_35340# 0.07907f
C914 a_10384_3220# a_10794_3220# 0.02581f
C915 FB a_3785_35340# 0.16312f
C916 a_30105_14900# a_31667_15349# 0.03025f
C917 a_6760_3464# a_7180_3464# 1.32419f
C918 a_35027_19269# a_30105_18820# 0.03234f
C919 a_33465_35060# a_31785_18820# 0.54749f
C920 a_35145_35402# a_29987_23329# 0.0864f
C921 a_35145_18820# a_29987_23329# 0.02648f
C922 FS a_46784_30800# 0.01309f
C923 a_31785_22740# a_38505_18820# 0.02568f
C924 a_12185_14900# VDD 2.61906f
C925 a_46905_26800# a_31785_35060# 0.03139f
C926 a_3667_23609# a_10654_22960# 0.0228f
C927 a_157709_14900# a_158721_14900# 2.42159f
C928 a_41747_19269# a_49285_30860# 0.06629f
C929 a_23684_35280# a_3785_18960# 0.01051f
C930 a_15400_18960# a_17374_18900# 0.01988f
C931 a_48440_18820# a_30105_14900# 0.08857f
C932 NB a_12185_14900# 0.03998f
C933 a_31524_35000# a_31934_35000# 0.0129f
C934 a_183284_14840# a_183400_14900# 0.01998f
C935 a_38505_18820# a_35145_26800# 0.06985f
C936 a_13865_14900# a_13720_23020# 0.03849f
C937 a_47054_18760# a_45080_18820# 0.01542f
C938 a_39924_22680# VDD 0.36272f
C939 a_15545_14900# a_3667_36069# 0.08267f
C940 a_3667_27669# a_5465_14900# 0.08066f
C941 a_33614_18760# a_31640_18820# 0.01542f
C942 ICP2 VCTRL 0.08224f
C943 a_3667_19549# a_18760_35340# 0.25404f
C944 a_10244_27020# VDD 0.36279f
C945 VDD a_3934_27020# 0.34678f
C946 ICP2 a_183400_14900# 0.09007f
C947 VDD a_3934_18900# 0.34678f
C948 a_29987_31589# a_33465_35060# 0.25164f
C949 a_8825_35340# a_5465_14900# 0.77353f
C950 FB VDD 9.2472f
C951 a_3785_23020# a_5347_15489# 0.0995f
C952 a_35145_14900# a_30105_26800# 0.02929f
C953 a_36707_19269# a_33465_35060# 0.03586f
C954 a_30105_18820# a_30105_14900# 0.01492f
C955 a_8825_35340# a_15694_27020# 0.02286f
C956 FB NB 0.3186f
C957 a_35145_35402# a_33347_19269# 0.0735f
C958 a_35145_18820# a_33347_19269# 0.11134f
C959 a_29987_31589# a_41747_19269# 0.50154f
C960 a_3667_27669# a_20734_27020# 0.02091f
C961 a_35145_26800# a_40185_26800# 0.04202f
C962 FB a_29987_15349# 0.04359f
C963 a_36974_26740# a_33347_19269# 0.02208f
C964 a_174020_15139# a_169869_15139# 0.82541f
C965 a_46905_26800# a_33347_19269# 0.07166f
C966 a_3667_19549# a_3785_31140# 0.46888f
C967 a_33465_26800# a_33347_19269# 0.11691f
C968 a_3785_23020# a_13865_23020# 0.04223f
C969 a_11924_22960# VDD 0.36374f
C970 a_169869_15139# a_176840_14840# 0.01073f
C971 a_8825_35340# a_15284_27020# 0.0104f
C972 a_45080_22740# a_47054_22680# 0.01542f
C973 a_38505_18820# a_31785_35060# 0.11468f
C974 a_31667_27389# a_31667_23329# 0.05404f
C975 PB a_33465_35060# 0.03849f
C976 a_3667_19549# PB 0.0354f
C977 a_31785_22740# a_31785_14900# 0.04271f
C978 a_8680_31140# a_5347_36069# 0.08298f
C979 a_15284_35280# a_8825_35340# 0.01078f
C980 VDD a_20324_14840# 0.36665f
C981 a_3667_27669# a_5347_15489# 0.03849f
C982 ICP2 a_29987_19269# 0.04359f
C983 a_22120_31140# a_22414_31080# 0.01069f
C984 a_36707_19269# a_38360_18820# 0.03747f
C985 a_30105_26800# a_29987_19269# 0.1418f
C986 ICP2 a_30105_26800# 0.04359f
C987 a_12185_14900# a_5347_36069# 0.04223f
C988 a_31785_14900# a_35145_26800# 0.07649f
C989 a_41747_19269# PB 0.08956f
C990 a_31667_27389# a_35027_19269# 0.01046f
C991 a_29987_23329# a_38505_18820# 0.03234f
C992 a_38654_22680# a_31667_15349# 0.02296f
C993 a_15545_14900# a_15400_18960# 0.07106f
C994 FB a_33465_30860# 0.4318f
C995 a_8825_35340# a_5347_15489# 0.11155f
C996 VDD a_50004_26740# 0.36272f
C997 a_35294_26740# VDD 0.34042f
C998 VDD a_49024_30800# 0.36665f
C999 a_31785_22740# a_31934_22680# 0.033f
C1000 FB FS 0.07698f
C1001 a_31934_18760# a_31785_18820# 0.01937f
C1002 a_10654_22960# VDD 0.34967f
C1003 VDD a_47054_35000# 0.47465f
C1004 VDD a_39924_26740# 0.36434f
C1005 a_35294_14840# a_35145_14900# 0.01901f
C1006 a_22414_18900# a_3785_14900# 0.0264f
C1007 a_41865_18820# FB 0.07698f
C1008 a_31934_35000# a_31667_35929# 0.01171f
C1009 a_35145_14900# a_36825_22740# 0.02996f
C1010 a_8680_31140# a_7000_31140# 0.2601f
C1011 a_3667_19549# a_3785_14900# 0.3358f
C1012 a_3667_27669# a_13865_23020# 0.0361f
C1013 a_3667_19549# a_24094_22960# 0.01991f
C1014 a_29844_35000# a_30254_35000# 0.0129f
C1015 a_5320_14900# a_3785_14900# 0.03996f
C1016 FB a_5347_36069# 0.12995f
C1017 a_186644_14840# a_183400_14900# 0.0121f
C1018 a_6884_31080# a_7000_31140# 0.02888f
C1019 a_10360_35340# a_10244_35280# 0.02865f
C1020 a_41747_19269# a_30105_18820# 0.03234f
C1021 a_10654_27020# a_3785_35340# 0.02241f
C1022 a_8825_35340# a_13865_23020# 0.04212f
C1023 a_13720_35340# a_8825_35340# 0.15961f
C1024 a_31667_23329# VDD 4.59199f
C1025 a_11924_14840# VDD 0.36569f
C1026 VDD a_38654_26740# 0.34827f
C1027 a_38505_18820# a_33347_19269# 0.18367f
C1028 a_30254_26740# a_30105_26800# 0.02501f
C1029 a_22004_18900# a_3785_14900# 0.01236f
C1030 a_31785_22740# a_31785_18820# 0.02568f
C1031 NB a_31667_23329# 0.04359f
C1032 a_31785_35060# a_31934_35000# 0.05376f
C1033 VDD a_31524_22680# 0.33996f
C1034 a_8564_31080# a_7000_31140# 0.01745f
C1035 a_31785_14900# a_31785_35060# 0.03847f
C1036 a_3785_31140# a_3667_36069# 0.50839f
C1037 a_35027_19269# VDD 1.44542f
C1038 a_38244_22680# VDD 0.33892f
C1039 a_35145_26800# a_31785_18820# 0.15969f
C1040 a_31667_23329# a_29987_15349# 0.71255f
C1041 a_35027_19269# NB 0.03851f
C1042 a_19054_35280# a_18760_35340# 0.0133f
C1043 a_35145_18820# a_35145_14900# 0.10472f
C1044 a_10360_35340# a_5347_36069# 0.04198f
C1045 a_10654_27020# VDD 0.34827f
C1046 a_35145_35402# a_35145_14900# 0.04765f
C1047 a_31785_14900# a_29987_23329# 0.20629f
C1048 a_10654_14840# VDD 0.34967f
C1049 a_35027_19269# a_29987_15349# 0.01462f
C1050 a_3667_19549# a_20440_35340# 0.02451f
C1051 a_3667_19549# a_13865_14900# 0.03791f
C1052 a_41865_18820# a_50004_26740# 0.01437f
C1053 a_8564_31080# a_8680_31140# 0.02865f
C1054 a_169869_15139# a_167229_16189# 0.03776f
C1055 a_8564_18900# a_8680_18960# 0.01998f
C1056 a_24094_27020# a_5347_15489# 0.02871f
C1057 a_45080_22740# a_31667_23329# 0.04134f
C1058 a_33347_19269# a_40185_26800# 0.09965f
C1059 a_29987_31589# a_31785_22740# 0.05434f
C1060 a_3667_19549# a_20324_22960# 0.01351f
C1061 a_31785_22740# a_36707_19269# 0.03124f
C1062 VDD a_30254_22680# 0.34678f
C1063 a_3785_31140# a_5320_35340# 0.076f
C1064 a_7294_35280# a_5320_35340# 0.02878f
C1065 a_31667_35929# a_31785_18820# 0.03849f
C1066 a_31934_26740# a_29987_19269# 0.02068f
C1067 a_29987_31589# a_35145_26800# 0.07107f
C1068 a_36707_19269# a_35145_26800# 0.07434f
C1069 FB a_12185_14900# 0.08563f
C1070 VDD a_30105_14900# 0.1975f
C1071 a_31667_23329# a_33465_30860# 0.3828f
C1072 a_3785_14900# a_3667_36069# 0.11043f
C1073 a_31640_18820# a_31785_18820# 0.31799f
C1074 a_31667_27389# a_33465_35060# 1.66141f
C1075 a_33204_35000# a_33614_35000# 0.0129f
C1076 a_3667_19549# a_3785_18960# 2.76981f
C1077 FS a_31667_23329# 0.03791f
C1078 a_29987_31589# a_45374_18760# 0.01901f
C1079 a_7294_22960# a_5347_15489# 0.02702f
C1080 a_5204_31080# a_3640_31140# 0.01037f
C1081 a_36825_22740# a_36974_22680# 0.02332f
C1082 a_35027_19269# a_33465_30860# 0.03167f
C1083 a_31785_22740# a_31667_15349# 1.37085f
C1084 a_30105_14900# a_29987_15349# 4.16109f
C1085 a_41865_18820# a_31667_23329# 0.617f
C1086 a_31785_14900# a_33347_19269# 0.08798f
C1087 a_35145_18820# ICP2 0.04359f
C1088 a_31667_27389# a_41747_19269# 0.03088f
C1089 a_29987_31589# a_31667_35929# 0.38136f
C1090 a_35145_35402# a_29987_19269# 0.03791f
C1091 a_31785_35060# a_31785_18820# 0.03204f
C1092 a_15400_35340# a_8825_35340# 0.08775f
C1093 a_35145_35402# ICP2 0.04359f
C1094 a_35145_18820# a_30105_26800# 0.03356f
C1095 a_31785_22740# PB 0.04208f
C1096 a_35145_35402# a_30105_26800# 0.83572f
C1097 a_31667_15349# a_35145_26800# 0.03167f
C1098 a_3667_23609# a_8974_22960# 0.02269f
C1099 a_31785_22740# a_48440_18820# 0.02448f
C1100 a_29987_19269# a_38654_35342# 0.01149f
C1101 VDD a_48324_26740# 0.33901f
C1102 a_15545_14900# a_5347_15489# 0.08039f
C1103 a_3667_19549# a_3785_35340# 0.04188f
C1104 a_23684_22960# VDD 0.36279f
C1105 a_30105_22740# a_31667_23329# 0.02457f
C1106 PB a_35145_26800# 2.77926f
C1107 a_29987_23329# a_31785_18820# 0.03791f
C1108 a_5347_31869# a_3785_23020# 0.04223f
C1109 a_36564_26740# VDD 0.3627f
C1110 a_9114_3220# VDD 1.0911f
C1111 FB a_43284_22680# 0.01046f
C1112 a_48324_18760# a_48440_18820# 0.01552f
C1113 a_5347_31869# a_3640_31140# 0.05564f
C1114 a_33465_26800# a_29987_19269# 0.03122f
C1115 a_30105_22740# a_31524_22680# 0.02887f
C1116 a_166745_22522# a_169869_15139# 0.26604f
C1117 a_33465_26800# a_30105_26800# 0.06213f
C1118 a_42014_30800# VDD 0.47465f
C1119 a_3667_27669# ICP2 0.04359f
C1120 a_3667_23609# a_3667_36069# 0.04457f
C1121 ICP2 a_185512_20020# 0.07127f
C1122 a_29987_31589# a_31785_35060# 0.20409f
C1123 a_16964_27020# a_17080_27080# 0.01998f
C1124 a_31667_35929# a_31667_15349# 0.02214f
C1125 a_33465_30860# a_30105_14900# 0.19323f
C1126 a_31785_22740# a_30105_18820# 3.09031f
C1127 VDD a_47054_26740# 0.34666f
C1128 a_48440_18820# a_50414_18760# 0.01542f
C1129 a_36707_19269# a_31785_35060# 0.03791f
C1130 a_13865_14900# a_3667_36069# 0.07218f
C1131 a_8825_35340# ICP2 0.04359f
C1132 a_15545_14900# a_13865_23020# 0.04835f
C1133 a_38505_18820# a_35145_14900# 0.06748f
C1134 a_30105_35060# a_30254_35000# 0.0476f
C1135 PB a_31667_35929# 0.03849f
C1136 a_3640_31140# a_3524_31080# 0.02888f
C1137 a_3667_27669# a_22120_31140# 0.02905f
C1138 a_22414_18900# VDD 0.34888f
C1139 a_6760_3464# a_10794_3220# 0.01712f
C1140 a_30105_18820# a_35145_26800# 0.03064f
C1141 a_3667_19549# VDD 5.28543f
C1142 VDD a_33465_35060# 2.90508f
C1143 a_29987_31589# a_29987_23329# 0.58827f
C1144 a_35027_19269# a_35000_18820# 0.05894f
C1145 a_31640_18820# a_31667_15349# 0.045f
C1146 a_41865_18820# a_30105_14900# 0.03942f
C1147 a_8704_3220# VDD 1.15375f
C1148 a_15400_18960# a_3785_14900# 0.30974f
C1149 a_29987_23329# a_36707_19269# 0.04575f
C1150 a_30105_22740# a_30254_22680# 0.02481f
C1151 NB a_33465_35060# 0.04359f
C1152 a_31785_14900# a_31934_14840# 0.01937f
C1153 a_3667_19549# NB 0.03441f
C1154 a_41604_30800# VDD 0.49562f
C1155 a_19487_1769# a_24794_1462# 0.01149f
C1156 a_3667_27669# a_5347_31869# 0.04359f
C1157 a_33347_19269# a_31785_18820# 0.16191f
C1158 a_41747_19269# VDD 1.68955f
C1159 a_6884_18900# VDD 0.3628f
C1160 a_31785_35060# a_31667_15349# 0.05135f
C1161 a_41747_19269# NB 0.03676f
C1162 a_3785_18960# a_3667_36069# 0.04345f
C1163 a_38654_22680# VDD 0.34107f
C1164 a_8680_35340# a_8825_35340# 0.28091f
C1165 a_22004_18900# VDD 0.36272f
C1166 a_30105_35060# a_31524_35000# 0.05265f
C1167 a_185374_14840# a_169869_15139# 0.01988f
C1168 a_6760_3464# a_10384_3220# 0.01904f
C1169 a_35145_14900# a_40185_26800# 0.01672f
C1170 a_24094_35280# a_3785_18960# 0.02878f
C1171 a_19054_22960# VDD 0.34967f
C1172 a_5347_31869# a_12334_18900# 0.02246f
C1173 a_29987_23329# a_31667_15349# 0.10782f
C1174 a_167305_14900# a_169869_15139# 0.5141f
C1175 a_166745_22522# a_166894_22462# 0.01226f
C1176 a_31785_14900# a_31640_14900# 0.33258f
C1177 PB a_5465_14900# 0.03676f
C1178 VDD a_13604_27020# 0.3627f
C1179 a_3785_23020# a_23684_27020# 0.02652f
C1180 a_8825_35340# a_12334_27020# 0.02074f
C1181 a_30254_14840# a_30105_14900# 0.01923f
C1182 a_35000_18820# a_30105_14900# 0.0684f
C1183 ICP2 a_38505_18820# 0.03676f
C1184 a_3667_36069# a_3785_35340# 0.54303f
C1185 a_29987_23329# PB 0.07645f
C1186 a_21167_1909# VDD 0.57807f
C1187 a_38505_18820# a_30105_26800# 0.02618f
C1188 a_31640_18820# a_30105_18820# 0.03485f
C1189 VDD a_30254_35000# 0.59998f
C1190 a_29987_31589# a_33347_19269# 0.44987f
C1191 a_3667_19549# a_20734_22960# 0.02374f
C1192 a_36707_19269# a_33347_19269# 0.77414f
C1193 VDD a_41604_26740# 0.33892f
C1194 a_18760_35340# a_5347_15489# 0.0913f
C1195 a_5614_27020# a_3667_36069# 0.021f
C1196 LO VDD 0.06851f
C1197 a_48440_22740# a_30105_18820# 0.02845f
C1198 VDD a_8974_22960# 0.35048f
C1199 a_33465_30860# a_33465_35060# 0.24824f
C1200 a_40334_18760# a_38360_18820# 0.01542f
C1201 FB a_31667_23329# 0.1425f
C1202 a_18644_22960# VDD 0.36279f
C1203 FS a_33465_35060# 0.29723f
C1204 a_38360_18820# a_29987_15349# 0.05885f
C1205 a_31785_14900# a_35145_14900# 0.33515f
C1206 a_41747_19269# a_33465_30860# 0.03167f
C1207 a_169869_15139# a_174309_15139# 0.64783f
C1208 a_5320_35340# a_3785_35340# 0.06896f
C1209 a_35027_19269# FB 0.08901f
C1210 a_3785_14900# a_5465_14900# 0.06222f
C1211 a_31524_35000# VDD 0.58512f
C1212 a_29987_23329# a_30105_18820# 0.0414f
C1213 a_41747_19269# FS 0.04421f
C1214 a_149000_15084# PB 9.53092f
C1215 a_31785_22740# a_31667_27389# 0.04288f
C1216 a_30105_26800# a_40185_26800# 0.04668f
C1217 a_33347_19269# a_31667_15349# 0.06755f
C1218 a_35145_18820# a_35145_35402# 0.06848f
C1219 a_5347_31869# a_14014_18900# 0.0215f
C1220 a_18760_35340# a_13865_23020# 0.03905f
C1221 a_5204_27020# a_3667_36069# 0.01053f
C1222 VDD a_3667_36069# 2.07544f
C1223 a_49434_30800# a_49285_30860# 0.02481f
C1224 a_3785_31140# a_5347_15489# 0.06894f
C1225 a_174734_22462# ICP2 0.01615f
C1226 a_181821_20080# VDD 0.25314f
C1227 a_3667_23609# a_13604_35280# 0.01659f
C1228 a_41865_18820# a_41747_19269# 0.19918f
C1229 PB a_33347_19269# 0.07993f
C1230 a_31667_27389# a_35145_26800# 0.04054f
C1231 a_3667_27669# a_3785_23020# 0.01076f
C1232 a_181821_20080# NB 1.32677f
C1233 VDD a_45374_26740# 0.34827f
C1234 PB a_5347_15489# 0.04359f
C1235 a_15545_14900# a_15694_31422# 0.01511f
C1236 a_8825_35340# a_3785_23020# 1.09396f
C1237 a_17807_1769# VDD 1.11895f
C1238 a_31667_27389# a_48734_22680# 0.01901f
C1239 a_3667_27669# a_22414_27020# 0.01988f
C1240 a_180040_14900# VDD 0.25314f
C1241 a_31667_27389# a_31667_35929# 0.90366f
C1242 a_3785_31140# a_13865_23020# 0.04551f
C1243 a_31785_14900# a_30105_26800# 0.03124f
C1244 ICP2 a_167229_16189# 1.00703f
C1245 a_15545_14900# a_15694_14840# 0.02481f
C1246 VDD a_7180_3464# 0.75905f
C1247 a_30105_18820# a_33347_19269# 0.20683f
C1248 a_41747_19269# a_48734_26740# 0.02205f
C1249 a_180040_14900# NB 1.55476f
C1250 a_3667_23609# a_5465_14900# 0.05069f
C1251 a_13720_35340# a_3785_31140# 0.08579f
C1252 a_21167_1909# a_5347_36069# 0.05702f
C1253 a_38654_18760# a_38505_18820# 0.01937f
C1254 a_13865_23020# PB 0.03851f
C1255 a_30105_35060# a_31667_35929# 0.05266f
C1256 a_20734_35280# a_18760_35340# 0.02882f
C1257 a_3785_14900# a_5347_15489# 0.097f
C1258 VDD a_33614_35000# 0.59998f
C1259 a_3785_31140# a_3640_35340# 0.08755f
C1260 LO a_5347_36069# 0.3106f
C1261 a_31785_22740# VDD 2.03947f
C1262 a_46644_35000# a_38505_18820# 0.01163f
C1263 VDD a_43694_26740# 0.34827f
C1264 a_31667_27389# a_48440_22740# 0.25301f
C1265 a_31785_22740# NB 0.0354f
C1266 a_3667_27669# a_8825_35340# 0.60406f
C1267 a_31667_27389# a_31785_35060# 0.20693f
C1268 ICP2 a_174324_22462# 0.01216f
C1269 VDD a_35145_26800# 2.47724f
C1270 a_3934_22960# a_3785_23020# 0.02481f
C1271 a_3667_19549# a_12185_14900# 0.03557f
C1272 a_181821_20080# FS 0.10121f
C1273 a_15545_14900# a_5347_31869# 0.05687f
C1274 a_35027_19269# a_45374_35342# 0.01149f
C1275 NB a_35145_26800# 0.04359f
C1276 a_31785_22740# a_29987_15349# 0.11456f
C1277 a_30105_35060# a_31785_35060# 0.21263f
C1278 a_3785_18960# a_5465_14900# 0.04402f
C1279 a_29987_31589# a_35145_14900# 0.41945f
C1280 a_3667_36069# a_5347_36069# 0.03871f
C1281 a_31667_27389# a_29987_23329# 0.07007f
C1282 a_43694_22680# a_33465_35060# 0.02332f
C1283 a_31640_14900# a_31667_15349# 0.03205f
C1284 a_36707_19269# a_35145_14900# 0.17928f
C1285 a_35145_18820# a_38505_18820# 0.28931f
C1286 VDD a_43284_26740# 0.36272f
C1287 a_35145_35402# a_38505_18820# 0.03234f
C1288 a_35027_19269# a_31667_23329# 0.03168f
C1289 a_30105_35060# a_29987_23329# 0.13865f
C1290 a_31785_22740# a_45080_22740# 0.04559f
C1291 a_3667_36069# a_3934_35280# 0.01188f
C1292 VDD a_31667_35929# 1.81738f
C1293 a_29987_19269# a_31785_18820# 0.37957f
C1294 ICP2 a_31785_18820# 0.04359f
C1295 a_3667_23609# a_5347_15489# 0.35339f
C1296 a_5465_14900# a_3785_35340# 0.06694f
C1297 a_3667_19549# a_17080_27080# 0.03412f
C1298 VDD a_42014_26740# 0.34168f
C1299 a_30105_26800# a_31785_18820# 0.09016f
C1300 a_180040_14900# FS 0.09539f
C1301 FB a_33465_35060# 0.24204f
C1302 a_3667_19549# FB 0.45533f
C1303 NB a_31667_35929# 0.03998f
C1304 a_10360_35340# a_10654_35280# 0.01363f
C1305 a_31785_22740# a_31934_31142# 0.01149f
C1306 a_166745_22522# ICP2 0.50439f
C1307 a_13865_14900# a_5347_15489# 0.10709f
C1308 REFCK VDD 1.09784f
C1309 a_17807_1769# a_5347_36069# 0.42945f
C1310 a_41604_18760# a_41720_18820# 0.01552f
C1311 a_3640_31140# a_3934_31080# 0.01038f
C1312 a_31785_22740# a_33465_30860# 0.05672f
C1313 a_5347_36069# a_5320_35340# 0.15898f
C1314 VCTRL PB 0.12717f
C1315 a_29987_15349# a_31667_35929# 0.0396f
C1316 a_35145_14900# a_31667_15349# 0.09463f
C1317 a_41747_19269# FB 0.14231f
C1318 a_3667_36069# a_7000_31140# 0.08816f
C1319 a_31785_22740# FS 0.08248f
C1320 ICP2 a_176414_22120# 0.01132f
C1321 a_15400_35340# a_3785_31140# 0.08588f
C1322 a_33465_30860# a_35145_26800# 0.17848f
C1323 a_35145_14900# PB 0.03849f
C1324 a_5347_15489# a_5614_22960# 0.02481f
C1325 a_29987_23329# a_35000_14900# 0.02508f
C1326 a_29987_31589# a_29987_19269# 0.04103f
C1327 a_31785_35060# VDD 2.17599f
C1328 a_29987_31589# ICP2 0.04359f
C1329 a_31667_27389# a_33347_19269# 0.20185f
C1330 a_31640_18820# a_29987_15349# 0.05121f
C1331 a_31785_22740# a_41865_18820# 0.23459f
C1332 a_15694_35280# a_13720_35340# 0.02878f
C1333 a_31667_23329# a_30105_14900# 0.28998f
C1334 a_29987_31589# a_30105_26800# 0.86249f
C1335 FS a_35145_26800# 0.034f
C1336 a_36707_19269# ICP2 0.04359f
C1337 a_22004_27020# VDD 0.36272f
C1338 a_35145_35402# a_35294_35342# 0.01386f
C1339 a_36707_19269# a_29987_19269# 0.03236f
C1340 a_36707_19269# a_30105_26800# 0.037f
C1341 a_3785_18960# a_5347_15489# 0.15685f
C1342 a_3667_23609# a_13720_35340# 0.23634f
C1343 a_13865_14900# a_13865_23020# 0.04463f
C1344 a_176004_22120# ICP2 0.01078f
C1345 VDD a_5465_14900# 2.8296f
C1346 a_41865_18820# a_35145_26800# 0.03812f
C1347 a_8680_31140# a_3667_36069# 0.07981f
C1348 a_29987_23329# VDD 5.19095f
C1349 a_41720_18820# a_29987_15349# 0.05263f
C1350 a_169869_15139# VDD 2.92642f
C1351 VDD a_15694_27020# 0.34827f
C1352 a_31785_35060# a_29987_15349# 0.04517f
C1353 a_31785_22740# a_30105_22740# 0.13862f
C1354 NB a_5465_14900# 0.03649f
C1355 a_7294_27020# a_3785_35340# 0.0226f
C1356 a_15545_14900# a_3785_23020# 0.03791f
C1357 a_29987_23329# NB 0.07674f
C1358 a_12185_14900# a_3667_36069# 0.07092f
C1359 a_33465_30860# a_31667_35929# 0.37906f
C1360 NB a_169869_15139# 0.88297f
C1361 a_30105_18820# a_35145_14900# 0.03239f
C1362 a_5347_15489# a_3785_35340# 0.17042f
C1363 a_35145_18820# a_31785_14900# 0.03667f
C1364 ICP2 a_3785_31140# 0.0412f
C1365 a_29987_23329# a_29987_15349# 0.62642f
C1366 a_35145_35402# a_31785_14900# 0.03847f
C1367 a_30105_26800# a_31667_15349# 0.02568f
C1368 a_20734_27020# VDD 0.34827f
R0 PB PB.n14 293.003
R1 PB.n0 PB.t0 36.0256
R2 PB.n7 PB.t15 36.0256
R3 PB.n6 PB.n5 21.4256
R4 PB.n5 PB.n4 21.4256
R5 PB.n4 PB.n3 21.4256
R6 PB.n3 PB.n2 21.4256
R7 PB.n2 PB.n1 21.4256
R8 PB.n1 PB.n0 21.4256
R9 PB.n13 PB.n12 21.4256
R10 PB.n12 PB.n11 21.4256
R11 PB.n11 PB.n10 21.4256
R12 PB.n10 PB.n9 21.4256
R13 PB.n9 PB.n8 21.4256
R14 PB.n8 PB.n7 21.4256
R15 PB.n6 PB.t7 14.6005
R16 PB.n5 PB.t6 14.6005
R17 PB.n4 PB.t5 14.6005
R18 PB.n3 PB.t4 14.6005
R19 PB.n2 PB.t3 14.6005
R20 PB.n1 PB.t2 14.6005
R21 PB.n0 PB.t1 14.6005
R22 PB.n13 PB.t8 14.6005
R23 PB.n12 PB.t9 14.6005
R24 PB.n11 PB.t10 14.6005
R25 PB.n10 PB.t11 14.6005
R26 PB.n9 PB.t12 14.6005
R27 PB.n8 PB.t13 14.6005
R28 PB.n7 PB.t14 14.6005
R29 PB.n14 PB.n6 10.7131
R30 PB.n14 PB.n13 10.7131
R31 NB NB.n8 322.822
R32 NB.n0 NB.t0 36.0256
R33 NB.n4 NB.t9 36.0256
R34 NB.n3 NB.n2 21.4256
R35 NB.n2 NB.n1 21.4256
R36 NB.n1 NB.n0 21.4256
R37 NB.n7 NB.n6 21.4256
R38 NB.n6 NB.n5 21.4256
R39 NB.n5 NB.n4 21.4256
R40 NB.n3 NB.t4 14.6005
R41 NB.n2 NB.t3 14.6005
R42 NB.n1 NB.t2 14.6005
R43 NB.n0 NB.t1 14.6005
R44 NB.n7 NB.t5 14.6005
R45 NB.n6 NB.t6 14.6005
R46 NB.n5 NB.t7 14.6005
R47 NB.n4 NB.t8 14.6005
R48 NB.n8 NB.n3 10.7131
R49 NB.n8 NB.n7 10.7131
R50 ICP2 ICP2.n2 302.724
R51 ICP2.n1 ICP2.t2 72.4689
R52 ICP2.n0 ICP2.t1 56.5065
R53 ICP2.n0 ICP2.t0 56.5065
R54 ICP2.n1 ICP2.t3 48.3995
R55 ICP2.n2 ICP2.n0 48.2109
R56 ICP2.n2 ICP2.n1 22.8995
R57 FS FS.n1 256.623
R58 FS.n1 FS.n0 13.8965
R59 FS.n1 FS.t2 12.5402
R60 FS.n0 FS.t1 5.71141
R61 FS.n0 FS.t0 5.53998
R62 FB FB.n6 216.106
R63 FB.n6 FB.n2 107.034
R64 FB.n3 FB.t6 106.787
R65 FB.n0 FB.t7 94.7172
R66 FB.n2 FB.t5 75.7962
R67 FB.n0 FB.t4 73.7289
R68 FB.n1 FB.t2 72.8229
R69 FB.n4 FB.t3 61.6269
R70 FB.n6 FB.n5 30.2525
R71 FB.n1 FB.n0 27.1565
R72 FB.n4 FB.t0 18.3424
R73 FB.n3 FB.t1 15.1206
R74 FB.n5 FB.n4 14.3225
R75 FB.n2 FB.n1 9.0065
R76 FB.n5 FB.n3 2.0765
R77 a_149000_17206.n2 a_149000_17206.n1 76.8236
R78 a_149000_17206.t7 a_149000_17206.t3 14.5325
R79 a_149000_17206.t3 a_149000_17206.n2 14.0165
R80 a_149000_17206.n0 a_149000_17206.t5 13.8895
R81 a_149000_17206.t2 a_149000_17206.t7 13.3625
R82 a_149000_17206.n2 a_149000_17206.t1 11.9126
R83 a_149000_17206.n0 a_149000_17206.t4 11.078
R84 a_149000_17206.n1 a_149000_17206.t6 6.0601
R85 a_149000_17206.n1 a_149000_17206.n0 4.40544
R86 a_149000_17206.t0 a_149000_17206.t2 2.97037
R87 a_10645_3280.n1 a_10645_3280.t5 85.1349
R88 a_10645_3280.t1 a_10645_3280.n2 77.5205
R89 a_10645_3280.n2 a_10645_3280.t4 66.5919
R90 a_10645_3280.n0 a_10645_3280.t3 51.6438
R91 a_10645_3280.n0 a_10645_3280.t2 49.8948
R92 a_10645_3280.n2 a_10645_3280.n1 35.8565
R93 a_10645_3280.t0 a_10645_3280.t1 21.4978
R94 a_10645_3280.n1 a_10645_3280.n0 10.3565
R95 a_20585_14900.n1 a_20585_14900.n0 302.233
R96 a_20585_14900.n0 a_20585_14900.t2 74.1489
R97 a_20585_14900.n0 a_20585_14900.t3 71.7219
R98 a_20585_14900.t0 a_20585_14900.n1 36.3124
R99 a_20585_14900.n1 a_20585_14900.t1 14.9466
R100 a_18905_14900.t1 a_18905_14900.n4 259.026
R101 a_18905_14900.n0 a_18905_14900.t6 72.4689
R102 a_18905_14900.n1 a_18905_14900.t2 72.2797
R103 a_18905_14900.n1 a_18905_14900.t3 72.2797
R104 a_18905_14900.n2 a_18905_14900.t4 72.2797
R105 a_18905_14900.n2 a_18905_14900.t5 72.2797
R106 a_18905_14900.n0 a_18905_14900.t7 48.3995
R107 a_18905_14900.n4 a_18905_14900.n3 29.2025
R108 a_18905_14900.t0 a_18905_14900.t1 28.8424
R109 a_18905_14900.n4 a_18905_14900.n0 20.8955
R110 a_18905_14900.n3 a_18905_14900.n1 9.22887
R111 a_18905_14900.n3 a_18905_14900.n2 6.53487
R112 a_7027_15489.n2 a_7027_15489.n1 298.423
R113 a_7027_15489.n0 a_7027_15489.t6 100.126
R114 a_7027_15489.n1 a_7027_15489.t2 83.7789
R115 a_7027_15489.n1 a_7027_15489.t3 61.6959
R116 a_7027_15489.n0 a_7027_15489.t5 52.5086
R117 a_7027_15489.t0 a_7027_15489.t1 16.2304
R118 a_7027_15489.t4 a_7027_15489.n2 13.2065
R119 a_7027_15489.n2 a_7027_15489.n0 5.8565
R120 a_7027_15489.t1 a_7027_15489.t4 4.8965
R121 a_3667_15489.n5 a_3667_15489.t12 91.2822
R122 a_3667_15489.n2 a_3667_15489.t10 87.4572
R123 a_3667_15489.n0 a_3667_15489.t4 78.7689
R124 a_3667_15489.n6 a_3667_15489.t8 71.0919
R125 a_3667_15489.n0 a_3667_15489.t6 71.0229
R126 a_3667_15489.n1 a_3667_15489.t7 71.0229
R127 a_3667_15489.n2 a_3667_15489.t11 71.0193
R128 a_3667_15489.n5 a_3667_15489.t9 71.0193
R129 a_3667_15489.t0 a_3667_15489.t3 27.7324
R130 a_3667_15489.n3 a_3667_15489.t1 14.2841
R131 a_3667_15489.n6 a_3667_15489.n5 11.5925
R132 a_3667_15489.t2 a_3667_15489.t5 10.7765
R133 a_3667_15489.n4 a_3667_15489.n3 10.3565
R134 a_3667_15489.t5 a_3667_15489.n7 10.1465
R135 a_3667_15489.n7 a_3667_15489.n4 7.5365
R136 a_3667_15489.n3 a_3667_15489.n2 7.1165
R137 a_3667_15489.n1 a_3667_15489.n0 5.0165
R138 a_3667_15489.t3 a_3667_15489.t2 2.0765
R139 a_3667_15489.n4 a_3667_15489.n1 2.0765
R140 a_3667_15489.n7 a_3667_15489.n6 2.0765
C1369 LO VSS 9.15196f
C1370 REFCK VSS 11.9706f
C1371 PB VSS 72.6228f
C1372 VCTRL VSS 35.2652f
C1373 NB VSS 87.77477f
C1374 ICP2 VSS 83.3815f
C1375 FS VSS 58.2749f
C1376 FB VSS 98.33846f
C1377 VDD VSS 0.84127p
C1378 a_24794_1462# VSS 0.24358f
C1379 a_24384_1462# VSS 0.25096f
C1380 a_23114_1462# VSS 0.02717f
C1381 a_22704_1462# VSS 0.02717f
C1382 a_21434_1462# VSS 0.24097f
C1383 a_21024_1462# VSS 0.25096f
C1384 a_21167_1909# VSS 1.73444f ; **FLOATING
C1385 a_19754_1120# VSS 0.39313f
C1386 a_19344_1120# VSS 0.40784f ; **FLOATING
C1387 a_19487_1769# VSS 1.98459f ; **FLOATING
C1388 a_18074_1120# VSS 0.04368f
C1389 a_17664_1120# VSS 0.04368f
C1390 a_17807_1769# VSS 2.31517f ; **FLOATING
C1391 a_14154_3220# VSS 0.67777f
C1392 a_13744_3220# VSS 0.70799f
C1393 a_12474_3220# VSS 0.67777f
C1394 a_12064_3220# VSS 0.70854f
C1395 a_10794_3220# VSS 0.13083f
C1396 a_10384_3220# VSS 0.13083f
C1397 a_9114_3220# VSS 0.13083f
C1398 a_8704_3220# VSS 0.13083f
C1399 a_7180_3464# VSS 6.51907f ; **FLOATING
C1400 a_6760_3464# VSS 4.00755f ; **FLOATING
C1401 a_6760_5586# VSS 0.72731f ; **FLOATING
C1402 a_187216_14840# VSS 0.40335f
C1403 a_186644_14840# VSS 0.40154f
C1404 a_185374_14840# VSS 0.38721f
C1405 a_184964_14840# VSS 0.38367f
C1406 a_183694_14840# VSS 0.38483f
C1407 a_183400_14900# VSS 1.48128f ; **FLOATING
C1408 a_183284_14840# VSS 0.38539f
C1409 a_182014_14840# VSS 0.38639f
C1410 a_181604_14840# VSS 0.38429f
C1411 a_180334_14840# VSS 0.38401f
C1412 a_179924_14840# VSS 0.38621f
C1413 a_178456_14840# VSS 0.1192f
C1414 a_176840_14840# VSS 0.1192f
C1415 a_175376_15079# VSS 1.18584f
C1416 a_174309_15139# VSS 0.96022f ; **FLOATING
C1417 a_173760_15079# VSS 1.18584f
C1418 a_172420_15079# VSS 0.09961f
C1419 a_171524_15079# VSS 0.09961f
C1420 a_170180_15079# VSS 0.09961f
C1421 a_169869_15139# VSS 33.688f ; **FLOATING
C1422 a_169284_15079# VSS 0.09961f
C1423 a_167940_14840# VSS 0.14509f
C1424 a_167305_14900# VSS 0.65923f ; **FLOATING
C1425 a_167044_14840# VSS 0.14509f
C1426 a_165448_14840# VSS 0.22758f
C1427 a_158721_14900# VSS 2.05369f ; **FLOATING
C1428 a_157709_14900# VSS 2.23391f ; **FLOATING
C1429 a_156760_14840# VSS 0.22758f
C1430 a_149000_15084# VSS 0.38266p ; **FLOATING
C1431 a_36974_14840# VSS 0.32598f
C1432 a_36564_14840# VSS 0.33627f ; **FLOATING
C1433 a_35294_14840# VSS 0.31705f
C1434 a_35000_14900# VSS 0.83276f ; **FLOATING
C1435 a_34884_14840# VSS 0.31973f
C1436 a_33614_14840# VSS 0.32598f
C1437 a_33204_14840# VSS 0.33627f ; **FLOATING
C1438 a_31934_14840# VSS 0.31705f
C1439 a_31640_14900# VSS 0.84326f ; **FLOATING
C1440 a_31524_14840# VSS 0.32093f
C1441 a_30254_14840# VSS 0.32406f
C1442 a_29844_14840# VSS 0.3397f ; **FLOATING
C1443 a_20734_14840# VSS 0.04368f
C1444 a_20324_14840# VSS 0.04368f
C1445 a_19054_14840# VSS 0.04368f
C1446 a_18644_14840# VSS 0.04368f
C1447 a_17374_14840# VSS 0.04368f
C1448 a_16964_14840# VSS 0.04368f
C1449 a_15694_14840# VSS 0.04368f
C1450 a_15284_14840# VSS 0.04368f
C1451 a_14014_14840# VSS 0.04368f
C1452 a_13604_14840# VSS 0.04368f
C1453 a_12334_14840# VSS 0.04368f
C1454 a_11924_14840# VSS 0.04368f
C1455 a_10654_14840# VSS 0.04368f
C1456 a_10244_14840# VSS 0.04368f
C1457 a_8974_14840# VSS 0.04368f
C1458 a_8564_14840# VSS 0.04368f
C1459 a_7294_14840# VSS 0.39439f
C1460 a_6884_14840# VSS 0.40799f ; **FLOATING
C1461 a_5614_14840# VSS 0.38371f
C1462 a_5320_14900# VSS 0.94793f ; **FLOATING
C1463 a_5204_14840# VSS 0.38606f
C1464 a_3934_14840# VSS 0.04368f
C1465 a_3524_14840# VSS 0.04368f
C1466 a_52094_18760# VSS 0.32093f
C1467 a_30105_14900# VSS 5.32759f ; **FLOATING
C1468 a_51684_18760# VSS 0.31705f
C1469 a_50414_18760# VSS 0.3275f
C1470 a_50004_18760# VSS 0.33627f ; **FLOATING
C1471 a_48734_18760# VSS 0.31736f
C1472 a_48440_18820# VSS 0.90874f ; **FLOATING
C1473 a_48324_18760# VSS 0.31874f
C1474 a_47054_18760# VSS 0.32598f
C1475 a_46644_18760# VSS 0.33627f ; **FLOATING
C1476 a_45374_18760# VSS 0.31705f
C1477 a_45080_18820# VSS 0.83268f ; **FLOATING
C1478 a_44964_18760# VSS 0.31973f
C1479 a_43694_18760# VSS 0.32598f
C1480 a_43284_18760# VSS 0.33627f ; **FLOATING
C1481 a_42014_18760# VSS 0.31705f
C1482 a_41720_18820# VSS 0.84326f ; **FLOATING
C1483 a_41604_18760# VSS 0.32093f
C1484 a_40334_18760# VSS 0.3275f
C1485 a_39924_18760# VSS 0.33627f ; **FLOATING
C1486 a_38654_18760# VSS 0.31805f
C1487 a_38360_18820# VSS 0.90519f ; **FLOATING
C1488 a_38244_18760# VSS 0.31973f
C1489 a_36974_18760# VSS 0.3263f
C1490 a_36564_18760# VSS 0.33726f ; **FLOATING
C1491 a_35294_18760# VSS 0.31705f
C1492 a_35000_18820# VSS 0.88025f ; **FLOATING
C1493 a_34884_18760# VSS 0.32093f
C1494 a_33614_18760# VSS 0.3263f
C1495 a_33204_18760# VSS 0.33726f ; **FLOATING
C1496 a_31934_18760# VSS 0.31805f
C1497 a_31640_18820# VSS 0.89146f ; **FLOATING
C1498 a_31524_18760# VSS 0.31879f
C1499 a_30254_18760# VSS 0.32406f
C1500 a_29844_18760# VSS 0.3397f ; **FLOATING
C1501 a_24094_18900# VSS 0.04368f
C1502 a_23684_18900# VSS 0.04368f
C1503 a_22414_18900# VSS 0.04368f
C1504 a_22004_18900# VSS 0.04368f
C1505 a_20734_18900# VSS 0.04368f
C1506 a_20324_18900# VSS 0.04368f
C1507 a_19054_18900# VSS 0.04368f
C1508 a_18644_18900# VSS 0.04368f
C1509 a_17374_18900# VSS 0.39374f
C1510 a_16964_18900# VSS 0.40738f
C1511 a_15694_18900# VSS 0.38401f ; **FLOATING
C1512 a_15400_18960# VSS 0.88266f ; **FLOATING
C1513 a_15284_18900# VSS 0.38545f
C1514 a_14014_18900# VSS 0.04368f
C1515 a_13604_18900# VSS 0.04368f
C1516 a_12334_18900# VSS 0.04368f
C1517 a_11924_18900# VSS 0.04368f
C1518 a_10654_18900# VSS 0.39313f
C1519 a_10244_18900# VSS 0.40738f ; **FLOATING
C1520 a_8974_18900# VSS 0.38401f
C1521 a_8680_18960# VSS 0.93065f ; **FLOATING
C1522 a_8564_18900# VSS 0.38545f
C1523 a_7294_18900# VSS 0.04368f
C1524 a_6884_18900# VSS 0.04368f
C1525 a_5614_18900# VSS 0.04368f
C1526 a_5204_18900# VSS 0.04368f
C1527 a_3934_18900# VSS 0.04368f
C1528 a_3524_18900# VSS 0.04368f
C1529 a_185512_20020# VSS 3.57578f
C1530 a_174020_15139# VSS 5.1829f ; **FLOATING
C1531 a_181821_20080# VSS 4.11924f ; **FLOATING
C1532 a_180040_14900# VSS 5.39375f ; **FLOATING
C1533 a_179860_20020# VSS 3.57578f
C1534 a_176414_22120# VSS 0.04368f
C1535 a_176004_22120# VSS 0.04368f
C1536 a_174734_22462# VSS 0.24044f
C1537 a_167229_16189# VSS 5.87069f ; **FLOATING
C1538 a_174324_22462# VSS 0.25233f
C1539 a_168574_22120# VSS 0.04368f
C1540 a_168164_22120# VSS 0.04368f
C1541 a_166894_22462# VSS 0.24044f
C1542 a_166745_22522# VSS 3.98633f ; **FLOATING
C1543 a_166484_22462# VSS 0.25233f ; **FLOATING
C1544 a_52094_22680# VSS 0.32093f
C1545 a_30105_18820# VSS 6.27235f ; **FLOATING
C1546 a_51684_22680# VSS 0.31705f
C1547 a_50414_22680# VSS 0.32598f
C1548 a_50004_22680# VSS 0.33627f ; **FLOATING
C1549 a_48734_22680# VSS 0.31705f
C1550 a_48440_22740# VSS 0.79864f ; **FLOATING
C1551 a_48324_22680# VSS 0.31973f
C1552 a_47054_22680# VSS 0.32598f
C1553 a_46644_22680# VSS 0.33627f ; **FLOATING
C1554 a_45374_22680# VSS 0.31705f
C1555 a_45080_22740# VSS 0.81919f ; **FLOATING
C1556 a_44964_22680# VSS 0.31973f
C1557 a_43694_22680# VSS 0.39182f
C1558 a_43284_22680# VSS 0.40875f
C1559 a_42014_22680# VSS 0.04368f
C1560 a_41604_22680# VSS 0.04368f
C1561 a_40334_22680# VSS 0.04368f
C1562 a_39924_22680# VSS 0.04368f
C1563 a_38654_22680# VSS 0.04368f
C1564 a_38244_22680# VSS 0.04368f
C1565 a_36974_22680# VSS 0.04368f
C1566 a_36825_22740# VSS 0.23824f ; **FLOATING
C1567 a_36564_22680# VSS 0.04368f
C1568 a_35294_22680# VSS 0.04368f
C1569 a_34884_22680# VSS 0.04368f
C1570 a_33614_22680# VSS 0.04368f
C1571 a_33204_22680# VSS 0.04368f
C1572 a_31934_22680# VSS 0.04368f
C1573 a_31524_22680# VSS 0.04368f
C1574 a_30254_22680# VSS 0.04368f
C1575 a_30105_22740# VSS 0.38345f ; **FLOATING
C1576 a_29844_22680# VSS 0.04368f
C1577 a_24094_22960# VSS 0.04368f
C1578 a_23684_22960# VSS 0.04368f
C1579 a_22414_22960# VSS 0.04368f
C1580 a_22004_22960# VSS 0.04368f
C1581 a_20734_22960# VSS 0.04368f
C1582 a_20324_22960# VSS 0.04368f
C1583 a_19054_22960# VSS 0.04368f
C1584 a_18644_22960# VSS 0.04368f
C1585 a_17374_22960# VSS 0.04368f
C1586 a_16964_22960# VSS 0.04368f
C1587 a_15694_22960# VSS 0.39439f
C1588 a_15284_22960# VSS 0.4082f ; **FLOATING
C1589 a_14014_22960# VSS 0.38453f
C1590 a_13720_23020# VSS 0.99605f ; **FLOATING
C1591 a_13604_22960# VSS 0.38721f
C1592 a_12334_22960# VSS 0.04368f
C1593 a_11924_22960# VSS 0.04368f
C1594 a_10654_22960# VSS 0.04368f
C1595 a_10244_22960# VSS 0.04368f
C1596 a_8974_22960# VSS 0.04368f
C1597 a_8564_22960# VSS 0.04368f
C1598 a_7294_22960# VSS 0.04368f
C1599 a_6884_22960# VSS 0.04368f
C1600 a_5614_22960# VSS 0.04368f
C1601 a_5204_22960# VSS 0.04368f
C1602 a_3934_22960# VSS 0.39121f
C1603 a_3524_22960# VSS 0.41138f ; **FLOATING
C1604 a_52094_26740# VSS 0.04368f
C1605 a_51684_26740# VSS 0.04368f
C1606 a_50414_26740# VSS 0.04368f
C1607 a_50004_26740# VSS 0.04368f
C1608 a_48734_26740# VSS 0.04368f
C1609 a_48324_26740# VSS 0.04368f
C1610 a_47054_26740# VSS 0.04368f
C1611 a_46905_26800# VSS 0.24767f ; **FLOATING
C1612 a_46644_26740# VSS 0.04368f
C1613 a_45374_26740# VSS 0.04368f
C1614 a_44964_26740# VSS 0.04368f
C1615 a_43694_26740# VSS 0.04368f
C1616 a_43284_26740# VSS 0.04368f
C1617 a_42014_26740# VSS 0.04368f
C1618 a_41604_26740# VSS 0.04368f
C1619 a_40334_26740# VSS 0.04368f
C1620 a_40185_26800# VSS 0.25213f ; **FLOATING
C1621 a_39924_26740# VSS 0.04368f
C1622 a_38654_26740# VSS 0.04368f
C1623 a_38244_26740# VSS 0.04368f
C1624 a_36974_26740# VSS 0.04368f
C1625 a_36564_26740# VSS 0.04368f
C1626 a_35294_26740# VSS 0.04368f
C1627 a_34884_26740# VSS 0.04368f
C1628 a_33614_26740# VSS 0.04368f
C1629 a_33465_26800# VSS 0.23689f ; **FLOATING
C1630 a_33204_26740# VSS 0.04368f
C1631 a_31934_26740# VSS 0.04368f
C1632 a_31524_26740# VSS 0.04368f
C1633 a_30254_26740# VSS 0.04368f
C1634 a_29844_26740# VSS 0.04368f
C1635 a_24094_27020# VSS 0.38626f
C1636 a_3785_23020# VSS 4.82523f ; **FLOATING
C1637 a_23684_27020# VSS 0.38389f
C1638 a_22414_27020# VSS 0.04368f
C1639 a_22004_27020# VSS 0.04368f
C1640 a_20734_27020# VSS 0.04368f
C1641 a_20324_27020# VSS 0.04368f
C1642 a_19054_27020# VSS 0.39313f
C1643 a_18644_27020# VSS 0.40738f ; **FLOATING
C1644 a_17374_27020# VSS 0.38401f
C1645 a_17080_27080# VSS 0.8879f ; **FLOATING
C1646 a_16964_27020# VSS 0.38519f
C1647 a_15694_27020# VSS 0.04368f
C1648 a_15284_27020# VSS 0.04368f
C1649 a_14014_27020# VSS 0.04368f
C1650 a_13604_27020# VSS 0.04368f
C1651 a_12334_27020# VSS 0.04368f
C1652 a_11924_27020# VSS 0.04368f
C1653 a_10654_27020# VSS 0.04368f
C1654 a_10244_27020# VSS 0.04368f
C1655 a_8974_27020# VSS 0.04368f
C1656 a_8564_27020# VSS 0.04368f
C1657 a_7294_27020# VSS 0.04368f
C1658 a_6884_27020# VSS 0.04368f
C1659 a_5614_27020# VSS 0.04368f
C1660 a_5204_27020# VSS 0.04368f
C1661 a_3934_27020# VSS 0.04368f
C1662 a_3524_27020# VSS 0.04368f
C1663 a_51114_30800# VSS 0.04368f
C1664 a_50704_30800# VSS 0.04368f
C1665 a_49434_30800# VSS 0.04368f
C1666 a_49285_30860# VSS 0.31605f ; **FLOATING
C1667 a_49024_30800# VSS 0.04368f
C1668 a_47680_30800# VSS 0.07989f
C1669 a_46784_30800# VSS 0.07989f
C1670 a_45536_30800# VSS 0.5796f ; **FLOATING
C1671 a_44964_30800# VSS 0.58257f ; **FLOATING
C1672 a_43694_31142# VSS 0.24275f
C1673 a_43284_31142# VSS 0.25096f ; **FLOATING
C1674 a_42014_30800# VSS 0.05836f
C1675 a_41604_30800# VSS 0.05836f
C1676 a_31785_14900# VSS 8.17718f ; **FLOATING
C1677 a_40334_31142# VSS 0.24275f
C1678 a_31667_15349# VSS 4.06358f ; **FLOATING
C1679 a_39924_31142# VSS 0.25096f ; **FLOATING
C1680 a_35145_14900# VSS 7.54667f ; **FLOATING
C1681 a_38654_31142# VSS 0.24044f
C1682 a_38244_31142# VSS 0.25327f ; **FLOATING
C1683 a_36974_31142# VSS 0.24044f
C1684 a_36564_31142# VSS 0.25327f ; **FLOATING
C1685 a_35294_31142# VSS 0.24044f
C1686 a_34884_31142# VSS 0.25149f
C1687 a_33614_30800# VSS 0.05836f
C1688 a_33465_30860# VSS 7.71674f ; **FLOATING
C1689 a_33204_30800# VSS 0.05836f
C1690 a_29987_15349# VSS 6.07848f ; **FLOATING
C1691 a_31934_31142# VSS 0.24275f
C1692 a_31785_22740# VSS 6.14274f ; **FLOATING
C1693 a_31524_31142# VSS 0.25327f ; **FLOATING
C1694 a_30254_31142# VSS 0.24044f
C1695 a_29844_31142# VSS 0.2541f ; **FLOATING
C1696 a_24094_31080# VSS 0.39521f
C1697 a_23684_31080# VSS 0.4082f ; **FLOATING
C1698 a_22414_31080# VSS 0.38483f
C1699 a_22120_31140# VSS 1.12453f ; **FLOATING
C1700 a_22004_31080# VSS 0.38539f
C1701 a_20734_31422# VSS 0.24128f ; **FLOATING
C1702 a_20324_31422# VSS 0.2541f ; **FLOATING
C1703 a_19054_31422# VSS 0.24044f ; **FLOATING
C1704 a_18644_31422# VSS 0.2541f ; **FLOATING
C1705 a_17374_31422# VSS 0.24358f ; **FLOATING
C1706 a_16964_31422# VSS 0.25327f ; **FLOATING
C1707 a_15694_31422# VSS 0.24128f
C1708 a_15545_14900# VSS 7.13195f ; **FLOATING
C1709 a_15284_31422# VSS 0.25327f ; **FLOATING
C1710 a_14014_31422# VSS 0.24128f
C1711 a_13865_14900# VSS 7.65972f ; **FLOATING
C1712 a_13604_31422# VSS 0.25327f ; **FLOATING
C1713 a_12334_31422# VSS 0.24128f
C1714 a_12185_14900# VSS 7.52295f ; **FLOATING
C1715 a_11924_31422# VSS 0.25327f ; **FLOATING
C1716 a_5465_14900# VSS 7.42073f ; **FLOATING
C1717 a_10654_31080# VSS 0.53581f
C1718 a_10244_31080# VSS 0.55653f
C1719 a_8974_31080# VSS 0.52235f
C1720 a_8680_31140# VSS 1.18966f ; **FLOATING
C1721 a_8564_31080# VSS 0.52159f
C1722 a_7294_31080# VSS 0.52095f
C1723 a_3785_14900# VSS 9.35055f ; **FLOATING
C1724 a_7000_31140# VSS 0.82768f ; **FLOATING
C1725 a_6884_31080# VSS 0.52189f
C1726 a_5614_31080# VSS 0.53441f
C1727 a_5204_31080# VSS 0.55653f
C1728 a_5347_31869# VSS 9.02057f ; **FLOATING
C1729 a_3934_31080# VSS 0.52095f
C1730 a_3640_31140# VSS 1.02614f ; **FLOATING
C1731 a_3524_31080# VSS 0.52329f
C1732 a_52094_35000# VSS 0.05836f
C1733 a_29987_31589# VSS 10.8579f ; **FLOATING
C1734 a_51684_35000# VSS 0.05836f
C1735 a_41865_18820# VSS 8.13774f ; **FLOATING
C1736 a_50414_35342# VSS 0.24358f
C1737 a_41747_19269# VSS 6.1871f ; **FLOATING
C1738 a_50004_35342# VSS 0.25327f ; **FLOATING
C1739 a_48734_35342# VSS 0.24275f
C1740 a_31667_23329# VSS 11.647f ; **FLOATING
C1741 a_48324_35342# VSS 0.25327f ; **FLOATING
C1742 a_47054_35000# VSS 0.05836f
C1743 a_46644_35000# VSS 0.05836f
C1744 a_35145_18820# VSS 6.04905f ; **FLOATING
C1745 a_45374_35342# VSS 0.24097f
C1746 a_35027_19269# VSS 6.15477f ; **FLOATING
C1747 a_44964_35342# VSS 0.25096f
C1748 a_38505_18820# VSS 6.98204f ; **FLOATING
C1749 a_43694_35342# VSS 0.24232f
C1750 a_36707_19269# VSS 7.92611f ; **FLOATING
C1751 a_43284_35342# VSS 0.25284f ; **FLOATING
C1752 a_42014_35000# VSS 0.05836f
C1753 a_41604_35000# VSS 0.05836f
C1754 a_33347_19269# VSS 8.59631f ; **FLOATING
C1755 a_40334_35342# VSS 0.24044f
C1756 a_35145_26800# VSS 7.79635f ; **FLOATING
C1757 a_39924_35342# VSS 0.25149f
C1758 a_31785_18820# VSS 8.09605f ; **FLOATING
C1759 a_38654_35342# VSS 0.24097f
C1760 a_29987_19269# VSS 8.14822f ; **FLOATING
C1761 a_38244_35342# VSS 0.25159f ; **FLOATING
C1762 a_36974_35000# VSS 0.05836f
C1763 a_36564_35000# VSS 0.05836f
C1764 a_30105_26800# VSS 6.11816f ; **FLOATING
C1765 a_35294_35342# VSS 0.24044f
C1766 a_35145_35402# VSS 7.1272f ; **FLOATING
C1767 a_34884_35342# VSS 0.25347f ; **FLOATING
C1768 a_31667_27389# VSS 10.5172f ; **FLOATING
C1769 a_33614_35000# VSS 0.07326f
C1770 a_33465_35060# VSS 6.24917f ; **FLOATING
C1771 a_33204_35000# VSS 0.07326f
C1772 a_31934_35000# VSS 0.07326f
C1773 a_31785_35060# VSS 8.30096f ; **FLOATING
C1774 a_31524_35000# VSS 0.07326f
C1775 a_31667_35929# VSS 4.60802f ; **FLOATING
C1776 a_30254_35000# VSS 0.07326f
C1777 a_30105_35060# VSS 0.53828f ; **FLOATING
C1778 a_29844_35000# VSS 0.07326f
C1779 a_29987_23329# VSS 16.1561f ; **FLOATING
C1780 a_24094_35280# VSS 0.52329f
C1781 a_3785_18960# VSS 14.2924f ; **FLOATING
C1782 a_3785_31140# VSS 5.01171f ; **FLOATING
C1783 a_23684_35280# VSS 0.52095f
C1784 a_22414_35280# VSS 0.53581f
C1785 a_22004_35280# VSS 0.55513f
C1786 a_20734_35280# VSS 0.52235f
C1787 a_20440_35340# VSS 1.2045f ; **FLOATING
C1788 a_20324_35280# VSS 0.52159f
C1789 a_19054_35280# VSS 0.52095f
C1790 a_3667_19549# VSS 11.8094f ; **FLOATING
C1791 a_18760_35340# VSS 0.8503f ; **FLOATING
C1792 a_18644_35280# VSS 0.52189f
C1793 a_13865_23020# VSS 6.92237f ; **FLOATING
C1794 a_17374_35280# VSS 0.534f
C1795 a_16964_35280# VSS 0.55513f
C1796 a_15694_35280# VSS 0.52095f
C1797 a_15400_35340# VSS 1.04214f ; **FLOATING
C1798 a_15284_35280# VSS 0.52159f
C1799 a_14014_35280# VSS 0.52095f
C1800 a_3667_23609# VSS 7.74213f ; **FLOATING
C1801 a_13720_35340# VSS 0.77308f ; **FLOATING
C1802 a_13604_35280# VSS 0.52329f
C1803 a_5347_15489# VSS 21.1858f ; **FLOATING
C1804 a_12334_35280# VSS 0.53581f
C1805 a_11924_35280# VSS 0.55653f
C1806 a_3667_27669# VSS 8.77185f ; **FLOATING
C1807 a_10654_35280# VSS 0.52235f
C1808 a_10360_35340# VSS 1.22936f ; **FLOATING
C1809 a_10244_35280# VSS 0.52159f
C1810 a_8974_35280# VSS 0.52095f
C1811 a_8825_35340# VSS 7.05986f ; **FLOATING
C1812 a_8680_35340# VSS 0.75422f ; **FLOATING
C1813 a_8564_35280# VSS 0.52189f
C1814 a_7294_35280# VSS 0.534f
C1815 a_6884_35280# VSS 0.55513f
C1816 a_5614_35280# VSS 0.52095f
C1817 a_5320_35340# VSS 1.05903f ; **FLOATING
C1818 a_5204_35280# VSS 0.52299f
C1819 a_5347_36069# VSS 25.14f ; **FLOATING
C1820 a_3934_35280# VSS 0.52095f
C1821 a_3785_35340# VSS 10.1349f ; **FLOATING
C1822 a_3640_35340# VSS 0.93657f ; **FLOATING
C1823 a_3524_35280# VSS 0.52329f
C1824 a_3667_36069# VSS 9.29287f ; **FLOATING
C1825 a_3667_15489.t4 VSS 0.32598f ; **FLOATING
C1826 a_3667_15489.t6 VSS 0.17289f ; **FLOATING
C1827 a_3667_15489.n0 VSS 2.23832f ; **FLOATING
C1828 a_3667_15489.t7 VSS 0.17289f ; **FLOATING
C1829 a_3667_15489.n1 VSS 0.92646f ; **FLOATING
C1830 a_3667_15489.t10 VSS 0.33961f ; **FLOATING
C1831 a_3667_15489.t11 VSS 0.17073f ; **FLOATING
C1832 a_3667_15489.n2 VSS 2.15193f ; **FLOATING
C1833 a_3667_15489.t1 VSS 0.13574f ; **FLOATING
C1834 a_3667_15489.n3 VSS 1.38581f ; **FLOATING
C1835 a_3667_15489.n4 VSS 1.10357f ; **FLOATING
C1836 a_3667_15489.t12 VSS 0.39166f ; **FLOATING
C1837 a_3667_15489.t9 VSS 0.17073f ; **FLOATING
C1838 a_3667_15489.n5 VSS 2.96222f ; **FLOATING
C1839 a_3667_15489.t8 VSS 0.17463f ; **FLOATING
C1840 a_3667_15489.n6 VSS 0.93103f ; **FLOATING
C1841 a_3667_15489.n7 VSS 1.08918f ; **FLOATING
C1842 a_3667_15489.t5 VSS 1.78962f ; **FLOATING
C1843 a_3667_15489.t2 VSS 4.44568f ; **FLOATING
C1844 a_3667_15489.t3 VSS 2.04688f ; **FLOATING
C1845 a_3667_15489.t0 VSS 0.931f ; **FLOATING
C1846 a_7027_15489.t1 VSS 3.61531f ; **FLOATING
C1847 a_7027_15489.t6 VSS 0.37723f ; **FLOATING
C1848 a_7027_15489.t5 VSS 0.05865f ; **FLOATING
C1849 a_7027_15489.n0 VSS 1.91605f ; **FLOATING
C1850 a_7027_15489.t2 VSS 0.14255f ; **FLOATING
C1851 a_7027_15489.t3 VSS 0.06729f ; **FLOATING
C1852 a_7027_15489.n1 VSS 11.4781f ; **FLOATING
C1853 a_7027_15489.n2 VSS 12.3612f ; **FLOATING
C1854 a_7027_15489.t4 VSS 1.21712f ; **FLOATING
C1855 a_7027_15489.t0 VSS 0.14912f ; **FLOATING
C1856 a_18905_14900.t6 VSS 0.08625f ; **FLOATING
C1857 a_18905_14900.t7 VSS 0.04594f ; **FLOATING
C1858 a_18905_14900.n0 VSS 0.60738f ; **FLOATING
C1859 a_18905_14900.t2 VSS 0.08056f ; **FLOATING
C1860 a_18905_14900.t3 VSS 0.08056f ; **FLOATING
C1861 a_18905_14900.n1 VSS 0.16377f ; **FLOATING
C1862 a_18905_14900.t4 VSS 0.08056f ; **FLOATING
C1863 a_18905_14900.t5 VSS 0.08056f ; **FLOATING
C1864 a_18905_14900.n2 VSS 0.11412f ; **FLOATING
C1865 a_18905_14900.n3 VSS 0.90528f ; **FLOATING
C1866 a_18905_14900.n4 VSS 10.1276f ; **FLOATING
C1867 a_18905_14900.t1 VSS 11.1912f ; **FLOATING
C1868 a_18905_14900.t0 VSS 0.5302f ; **FLOATING
C1869 a_20585_14900.t2 VSS 0.11904f ; **FLOATING
C1870 a_20585_14900.t3 VSS 0.11708f ; **FLOATING
C1871 a_20585_14900.n0 VSS 14.5882f ; **FLOATING
C1872 a_20585_14900.t1 VSS 0.10817f ; **FLOATING
C1873 a_20585_14900.n1 VSS 15.8582f ; **FLOATING
C1874 a_20585_14900.t0 VSS 1.05973f ; **FLOATING
C1875 a_10645_3280.t4 VSS 0.10393f ; **FLOATING
C1876 a_10645_3280.t5 VSS 0.32746f ; **FLOATING
C1877 a_10645_3280.t2 VSS 0.07686f ; **FLOATING
C1878 a_10645_3280.t3 VSS 0.08564f ; **FLOATING
C1879 a_10645_3280.n0 VSS 0.71215f ; **FLOATING
C1880 a_10645_3280.n1 VSS 3.19042f ; **FLOATING
C1881 a_10645_3280.n2 VSS 5.25882f ; **FLOATING
C1882 a_10645_3280.t1 VSS 4.44146f ; **FLOATING
C1883 a_10645_3280.t0 VSS 0.99245f ; **FLOATING
C1884 a_149000_17206.t0 VSS 0.01116f ; **FLOATING
C1885 a_149000_17206.t4 VSS 0.01551f ; **FLOATING
C1886 a_149000_17206.n0 VSS 0.35554f ; **FLOATING
C1887 a_149000_17206.t6 VSS 17.3878f ; **FLOATING
C1888 a_149000_17206.n1 VSS 3.4301f ; **FLOATING
C1889 a_149000_17206.n2 VSS 1.73103f ; **FLOATING
C1890 a_149000_17206.t3 VSS 0.03327f ; **FLOATING
C1891 a_149000_17206.t7 VSS 0.08628f ; **FLOATING
C1892 a_149000_17206.t2 VSS 0.03288f ; **FLOATING
C1893 FB.t5 VSS 0.0982f ; **FLOATING
C1894 FB.t2 VSS 0.09968f ; **FLOATING
C1895 FB.t4 VSS 0.08686f ; **FLOATING
C1896 FB.t7 VSS 0.30959f ; **FLOATING
C1897 FB.n0 VSS 2.57037f ; **FLOATING
C1898 FB.n1 VSS 1.59634f ; **FLOATING
C1899 FB.n2 VSS 3.38481f ; **FLOATING
C1900 FB.t6 VSS 0.32284f ; **FLOATING
C1901 FB.t1 VSS 0.08004f ; **FLOATING
C1902 FB.n3 VSS 1.60789f ; **FLOATING
C1903 FB.t3 VSS 0.05712f ; **FLOATING
C1904 FB.t0 VSS 0.20768f ; **FLOATING
C1905 FB.n4 VSS 0.49806f ; **FLOATING
C1906 FB.n5 VSS 1.2705f ; **FLOATING
C1907 FB.n6 VSS 12.1867f ; **FLOATING
C1908 FS.t0 VSS 0.20198f ; **FLOATING
C1909 FS.t1 VSS 0.20345f ; **FLOATING
C1910 FS.t2 VSS 0.31951f ; **FLOATING
C1911 FS.n0 VSS 0.12407f ; **FLOATING
C1912 FS.n1 VSS 10.898f ; **FLOATING
C1913 ICP2.t0 VSS 0.06289f ; **FLOATING
C1914 ICP2.t1 VSS 0.06289f ; **FLOATING
C1915 ICP2.n0 VSS 1.34486f ; **FLOATING
C1916 ICP2.t2 VSS 0.10263f ; **FLOATING
C1917 ICP2.t3 VSS 0.05466f ; **FLOATING
C1918 ICP2.n1 VSS 0.73686f ; **FLOATING
C1919 ICP2.n2 VSS 14.8083f ; **FLOATING
C1920 NB.t4 VSS 0.688f ; **FLOATING
C1921 NB.t3 VSS 0.688f ; **FLOATING
C1922 NB.t2 VSS 0.688f ; **FLOATING
C1923 NB.t1 VSS 0.688f ; **FLOATING
C1924 NB.t0 VSS 0.89246f ; **FLOATING
C1925 NB.n0 VSS 0.48771f ; **FLOATING
C1926 NB.n1 VSS 0.34838f ; **FLOATING
C1927 NB.n2 VSS 0.34838f ; **FLOATING
C1928 NB.n3 VSS 0.3237f ; **FLOATING
C1929 NB.t5 VSS 0.688f ; **FLOATING
C1930 NB.t6 VSS 0.688f ; **FLOATING
C1931 NB.t7 VSS 0.688f ; **FLOATING
C1932 NB.t8 VSS 0.688f ; **FLOATING
C1933 NB.t9 VSS 0.89246f ; **FLOATING
C1934 NB.n4 VSS 0.48771f ; **FLOATING
C1935 NB.n5 VSS 0.34838f ; **FLOATING
C1936 NB.n6 VSS 0.34838f ; **FLOATING
C1937 NB.n7 VSS 0.3237f ; **FLOATING
C1938 NB.n8 VSS 8.55924f ; **FLOATING
C1939 PB.t7 VSS 1.00594f ; **FLOATING
C1940 PB.t6 VSS 1.00594f ; **FLOATING
C1941 PB.t5 VSS 1.00594f ; **FLOATING
C1942 PB.t4 VSS 1.00594f ; **FLOATING
C1943 PB.t3 VSS 1.00594f ; **FLOATING
C1944 PB.t2 VSS 1.00594f ; **FLOATING
C1945 PB.t1 VSS 1.00594f ; **FLOATING
C1946 PB.t0 VSS 1.30489f ; **FLOATING
C1947 PB.n0 VSS 0.7131f ; **FLOATING
C1948 PB.n1 VSS 0.50938f ; **FLOATING
C1949 PB.n2 VSS 0.50938f ; **FLOATING
C1950 PB.n3 VSS 0.50938f ; **FLOATING
C1951 PB.n4 VSS 0.50938f ; **FLOATING
C1952 PB.n5 VSS 0.50938f ; **FLOATING
C1953 PB.n6 VSS 0.4733f ; **FLOATING
C1954 PB.t8 VSS 1.00594f ; **FLOATING
C1955 PB.t9 VSS 1.00594f ; **FLOATING
C1956 PB.t10 VSS 1.00594f ; **FLOATING
C1957 PB.t11 VSS 1.00594f ; **FLOATING
C1958 PB.t12 VSS 1.00594f ; **FLOATING
C1959 PB.t13 VSS 1.00594f ; **FLOATING
C1960 PB.t14 VSS 1.00594f ; **FLOATING
C1961 PB.t15 VSS 1.30489f ; **FLOATING
C1962 PB.n7 VSS 0.7131f ; **FLOATING
C1963 PB.n8 VSS 0.50938f ; **FLOATING
C1964 PB.n9 VSS 0.50938f ; **FLOATING
C1965 PB.n10 VSS 0.50938f ; **FLOATING
C1966 PB.n11 VSS 0.50938f ; **FLOATING
C1967 PB.n12 VSS 0.50938f ; **FLOATING
C1968 PB.n13 VSS 0.4733f ; **FLOATING
C1969 PB.n14 VSS 12.0276f ; **FLOATING
.ends
