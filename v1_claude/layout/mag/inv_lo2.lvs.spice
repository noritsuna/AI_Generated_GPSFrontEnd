* NGSPICE file created from inv_lo2.ext - technology: gf180mcuD

.subckt inv_lo2_MN Y A VSS
X0 VSS A Y VSS nfet_03v3 ad=1.335p pd=6.89u as=0.795p ps=3.53u w=3u l=0.28u
X1 Y A VSS VSS nfet_03v3 ad=0.795p pd=3.53u as=1.335p ps=6.89u w=3u l=0.28u
.ends

.subckt inv_lo2_MP Y A VDD
X0 VDD A Y VDD pfet_03v3 ad=0.795p pd=3.53u as=0.795p ps=3.53u w=3u l=0.28u
X1 Y A VDD VDD pfet_03v3 ad=0.795p pd=3.53u as=1.335p ps=6.89u w=3u l=0.28u
X2 VDD A Y VDD pfet_03v3 ad=1.335p pd=6.89u as=0.795p ps=3.53u w=3u l=0.28u
X3 Y A VDD VDD pfet_03v3 ad=0.795p pd=3.53u as=0.795p ps=3.53u w=3u l=0.28u
.ends

.subckt inv_lo2 VSS VDD A Y
XXMN Y A VSS inv_lo2_MN
XXMP Y A VDD inv_lo2_MP
.ends
