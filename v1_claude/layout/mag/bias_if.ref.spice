.subckt bias_if PB NBIF PBIF VDD VSS
XRDA vdiv VDD VSS ppolyf_u_1k r_width=1u r_length=70u
XRDB VSS vdiv VSS ppolyf_u_1k r_width=1u r_length=28.3u
XMOT ot PB VDD VDD pfet_03v3 L=2u W=32u nf=4  m=1
XMI1 o1 vdiv ot VDD pfet_03v3 L=1u W=16u nf=2  m=1
XMI2 og x ot VDD pfet_03v3 L=1u W=16u nf=2  m=1
XML1 o1 o1 VSS VSS nfet_03v3 L=2u W=4u nf=1  m=1
XML2 og o1 VSS VSS nfet_03v3 L=2u W=4u nf=1  m=1
XCC og VSS cap_mim_2f0_m4m5_noshield c_width=20e-6 c_length=20e-6 m=1
XMV dp og x VSS nfet_03v3 L=1u W=20u nf=2  m=1
XRREF0 r1 x VSS ppolyf_u_1k r_width=1u r_length=2u
XRREF1 r2 r1 VSS ppolyf_u_1k r_width=1u r_length=2u
XRREF2 r3 r2 VSS ppolyf_u_1k r_width=1u r_length=2u
XRREF3 r4 r3 VSS ppolyf_u_1k r_width=1u r_length=2u
XRREF4 r5 r4 VSS ppolyf_u_1k r_width=1u r_length=2u
XRREF5 r6 r5 VSS ppolyf_u_1k r_width=1u r_length=2u
XRREF6 r7 r6 VSS ppolyf_u_1k r_width=1u r_length=2u
XRREF7 r8 r7 VSS ppolyf_u_1k r_width=1u r_length=2u
XRREF8 VSS r8 VSS ppolyf_u_1k r_width=1u r_length=2u
XMPD dp dp VDD VDD pfet_03v3 L=2u W=32u nf=4  m=1
XMPM NBIF dp VDD VDD pfet_03v3 L=2u W=32u nf=4  m=1
XMND NBIF NBIF VSS VSS nfet_03v3 L=2u W=16u nf=2  m=1
XCNB NBIF VSS cap_mim_2f0_m4m5_noshield c_width=20e-6 c_length=20e-6 m=1
XMNP PBIF NBIF VSS VSS nfet_03v3 L=2u W=16u nf=2  m=1
XMPP PBIF PBIF VDD VDD pfet_03v3 L=2u W=32u nf=4  m=1
XCPB VDD PBIF cap_mim_2f0_m4m5_noshield c_width=20e-6 c_length=20e-6 m=1
.ends
