* NGSPICE file created from sa_comp_flat.ext - technology: gf180mcuD

.subckt sa_comp_flat VSS VDD INP INN REFP REFN CLK Q QB
X0 a_9100_18120# a_5885_13920# VDD VDD pfet_03v3 ad=1.78p pd=8.89u as=1.78p ps=8.89u w=4u l=0.28u
X1 QB Q VSS VSS nfet_03v3 ad=0.445p pd=2.89u as=0.445p ps=2.89u w=1u l=0.28u
X2 QB Q a_4905_18120# VDD pfet_03v3 ad=1.78p pd=8.89u as=1.78p ps=8.89u w=4u l=0.28u
X3 a_1427_18849# a_1427_14649# VSS VSS nfet_03v3 ad=0.445p pd=2.89u as=0.445p ps=2.89u w=1u l=0.28u
X4 Q QB VSS VSS nfet_03v3 ad=0.445p pd=2.89u as=0.445p ps=2.89u w=1u l=0.28u
X5 a_1427_14649# a_3107_6109# a_1545_1180# VSS nfet_03v3 ad=0.89p pd=4.89u as=0.89p ps=4.89u w=2u l=0.28u
X6 a_1427_18849# a_1427_14649# VDD VDD pfet_03v3 ad=0.89p pd=4.89u as=0.89p ps=4.89u w=2u l=0.28u
X7 a_5740_5520# CLK VDD VDD pfet_03v3 ad=0.445p pd=2.89u as=0.445p ps=2.89u w=1u l=0.28u
X8 a_5740_5520# INN a_1400_1180# VSS nfet_03v3 ad=1.78p pd=8.89u as=1.78p ps=8.89u w=4u l=0.28u
X9 QB a_1427_18849# VSS VSS nfet_03v3 ad=0.445p pd=2.89u as=0.445p ps=2.89u w=1u l=0.28u
X10 a_4905_18120# a_1427_18849# VDD VDD pfet_03v3 ad=1.78p pd=8.89u as=1.78p ps=8.89u w=4u l=0.28u
X11 VSS CLK a_1400_1180# VSS nfet_03v3 ad=1.78p pd=8.89u as=1.06p ps=4.53u w=4u l=0.28u
X12 a_5740_5520# REFP a_1400_1180# VSS nfet_03v3 ad=1.78p pd=8.89u as=1.78p ps=8.89u w=4u l=0.28u
X13 a_1427_14649# a_3107_6109# VDD VDD pfet_03v3 ad=0.89p pd=4.89u as=0.89p ps=4.89u w=2u l=0.28u
X14 a_5885_13920# a_3107_6109# VDD VDD pfet_03v3 ad=0.89p pd=4.89u as=0.89p ps=4.89u w=2u l=0.28u
X15 a_3107_6109# a_1427_14649# a_5740_5520# VSS nfet_03v3 ad=0.89p pd=4.89u as=0.89p ps=4.89u w=2u l=0.28u
X16 a_3107_6109# CLK VDD VDD pfet_03v3 ad=0.445p pd=2.89u as=0.445p ps=2.89u w=1u l=0.28u
X17 a_1400_1180# CLK VSS VSS nfet_03v3 ad=1.06p pd=4.53u as=1.78p ps=8.89u w=4u l=0.28u
X18 a_1545_1180# CLK VDD VDD pfet_03v3 ad=0.445p pd=2.89u as=0.445p ps=2.89u w=1u l=0.28u
X19 a_1545_1180# REFN a_1400_1180# VSS nfet_03v3 ad=1.78p pd=8.89u as=1.78p ps=8.89u w=4u l=0.28u
X20 a_1545_1180# INP a_1400_1180# VSS nfet_03v3 ad=1.78p pd=8.89u as=1.78p ps=8.89u w=4u l=0.28u
X21 a_5885_13920# a_3107_6109# VSS VSS nfet_03v3 ad=0.445p pd=2.89u as=0.445p ps=2.89u w=1u l=0.28u
X22 a_3107_6109# a_1427_14649# VDD VDD pfet_03v3 ad=0.89p pd=4.89u as=0.89p ps=4.89u w=2u l=0.28u
X23 Q a_5885_13920# VSS VSS nfet_03v3 ad=0.445p pd=2.89u as=0.445p ps=2.89u w=1u l=0.28u
X24 a_1427_14649# CLK VDD VDD pfet_03v3 ad=0.445p pd=2.89u as=0.445p ps=2.89u w=1u l=0.28u
X25 Q QB a_9100_18120# VDD pfet_03v3 ad=1.78p pd=8.89u as=1.78p ps=8.89u w=4u l=0.28u
C0 CLK a_3107_6109# 0.12136f
C1 a_9394_18060# Q 0.04353f
C2 REFN INP 0.07635f
C3 REFP a_1400_1180# 0.05974f
C4 a_9100_18120# a_5885_13920# 0.06318f
C5 QB a_5885_13920# 0.38327f
C6 a_3374_1120# a_2964_1120# 0.0129f
C7 a_6734_18060# QB 0.04484f
C8 a_3374_9660# a_1427_14649# 0.02853f
C9 a_5740_5520# a_8144_1120# 0.01552f
C10 a_9100_18120# QB 0.16289f
C11 a_1400_1180# a_1284_1120# 0.04076f
C12 REFP VDD 1.23846f
C13 a_9100_18120# a_10664_18060# 0.01509f
C14 a_1400_1180# a_5216_1120# 0.01072f
C15 a_5885_13920# a_6034_13860# 0.02481f
C16 a_1427_18849# a_1427_14649# 0.11878f
C17 Q a_1427_18849# 0.11516f
C18 a_9100_18120# a_9394_18060# 0.01648f
C19 a_9394_18060# QB 0.01288f
C20 REFP a_3107_6109# 0.75417f
C21 a_5624_5460# a_5740_5520# 0.01998f
C22 CLK a_5740_5520# 0.08625f
C23 REFP REFN 0.0548f
C24 Q a_14434_18402# 0.01296f
C25 a_5054_18060# a_4644_18060# 0.0129f
C26 VDD a_6034_9660# 0.35048f
C27 a_1400_1180# a_1694_1120# 0.01483f
C28 QB a_1427_18849# 0.19076f
C29 a_5054_18060# VDD 0.60019f
C30 a_1427_14649# a_1694_10002# 0.01511f
C31 a_1427_14649# a_1545_1180# 0.10361f
C32 VDD a_1427_14649# 2.99884f
C33 a_5054_18060# a_4905_18120# 0.04654f
C34 a_1400_1180# INN 0.05829f
C35 a_3374_18402# QB 0.01595f
C36 VDD Q 1.58447f
C37 a_3107_6109# a_6034_9660# 0.02223f
C38 a_4905_18120# Q 0.20754f
C39 a_1400_1180# a_3374_1120# 0.01384f
C40 VDD a_2964_13860# 0.36377f
C41 REFP a_5740_5520# 0.56518f
C42 VDD a_6324_18060# 0.58253f
C43 a_1694_1120# a_1545_1180# 0.05124f
C44 a_1400_1180# a_2964_1120# 0.04956f
C45 a_6324_18060# a_4905_18120# 0.04961f
C46 a_3107_6109# a_1427_14649# 0.76576f
C47 a_3374_13860# a_1427_14649# 0.01094f
C48 VDD a_5885_13920# 1.32076f
C49 INN a_1545_1180# 0.01807f
C50 VDD INN 0.29835f
C51 VDD a_6734_18060# 0.58394f
C52 a_3374_1120# a_1545_1180# 0.04066f
C53 VDD a_7714_5802# 0.21693f
C54 REFP CLK 0.14066f
C55 a_2964_1120# a_1545_1180# 0.01552f
C56 VDD a_5624_13860# 0.36665f
C57 a_9100_18120# VDD 0.94704f
C58 a_5885_13920# a_3107_6109# 0.14279f
C59 VDD QB 1.67089f
C60 INN a_3107_6109# 0.19161f
C61 VDD a_10664_18060# 0.63223f
C62 a_4905_18120# QB 0.37231f
C63 a_6034_5460# a_3107_6109# 0.01993f
C64 a_12754_18402# Q 0.01296f
C65 a_8554_1120# a_8144_1120# 0.0129f
C66 a_2964_5460# a_1545_1180# 0.02887f
C67 a_5740_5520# a_8554_1120# 0.04066f
C68 VDD a_9394_18060# 0.58329f
C69 VDD a_6034_13860# 0.3476f
C70 REFN INN 0.09637f
C71 a_5740_5520# a_1427_14649# 0.02886f
C72 VDD a_3374_9660# 0.3476f
C73 a_1400_1180# a_6874_1120# 0.01037f
C74 VDD a_1284_5802# 0.22745f
C75 Q a_8984_18060# 0.02214f
C76 VDD a_5624_9660# 0.36279f
C77 VDD a_1427_18849# 1.21426f
C78 a_5740_5520# INN 0.11209f
C79 a_9100_18120# a_11074_18060# 0.04066f
C80 CLK a_1427_14649# 0.16378f
C81 a_5885_13920# a_7714_14202# 0.0139f
C82 a_4905_18120# a_1427_18849# 0.05138f
C83 a_10664_18060# a_11074_18060# 0.0129f
C84 a_6034_5460# a_5740_5520# 0.01311f
C85 a_5740_5520# a_7714_5802# 0.01149f
C86 a_6464_1120# a_6874_1120# 0.0129f
C87 a_5624_9660# a_3107_6109# 0.0136f
C88 a_1694_14202# a_1427_18849# 0.01732f
C89 a_3374_13860# a_1427_18849# 0.01988f
C90 CLK INN 1.50147f
C91 a_1400_1180# a_1545_1180# 0.66682f
C92 a_9100_18120# a_8984_18060# 0.04076f
C93 QB a_8984_18060# 0.01581f
C94 a_6464_1120# a_1400_1180# 0.05544f
C95 a_4644_18060# VDD 0.63479f
C96 REFP a_1427_14649# 0.41482f
C97 a_9394_18060# a_8984_18060# 0.0129f
C98 QB a_1694_18402# 0.01511f
C99 VDD a_1694_10002# 0.21462f
C100 VDD a_1545_1180# 0.68858f
C101 VDD a_2964_9660# 0.36665f
C102 VDD a_4905_18120# 0.88551f
C103 a_3107_6109# a_1545_1180# 0.02512f
C104 VDD a_3107_6109# 3.11155f
C105 a_1400_1180# REFN 0.06129f
C106 a_4644_1120# a_1400_1180# 0.0178f
C107 a_3374_13860# VDD 0.34967f
C108 a_6874_1120# a_5740_5520# 0.05266f
C109 a_1284_1120# a_1694_1120# 0.0129f
C110 REFN a_1545_1180# 0.06928f
C111 CLK a_1427_18849# 0.03709f
C112 a_3374_5460# a_1427_14649# 0.02871f
C113 a_1400_1180# a_8144_1120# 0.04917f
C114 a_1400_1180# a_5740_5520# 0.58568f
C115 a_1400_1180# INP 0.06179f
C116 VDD a_11074_18060# 0.60275f
C117 VDD a_7714_10002# 0.21693f
C118 VDD a_1284_10002# 0.22745f
C119 VDD a_7304_5802# 0.22431f
C120 VDD a_5740_5520# 0.72081f
C121 a_6324_18060# Q 0.01306f
C122 VDD a_7304_10002# 0.22431f
C123 INP a_1545_1180# 0.27323f
C124 a_3107_6109# a_7714_10002# 0.01149f
C125 CLK a_1400_1180# 0.13796f
C126 VDD INP 0.37747f
C127 INN a_1427_14649# 0.10995f
C128 Q a_5885_13920# 0.10869f
C129 VDD a_8984_18060# 0.58317f
C130 Q a_6734_18060# 0.01283f
C131 a_5740_5520# a_3107_6109# 0.20813f
C132 a_1694_5802# a_1545_1180# 0.01511f
C133 a_6324_18060# a_6734_18060# 0.0129f
C134 VDD a_1694_5802# 0.21379f
C135 CLK a_1545_1180# 0.02299f
C136 CLK VDD 4.42078f
C137 a_9100_18120# Q 0.38275f
C138 Q QB 0.69483f
C139 a_5624_5460# a_3107_6109# 0.01371f
C140 a_6324_18060# QB 0.01772f
C141 REFP VSS 4.71075f
C142 INN VSS 3.35747f
C143 INP VSS 1.80917f
C144 REFN VSS 5.43635f
C145 CLK VSS 10.2834f
C146 Q VSS 9.29863f
C147 QB VSS 7.34435f
C148 VDD VSS 0.1046p
C149 a_8554_1120# VSS 0.65977f
C150 a_8144_1120# VSS 0.65679f
C151 a_6874_1120# VSS 0.65977f
C152 a_6464_1120# VSS 0.65832f
C153 a_5216_1120# VSS 0.74138f
C154 a_4644_1120# VSS 0.74083f
C155 a_3374_1120# VSS 0.65977f
C156 a_2964_1120# VSS 0.65679f
C157 a_1694_1120# VSS 0.65883f
C158 a_1400_1180# VSS 4.01893f ; **FLOATING
C159 a_1284_1120# VSS 0.65774f
C160 a_7714_5802# VSS 0.02717f
C161 a_7304_5802# VSS 0.02717f
C162 a_6034_5460# VSS 0.38483f
C163 a_5740_5520# VSS 2.70745f ; **FLOATING
C164 a_5624_5460# VSS 0.38539f
C165 a_3374_5460# VSS 0.38545f
C166 a_2964_5460# VSS 0.38483f
C167 a_1694_5802# VSS 0.02717f
C168 a_1545_1180# VSS 2.94014f ; **FLOATING
C169 a_1284_5802# VSS 0.02717f
C170 a_7714_10002# VSS 0.02717f
C171 a_7304_10002# VSS 0.02717f
C172 a_6034_9660# VSS 0.04368f
C173 a_5624_9660# VSS 0.04368f
C174 a_3374_9660# VSS 0.04368f
C175 a_2964_9660# VSS 0.04368f
C176 a_1694_10002# VSS 0.02717f
C177 a_1284_10002# VSS 0.02717f
C178 a_7714_14202# VSS 0.24358f
C179 a_7304_14202# VSS 0.25096f ; **FLOATING
C180 a_6034_13860# VSS 0.04368f
C181 a_5624_13860# VSS 0.04368f
C182 a_3107_6109# VSS 6.34344f ; **FLOATING
C183 a_3374_13860# VSS 0.04368f
C184 a_2964_13860# VSS 0.04368f
C185 a_1694_14202# VSS 0.24044f
C186 a_1284_14202# VSS 0.2541f ; **FLOATING
C187 a_1427_14649# VSS 7.20592f ; **FLOATING
C188 a_14434_18402# VSS 0.24358f
C189 a_14024_18402# VSS 0.25096f ; **FLOATING
C190 a_12754_18402# VSS 0.24358f
C191 a_12344_18402# VSS 0.25096f ; **FLOATING
C192 a_11074_18060# VSS 0.07326f
C193 a_10664_18060# VSS 0.07326f
C194 a_5885_13920# VSS 5.1927f ; **FLOATING
C195 a_9394_18060# VSS 0.07326f
C196 a_9100_18120# VSS 0.55804f ; **FLOATING
C197 a_8984_18060# VSS 0.07326f
C198 a_6734_18060# VSS 0.07326f
C199 a_6324_18060# VSS 0.07326f
C200 a_5054_18060# VSS 0.07326f
C201 a_4905_18120# VSS 0.40798f ; **FLOATING
C202 a_4644_18060# VSS 0.07326f
C203 a_3374_18402# VSS 0.24275f
C204 a_2964_18402# VSS 0.2518f ; **FLOATING
C205 a_1694_18402# VSS 0.24044f
C206 a_1284_18402# VSS 0.2541f ; **FLOATING
C207 a_1427_18849# VSS 4.0535f ; **FLOATING
.ends
