.subckt inv_dig A Y VDD VSS
XMN Y A VSS VSS nfet_03v3 L=0.28u W=1u nf=1  m=1
XMP Y A VDD VDD pfet_03v3 L=0.28u W=2u nf=1  m=1
.ends
.subckt inv_dac A Y VDD VSS
XMN Y A VSS VSS nfet_03v3 L=0.28u W=8u nf=2  m=1
XMP Y A VDD VDD pfet_03v3 L=0.28u W=24u nf=4  m=1
.ends
.subckt afc_dac D0 D1 D2 D3 D4 D5 D6 D7 OUT VDD VSS
XRT VSS n0 VSS ppolyf_u_1k r_width=2u r_length=40u
XA0 D0 db0 VDD VSS inv_dig
XB0 db0 dr0 VDD VSS inv_dac
XR2_0 n0 dr0 VSS ppolyf_u_1k r_width=2u r_length=40u
XR1_0 n1 n0 VSS ppolyf_u_1k r_width=2u r_length=20.1u
XA1 D1 db1 VDD VSS inv_dig
XB1 db1 dr1 VDD VSS inv_dac
XR2_1 n1 dr1 VSS ppolyf_u_1k r_width=2u r_length=40u
XR1_1 n2 n1 VSS ppolyf_u_1k r_width=2u r_length=20.1u
XA2 D2 db2 VDD VSS inv_dig
XB2 db2 dr2 VDD VSS inv_dac
XR2_2 n2 dr2 VSS ppolyf_u_1k r_width=2u r_length=40u
XR1_2 n3 n2 VSS ppolyf_u_1k r_width=2u r_length=20.1u
XA3 D3 db3 VDD VSS inv_dig
XB3 db3 dr3 VDD VSS inv_dac
XR2_3 n3 dr3 VSS ppolyf_u_1k r_width=2u r_length=40u
XR1_3 n4 n3 VSS ppolyf_u_1k r_width=2u r_length=20.1u
XA4 D4 db4 VDD VSS inv_dig
XB4 db4 dr4 VDD VSS inv_dac
XR2_4 n4 dr4 VSS ppolyf_u_1k r_width=2u r_length=40u
XR1_4 n5 n4 VSS ppolyf_u_1k r_width=2u r_length=20.1u
XA5 D5 db5 VDD VSS inv_dig
XB5 db5 dr5 VDD VSS inv_dac
XR2_5 n5 dr5 VSS ppolyf_u_1k r_width=2u r_length=40u
XR1_5 n6 n5 VSS ppolyf_u_1k r_width=2u r_length=20.1u
XA6 D6 db6 VDD VSS inv_dig
XB6 db6 dr6 VDD VSS inv_dac
XR2_6 n6 dr6 VSS ppolyf_u_1k r_width=2u r_length=40u
XR1_6 OUT n6 VSS ppolyf_u_1k r_width=2u r_length=20.1u
XA7 D7 db7 VDD VSS inv_dig
XB7 db7 dr7 VDD VSS inv_dac
XR2_7 OUT dr7 VSS ppolyf_u_1k r_width=2u r_length=40u
.ends
