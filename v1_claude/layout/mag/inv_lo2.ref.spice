.subckt inv_lo2 A Y VDD VSS
XMN Y A VSS VSS nfet_03v3 L=0.28u W=6u nf=2  m=1
XMP Y A VDD VDD pfet_03v3 L=0.28u W=12u nf=4  m=1
.ends
