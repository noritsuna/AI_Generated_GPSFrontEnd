* NGSPICE file created from div96.ext - technology: gf180mcuD

.subckt inv_lo1_MN Y A VSS
X0 Y A VSS VSS nfet_03v3 ad=0.89p pd=4.89u as=0.89p ps=4.89u w=2u l=0.28u
.ends

.subckt inv_lo1_MP Y A VDD
X0 Y A VDD VDD pfet_03v3 ad=1.78p pd=8.89u as=1.78p ps=8.89u w=4u l=0.28u
.ends

.subckt inv_lo1 VDD A Y VSS
XXMN Y A VSS inv_lo1_MN
XXMP Y A VDD inv_lo1_MP
.ends

.subckt inv_lo2_MN Y A VSS
X0 VSS A Y VSS nfet_03v3 ad=1.335p pd=6.89u as=0.795p ps=3.53u w=3u l=0.28u
X1 Y A VSS VSS nfet_03v3 ad=0.795p pd=3.53u as=1.335p ps=6.89u w=3u l=0.28u
.ends

.subckt inv_lo2_MP Y A VDD
X0 VDD A Y VDD pfet_03v3 ad=0.795p pd=3.53u as=0.795p ps=3.53u w=3u l=0.28u
X1 Y A VDD VDD pfet_03v3 ad=0.795p pd=3.53u as=1.335p ps=6.89u w=3u l=0.28u
X2 VDD A Y VDD pfet_03v3 ad=1.335p pd=6.89u as=0.795p ps=3.53u w=3u l=0.28u
X3 Y A VDD VDD pfet_03v3 ad=0.795p pd=3.53u as=0.795p ps=3.53u w=3u l=0.28u
.ends

.subckt inv_lo2 VDD A Y VSS
XXMN Y A VSS inv_lo2_MN
XXMP Y A VDD inv_lo2_MP
.ends

.subckt tspc_dff_MP1 a1 D VDD
X0 a1 D VDD VDD pfet_03v3 ad=0.89p pd=4.89u as=0.89p ps=4.89u w=2u l=0.28u
.ends

.subckt tspc_dff_MP2 a1 x CK VDD
X0 x CK a1 VDD pfet_03v3 ad=0.89p pd=4.89u as=0.89p ps=4.89u w=2u l=0.28u
.ends

.subckt tspc_dff_MP3 y CK VDD
X0 y CK VDD VDD pfet_03v3 ad=0.89p pd=4.89u as=0.89p ps=4.89u w=2u l=0.28u
.ends

.subckt tspc_dff_MN1 x D VSS
X0 x D VSS VSS nfet_03v3 ad=0.445p pd=2.89u as=0.445p ps=2.89u w=1u l=0.28u
.ends

.subckt tspc_dff_MP4 QB y VDD
X0 QB y VDD VDD pfet_03v3 ad=1.335p pd=6.89u as=1.335p ps=6.89u w=3u l=0.28u
.ends

.subckt tspc_dff_MN2 b2 y x VSS
X0 y x b2 VSS nfet_03v3 ad=0.6675p pd=3.89u as=0.6675p ps=3.89u w=1.5u l=0.28u
.ends

.subckt tspc_dff_MP5 Q QB VDD
X0 Q QB VDD VDD pfet_03v3 ad=0.89p pd=4.89u as=0.89p ps=4.89u w=2u l=0.28u
.ends

.subckt tspc_dff_MN3 b2 CK VSS
X0 b2 CK VSS VSS nfet_03v3 ad=0.6675p pd=3.89u as=0.6675p ps=3.89u w=1.5u l=0.28u
.ends

.subckt tspc_dff_MN4 c3 QB CK VSS
X0 QB CK c3 VSS nfet_03v3 ad=0.6675p pd=3.89u as=0.6675p ps=3.89u w=1.5u l=0.28u
.ends

.subckt tspc_dff_MN5 c3 y VSS
X0 c3 y VSS VSS nfet_03v3 ad=0.6675p pd=3.89u as=0.6675p ps=3.89u w=1.5u l=0.28u
.ends

.subckt tspc_dff_MN6 Q QB VSS
X0 Q QB VSS VSS nfet_03v3 ad=0.445p pd=2.89u as=0.445p ps=2.89u w=1u l=0.28u
.ends

.subckt tspc_dff VDD D CK Q QB VSS
XXMP1 XMP2/a1 D VDD tspc_dff_MP1
XXMP2 XMP2/a1 XMP2/x CK VDD tspc_dff_MP2
XXMP3 XMP4/y CK VDD tspc_dff_MP3
XXMN1 XMP2/x D VSS tspc_dff_MN1
XXMP4 QB XMP4/y VDD tspc_dff_MP4
XXMN2 XMN3/b2 XMP4/y XMP2/x VSS tspc_dff_MN2
XXMP5 Q QB VDD tspc_dff_MP5
XXMN3 XMN3/b2 CK VSS tspc_dff_MN3
XXMN4 XMN5/c3 QB CK VSS tspc_dff_MN4
XXMN5 XMN5/c3 XMP4/y VSS tspc_dff_MN5
XXMN6 Q QB VSS tspc_dff_MN6
.ends

.subckt div2 VDD CK Q QB VSS
XXF VDD QB CK Q QB VSS tspc_dff
.ends

.subckt nor2_MP1 n1 A VDD
X0 n1 A VDD VDD pfet_03v3 ad=1.78p pd=8.89u as=1.78p ps=8.89u w=4u l=0.28u
.ends

.subckt nor2_MP2 n1 Y B VDD
X0 Y B n1 VDD pfet_03v3 ad=1.78p pd=8.89u as=1.78p ps=8.89u w=4u l=0.28u
.ends

.subckt nor2_MN1 Y A VSS
X0 Y A VSS VSS nfet_03v3 ad=0.445p pd=2.89u as=0.445p ps=2.89u w=1u l=0.28u
.ends

.subckt nor2_MN2 Y B VSS
X0 Y B VSS VSS nfet_03v3 ad=0.445p pd=2.89u as=0.445p ps=2.89u w=1u l=0.28u
.ends

.subckt nor2 VDD A B Y VSS
XXMP1 XMP2/n1 A VDD nor2_MP1
XXMP2 XMP2/n1 Y B VDD nor2_MP2
XXMN1 Y A VSS nor2_MN1
XXMN2 Y B VSS nor2_MN2
.ends

.subckt div3 VDD CK Q VSS
XXF1 VDD XN/Y CK Q XF1/QB VSS tspc_dff
XXF2 VDD Q CK XN/B XF2/QB VSS tspc_dff
XXN VDD Q XN/B XN/Y VSS nor2
.ends

.subckt div96 VSS VDD CK FS FB
XXFB1 VDD FB XFB2/A VSS inv_lo1
XXFB2 VDD XFB2/A FS VSS inv_lo2
XXD1 VDD CK XD1/Q XD1/QB VSS div2
XXD2 VDD XD1/Q XD2/Q XD2/QB VSS div2
XXD3 VDD XD2/Q XD3/Q XD3/QB VSS div2
XXD4 VDD XD3/Q XD4/Q XD4/QB VSS div2
XXD5 VDD XD4/Q XD5/Q VSS div3
XXD6 VDD XD5/Q FB XD6/QB VSS div2
.ends
