* NGSPICE file created from vmon_buf_flat.ext - technology: gf180mcuD

.subckt vmon_buf_flat VSS VDD IN NB OUT
X0 VDD a_1749_7509# OUT VDD pfet_03v3 ad=1.78p pd=8.89u as=1.06p ps=4.53u w=4u l=2u
X1 a_1749_7509# a_1749_7509# VDD VDD pfet_03v3 ad=1.06p pd=4.53u as=1.78p ps=8.89u w=4u l=2u
X2 a_2169_1180# IN a_1749_7509# VSS nfet_03v3 ad=2.12p pd=8.53u as=2.12p ps=8.53u w=8u l=1u
X3 OUT OUT a_2169_1180# VSS nfet_03v3 ad=2.12p pd=8.53u as=2.12p ps=8.53u w=8u l=1u
X4 VSS NB a_2169_1180# VSS nfet_03v3 ad=3.56p pd=16.89u as=2.12p ps=8.53u w=8u l=2u
X5 OUT a_1749_7509# VDD VDD pfet_03v3 ad=1.06p pd=4.53u as=1.06p ps=4.53u w=4u l=2u
X6 a_2169_1180# NB VSS VSS nfet_03v3 ad=2.12p pd=8.53u as=3.56p ps=16.89u w=8u l=2u
X7 a_1749_7509# IN a_2169_1180# VSS nfet_03v3 ad=2.12p pd=8.53u as=3.56p ps=16.89u w=8u l=1u
X8 VDD a_1749_7509# a_1749_7509# VDD pfet_03v3 ad=1.06p pd=4.53u as=1.06p ps=4.53u w=4u l=2u
X9 a_2169_1180# OUT OUT VSS nfet_03v3 ad=3.56p pd=16.89u as=2.12p ps=8.53u w=8u l=1u
C0 VDD NB 0.28297f
C1 a_1749_7509# a_3836_6580# 0.029f
C2 a_1749_7509# a_4500_1359# 0.04077f
C3 IN a_4500_1359# 0.03657f
C4 OUT VDD 0.87773f
C5 a_2169_1180# a_4500_1359# 0.18873f
C6 OUT a_6116_1359# 0.05612f
C7 OUT a_3836_6580# 0.05698f
C8 a_3836_6580# VDD 1.92027f
C9 a_1749_7509# IN 0.48802f
C10 a_1749_7509# a_2169_1180# 0.55199f
C11 a_2169_1180# IN 0.50981f
C12 a_1220_6580# VDD 1.93295f
C13 NB IN 0.05782f
C14 NB a_2169_1180# 0.56579f
C15 IN a_2824_1120# 0.02888f
C16 a_1749_7509# OUT 0.51421f
C17 a_1749_7509# VDD 5.43729f
C18 a_2169_1180# a_2824_1120# 0.05868f
C19 OUT IN 0.01875f
C20 OUT a_2169_1180# 1.05685f
C21 a_1220_1120# IN 0.03073f
C22 a_6116_1359# a_2169_1180# 0.17232f
C23 IN VSS 3.54391f
C24 NB VSS 5.33613f
C25 OUT VSS 5.70781f
C26 VDD VSS 31.2453f
C27 a_6116_1359# VSS 2.11443f
C28 a_4500_1359# VSS 2.11443f
C29 a_2824_1120# VSS 3.59083f
C30 a_2169_1180# VSS 2.16497f ; **FLOATING
C31 a_1220_1120# VSS 3.60909f
C32 a_3836_6580# VSS 0.14314f
C33 a_1220_6580# VSS 0.14314f
C34 a_1749_7509# VSS 3.3293f ; **FLOATING
.ends
