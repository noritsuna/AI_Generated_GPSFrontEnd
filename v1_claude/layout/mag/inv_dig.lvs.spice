* NGSPICE file created from inv_dig.ext - technology: gf180mcuD

.subckt inv_dig_MN Y A VSS
X0 Y A VSS VSS nfet_03v3 ad=0.445p pd=2.89u as=0.445p ps=2.89u w=1u l=0.28u
.ends

.subckt inv_dig_MP Y A VDD
X0 Y A VDD VDD pfet_03v3 ad=0.89p pd=4.89u as=0.89p ps=4.89u w=2u l=0.28u
.ends

.subckt inv_dig VSS VDD A Y
XXMN Y A VSS inv_dig_MN
XXMP Y A VDD inv_dig_MP
.ends
